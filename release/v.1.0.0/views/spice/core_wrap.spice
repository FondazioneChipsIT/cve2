* NGSPICE file created from core_wrap.ext - technology: ihp-sg13g2

* Black-box entry subcircuit for sg13g2_decap_8 abstract view
.subckt sg13g2_decap_8 VDD VSS
.ends

* Black-box entry subcircuit for sg13g2_fill_1 abstract view
.subckt sg13g2_fill_1 VDD VSS
.ends

* Black-box entry subcircuit for sg13g2_decap_4 abstract view
.subckt sg13g2_decap_4 VDD VSS
.ends

* Black-box entry subcircuit for sg13g2_nand2_1 abstract view
.subckt sg13g2_nand2_1 Y A B VDD VSS
.ends

* Black-box entry subcircuit for sg13g2_fill_2 abstract view
.subckt sg13g2_fill_2 VDD VSS
.ends

* Black-box entry subcircuit for sg13g2_o21ai_1 abstract view
.subckt sg13g2_o21ai_1 Y A1 A2 B1 VDD VSS
.ends

* Black-box entry subcircuit for sg13g2_nand3_1 abstract view
.subckt sg13g2_nand3_1 Y A B C VDD VSS
.ends

* Black-box entry subcircuit for sg13g2_dfrbpq_1 abstract view
.subckt sg13g2_dfrbpq_1 Q CLK D RESET_B VDD VSS
.ends

* Black-box entry subcircuit for sg13g2_mux2_1 abstract view
.subckt sg13g2_mux2_1 X A0 A1 S VDD VSS
.ends

* Black-box entry subcircuit for sg13g2_nor2_1 abstract view
.subckt sg13g2_nor2_1 Y A B VDD VSS
.ends

* Black-box entry subcircuit for sg13g2_nand2b_1 abstract view
.subckt sg13g2_nand2b_1 Y A_N B VDD VSS
.ends

* Black-box entry subcircuit for sg13g2_nor4_1 abstract view
.subckt sg13g2_nor4_1 Y A B C D VDD VSS
.ends

* Black-box entry subcircuit for sg13g2_nand2b_2 abstract view
.subckt sg13g2_nand2b_2 Y A_N B VDD VSS
.ends

* Black-box entry subcircuit for sg13g2_a21oi_1 abstract view
.subckt sg13g2_a21oi_1 Y A1 A2 B1 VDD VSS
.ends

* Black-box entry subcircuit for sg13g2_inv_1 abstract view
.subckt sg13g2_inv_1 Y A VDD VSS
.ends

* Black-box entry subcircuit for sg13g2_mux4_1 abstract view
.subckt sg13g2_mux4_1 X A0 A1 A2 A3 S0 S1 VDD VSS
.ends

* Black-box entry subcircuit for sg13g2_a21o_1 abstract view
.subckt sg13g2_a21o_1 X A1 A2 B1 VDD VSS
.ends

* Black-box entry subcircuit for sg13g2_and2_1 abstract view
.subckt sg13g2_and2_1 X A B VDD VSS
.ends

* Black-box entry subcircuit for sg13g2_nor4_2 abstract view
.subckt sg13g2_nor4_2 Y A B C D VDD VSS
.ends

* Black-box entry subcircuit for sg13g2_buf_1 abstract view
.subckt sg13g2_buf_1 X A VDD VSS
.ends

* Black-box entry subcircuit for sg13g2_dlygate4sd3_1 abstract view
.subckt sg13g2_dlygate4sd3_1 X A VDD VSS
.ends

* Black-box entry subcircuit for sg13g2_xnor2_1 abstract view
.subckt sg13g2_xnor2_1 Y A B VDD VSS
.ends

* Black-box entry subcircuit for sg13g2_a22oi_1 abstract view
.subckt sg13g2_a22oi_1 Y A1 A2 B1 B2 VDD VSS
.ends

* Black-box entry subcircuit for sg13g2_a21oi_2 abstract view
.subckt sg13g2_a21oi_2 Y A1 A2 B1 VDD VSS
.ends

* Black-box entry subcircuit for sg13g2_a221oi_1 abstract view
.subckt sg13g2_a221oi_1 Y A1 A2 B1 B2 C1 VDD VSS
.ends

* Black-box entry subcircuit for sg13g2_xor2_1 abstract view
.subckt sg13g2_xor2_1 X A B VDD VSS
.ends

* Black-box entry subcircuit for sg13g2_nor2b_1 abstract view
.subckt sg13g2_nor2b_1 Y A B_N VDD VSS
.ends

* Black-box entry subcircuit for sg13g2_buf_2 abstract view
.subckt sg13g2_buf_2 X A VDD VSS
.ends

* Black-box entry subcircuit for sg13g2_nor3_1 abstract view
.subckt sg13g2_nor3_1 Y A B C VDD VSS
.ends

* Black-box entry subcircuit for sg13g2_nand3b_1 abstract view
.subckt sg13g2_nand3b_1 Y A_N B C VDD VSS
.ends

* Black-box entry subcircuit for sg13g2_nand4_1 abstract view
.subckt sg13g2_nand4_1 Y A B C D VDD VSS
.ends

* Black-box entry subcircuit for sg13g2_buf_8 abstract view
.subckt sg13g2_buf_8 X A VDD VSS
.ends

* Black-box entry subcircuit for sg13g2_buf_4 abstract view
.subckt sg13g2_buf_4 X A VDD VSS
.ends

* Black-box entry subcircuit for sg13g2_nor2b_2 abstract view
.subckt sg13g2_nor2b_2 Y A B_N VDD VSS
.ends

* Black-box entry subcircuit for sg13g2_and2_2 abstract view
.subckt sg13g2_and2_2 X A B VDD VSS
.ends

* Black-box entry subcircuit for sg13g2_and3_1 abstract view
.subckt sg13g2_and3_1 X A B C VDD VSS
.ends

* Black-box entry subcircuit for sg13g2_inv_2 abstract view
.subckt sg13g2_inv_2 Y A VDD VSS
.ends

* Black-box entry subcircuit for sg13g2_antennanp abstract view
.subckt sg13g2_antennanp A VDD VSS
.ends

* Black-box entry subcircuit for sg13g2_or3_1 abstract view
.subckt sg13g2_or3_1 X A B C VDD VSS
.ends

* Black-box entry subcircuit for sg13g2_and4_1 abstract view
.subckt sg13g2_and4_1 X A B C D VDD VSS
.ends

* Black-box entry subcircuit for sg13g2_or2_1 abstract view
.subckt sg13g2_or2_1 X A B VDD VSS
.ends

* Black-box entry subcircuit for sg13g2_dfrbpq_2 abstract view
.subckt sg13g2_dfrbpq_2 Q CLK D RESET_B VDD VSS
.ends

* Black-box entry subcircuit for sg13g2_buf_16 abstract view
.subckt sg13g2_buf_16 X A VDD VSS
.ends

* Black-box entry subcircuit for sg13g2_a21o_2 abstract view
.subckt sg13g2_a21o_2 X A1 A2 B1 VDD VSS
.ends

* Black-box entry subcircuit for sg13g2_or4_1 abstract view
.subckt sg13g2_or4_1 X A B C D VDD VSS
.ends

* Black-box entry subcircuit for sg13g2_and3_2 abstract view
.subckt sg13g2_and3_2 X A B C VDD VSS
.ends

* Black-box entry subcircuit for sg13g2_nor2_2 abstract view
.subckt sg13g2_nor2_2 Y A B VDD VSS
.ends

* Black-box entry subcircuit for sg13g2_inv_4 abstract view
.subckt sg13g2_inv_4 Y A VDD VSS
.ends

* Black-box entry subcircuit for sg13g2_nand2_2 abstract view
.subckt sg13g2_nand2_2 Y A B VDD VSS
.ends

* Black-box entry subcircuit for sg13g2_or4_2 abstract view
.subckt sg13g2_or4_2 X A B C D VDD VSS
.ends

* Black-box entry subcircuit for sg13g2_nor3_2 abstract view
.subckt sg13g2_nor3_2 Y A B C VDD VSS
.ends

* Black-box entry subcircuit for sg13g2_inv_8 abstract view
.subckt sg13g2_inv_8 Y A VDD VSS
.ends

* Black-box entry subcircuit for sg13g2_or2_2 abstract view
.subckt sg13g2_or2_2 X A B VDD VSS
.ends

* Black-box entry subcircuit for sg13g2_or3_2 abstract view
.subckt sg13g2_or3_2 X A B C VDD VSS
.ends

* Black-box entry subcircuit for sg13g2_inv_16 abstract view
.subckt sg13g2_inv_16 Y A VDD VSS
.ends

* Black-box entry subcircuit for sg13g2_and4_2 abstract view
.subckt sg13g2_and4_2 X A B C D VDD VSS
.ends

* Black-box entry subcircuit for sg13g2_mux2_2 abstract view
.subckt sg13g2_mux2_2 X A0 A1 S VDD VSS
.ends

* Black-box entry subcircuit for sg13g2_tielo abstract view
.subckt sg13g2_tielo L_LO VDD VSS
.ends

.subckt core_wrap VGND VPWR boot_addr_i[0] boot_addr_i[10] boot_addr_i[11] boot_addr_i[12]
+ boot_addr_i[13] boot_addr_i[14] boot_addr_i[15] boot_addr_i[16] boot_addr_i[17]
+ boot_addr_i[18] boot_addr_i[19] boot_addr_i[1] boot_addr_i[20] boot_addr_i[21] boot_addr_i[22]
+ boot_addr_i[23] boot_addr_i[24] boot_addr_i[25] boot_addr_i[26] boot_addr_i[27]
+ boot_addr_i[28] boot_addr_i[29] boot_addr_i[2] boot_addr_i[30] boot_addr_i[31] boot_addr_i[3]
+ boot_addr_i[4] boot_addr_i[5] boot_addr_i[6] boot_addr_i[7] boot_addr_i[8] boot_addr_i[9]
+ clk_i core_busy_o data_addr_o[0] data_addr_o[10] data_addr_o[11] data_addr_o[12]
+ data_addr_o[13] data_addr_o[14] data_addr_o[15] data_addr_o[16] data_addr_o[17]
+ data_addr_o[18] data_addr_o[19] data_addr_o[1] data_addr_o[20] data_addr_o[21] data_addr_o[22]
+ data_addr_o[23] data_addr_o[24] data_addr_o[25] data_addr_o[26] data_addr_o[27]
+ data_addr_o[28] data_addr_o[29] data_addr_o[2] data_addr_o[30] data_addr_o[31] data_addr_o[3]
+ data_addr_o[4] data_addr_o[5] data_addr_o[6] data_addr_o[7] data_addr_o[8] data_addr_o[9]
+ data_be_o[0] data_be_o[1] data_be_o[2] data_be_o[3] data_err_i data_gnt_i data_rdata_i[0]
+ data_rdata_i[10] data_rdata_i[11] data_rdata_i[12] data_rdata_i[13] data_rdata_i[14]
+ data_rdata_i[15] data_rdata_i[16] data_rdata_i[17] data_rdata_i[18] data_rdata_i[19]
+ data_rdata_i[1] data_rdata_i[20] data_rdata_i[21] data_rdata_i[22] data_rdata_i[23]
+ data_rdata_i[24] data_rdata_i[25] data_rdata_i[26] data_rdata_i[27] data_rdata_i[28]
+ data_rdata_i[29] data_rdata_i[2] data_rdata_i[30] data_rdata_i[31] data_rdata_i[3]
+ data_rdata_i[4] data_rdata_i[5] data_rdata_i[6] data_rdata_i[7] data_rdata_i[8]
+ data_rdata_i[9] data_req_o data_rvalid_i data_wdata_o[0] data_wdata_o[10] data_wdata_o[11]
+ data_wdata_o[12] data_wdata_o[13] data_wdata_o[14] data_wdata_o[15] data_wdata_o[16]
+ data_wdata_o[17] data_wdata_o[18] data_wdata_o[19] data_wdata_o[1] data_wdata_o[20]
+ data_wdata_o[21] data_wdata_o[22] data_wdata_o[23] data_wdata_o[24] data_wdata_o[25]
+ data_wdata_o[26] data_wdata_o[27] data_wdata_o[28] data_wdata_o[29] data_wdata_o[2]
+ data_wdata_o[30] data_wdata_o[31] data_wdata_o[3] data_wdata_o[4] data_wdata_o[5]
+ data_wdata_o[6] data_wdata_o[7] data_wdata_o[8] data_wdata_o[9] data_we_o debug_req_i
+ fetch_enable_i instr_addr_o[0] instr_addr_o[10] instr_addr_o[11] instr_addr_o[12]
+ instr_addr_o[13] instr_addr_o[14] instr_addr_o[15] instr_addr_o[16] instr_addr_o[17]
+ instr_addr_o[18] instr_addr_o[19] instr_addr_o[1] instr_addr_o[20] instr_addr_o[21]
+ instr_addr_o[22] instr_addr_o[23] instr_addr_o[24] instr_addr_o[25] instr_addr_o[26]
+ instr_addr_o[27] instr_addr_o[28] instr_addr_o[29] instr_addr_o[2] instr_addr_o[30]
+ instr_addr_o[31] instr_addr_o[3] instr_addr_o[4] instr_addr_o[5] instr_addr_o[6]
+ instr_addr_o[7] instr_addr_o[8] instr_addr_o[9] instr_err_i instr_gnt_i instr_rdata_i[0]
+ instr_rdata_i[10] instr_rdata_i[11] instr_rdata_i[12] instr_rdata_i[13] instr_rdata_i[14]
+ instr_rdata_i[15] instr_rdata_i[16] instr_rdata_i[17] instr_rdata_i[18] instr_rdata_i[19]
+ instr_rdata_i[1] instr_rdata_i[20] instr_rdata_i[21] instr_rdata_i[22] instr_rdata_i[23]
+ instr_rdata_i[24] instr_rdata_i[25] instr_rdata_i[26] instr_rdata_i[27] instr_rdata_i[28]
+ instr_rdata_i[29] instr_rdata_i[2] instr_rdata_i[30] instr_rdata_i[31] instr_rdata_i[3]
+ instr_rdata_i[4] instr_rdata_i[5] instr_rdata_i[6] instr_rdata_i[7] instr_rdata_i[8]
+ instr_rdata_i[9] instr_req_o instr_rvalid_i irqs_i[0] irqs_i[10] irqs_i[11] irqs_i[12]
+ irqs_i[13] irqs_i[14] irqs_i[15] irqs_i[1] irqs_i[2] irqs_i[3] irqs_i[4] irqs_i[5]
+ irqs_i[6] irqs_i[7] irqs_i[8] irqs_i[9] rst_ni software_irq_i test_enable_i timer_irq_i
XFILLER_25_1948 VPWR VGND sg13g2_decap_8
XFILLER_100_138 VPWR VGND sg13g2_decap_8
XFILLER_80_1265 VPWR VGND sg13g2_fill_1
XFILLER_28_918 VPWR VGND sg13g2_decap_4
X_18869_ _18870_/C _23077_/Q _18869_/B VPWR VGND sg13g2_nand2_1
XFILLER_28_929 VPWR VGND sg13g2_fill_1
XFILLER_55_715 VPWR VGND sg13g2_decap_4
XFILLER_82_512 VPWR VGND sg13g2_fill_1
XFILLER_3_1722 VPWR VGND sg13g2_decap_8
XFILLER_94_383 VPWR VGND sg13g2_fill_2
XFILLER_54_214 VPWR VGND sg13g2_decap_4
XFILLER_55_748 VPWR VGND sg13g2_decap_4
X_21880_ _23935_/D _21946_/A1 _21885_/B _21879_/Y VPWR VGND sg13g2_o21ai_1
XFILLER_39_299 VPWR VGND sg13g2_fill_1
XFILLER_54_225 VPWR VGND sg13g2_decap_8
XFILLER_36_940 VPWR VGND sg13g2_decap_8
XFILLER_54_236 VPWR VGND sg13g2_fill_1
X_20831_ _22385_/B _22971_/Q _21087_/A _20831_/C VPWR VGND sg13g2_nand3_1
XFILLER_70_707 VPWR VGND sg13g2_fill_1
XFILLER_93_1604 VPWR VGND sg13g2_decap_8
XFILLER_36_962 VPWR VGND sg13g2_decap_8
XFILLER_39_1101 VPWR VGND sg13g2_fill_1
XFILLER_97_1784 VPWR VGND sg13g2_fill_1
XFILLER_3_1799 VPWR VGND sg13g2_decap_8
XFILLER_97_1795 VPWR VGND sg13g2_decap_4
XFILLER_78_1172 VPWR VGND sg13g2_fill_2
XFILLER_22_100 VPWR VGND sg13g2_decap_8
X_20762_ _20762_/Y _20762_/A _20768_/B VPWR VGND sg13g2_nand2_1
XFILLER_35_483 VPWR VGND sg13g2_decap_8
X_23550_ _23550_/Q clkload44/A _23550_/D fanout2749/X VPWR VGND sg13g2_dfrbpq_1
XFILLER_35_1009 VPWR VGND sg13g2_fill_1
X_22501_ _22501_/Q _22869_/CLK _22501_/D fanout2795/X VPWR VGND sg13g2_dfrbpq_1
XFILLER_71_1913 VPWR VGND sg13g2_fill_1
X_23481_ _23481_/Q clkload53/A _23481_/D fanout2787/X VPWR VGND sg13g2_dfrbpq_1
XFILLER_91_1350 VPWR VGND sg13g2_decap_4
X_20693_ _23399_/D _22429_/A1 _20704_/B _20692_/Y VPWR VGND sg13g2_o21ai_1
XFILLER_22_155 VPWR VGND sg13g2_decap_8
XFILLER_51_998 VPWR VGND sg13g2_decap_4
XFILLER_108_1560 VPWR VGND sg13g2_decap_4
X_22432_ _24200_/D _24200_/Q _20172_/Y _22449_/S VPWR VGND sg13g2_mux2_1
XFILLER_109_706 VPWR VGND sg13g2_decap_8
XFILLER_104_1435 VPWR VGND sg13g2_decap_4
X_22363_ _22382_/S _22430_/A _22363_/B VPWR VGND sg13g2_nor2_1
XFILLER_104_1468 VPWR VGND sg13g2_decap_8
XFILLER_30_1632 VPWR VGND sg13g2_decap_4
X_21314_ _23678_/D _21314_/A1 _21313_/B _21313_/Y VPWR VGND sg13g2_o21ai_1
X_24102_ _24102_/Q _24170_/CLK _24102_/D fanout2707/X VPWR VGND sg13g2_dfrbpq_1
XFILLER_30_1654 VPWR VGND sg13g2_decap_4
X_22294_ _24134_/D _22294_/A1 _22300_/B _22293_/Y VPWR VGND sg13g2_o21ai_1
XFILLER_50_1091 VPWR VGND sg13g2_decap_8
XFILLER_105_912 VPWR VGND sg13g2_decap_4
X_24033_ _24033_/Q clkload45/A _24033_/D fanout2716/X VPWR VGND sg13g2_dfrbpq_1
X_21245_ _21245_/Y _23645_/Q _21247_/B VPWR VGND sg13g2_nand2_1
XFILLER_7_7 VPWR VGND sg13g2_fill_1
XFILLER_78_807 VPWR VGND sg13g2_fill_1
X_21176_ _23612_/D _21309_/A1 _21175_/B _21175_/Y VPWR VGND sg13g2_o21ai_1
XFILLER_77_48 VPWR VGND sg13g2_decap_8
XFILLER_77_317 VPWR VGND sg13g2_decap_4
X_20127_ _20127_/Y _20127_/A _20144_/B VPWR VGND sg13g2_nand2_1
XFILLER_8_1633 VPWR VGND sg13g2_decap_4
XFILLER_89_188 VPWR VGND sg13g2_decap_8
XFILLER_115_1531 VPWR VGND sg13g2_decap_8
XFILLER_24_1414 VPWR VGND sg13g2_fill_1
XFILLER_115_1553 VPWR VGND sg13g2_decap_8
X_20058_ _20058_/Y _20058_/A _20058_/B VPWR VGND sg13g2_nor2_1
XFILLER_46_704 VPWR VGND sg13g2_fill_1
XFILLER_93_14 VPWR VGND sg13g2_fill_1
XFILLER_86_895 VPWR VGND sg13g2_decap_8
XFILLER_111_1439 VPWR VGND sg13g2_decap_8
X_11900_ _11901_/B _23418_/Q _23450_/Q _11904_/B VPWR VGND sg13g2_mux2_1
XFILLER_41_1761 VPWR VGND sg13g2_decap_4
XFILLER_45_203 VPWR VGND sg13g2_fill_2
XFILLER_41_1772 VPWR VGND sg13g2_fill_1
XFILLER_98_1559 VPWR VGND sg13g2_fill_1
X_12880_ _12880_/Y _12570_/S _23877_/Q _12879_/Y VPWR VGND sg13g2_o21ai_1
XFILLER_22_1171 VPWR VGND sg13g2_decap_8
XFILLER_27_940 VPWR VGND sg13g2_decap_8
XFILLER_73_556 VPWR VGND sg13g2_decap_8
X_23817_ _23817_/Q _24113_/CLK _23817_/D fanout2684/X VPWR VGND sg13g2_dfrbpq_1
XFILLER_45_258 VPWR VGND sg13g2_fill_2
XFILLER_61_707 VPWR VGND sg13g2_fill_1
XFILLER_73_567 VPWR VGND sg13g2_fill_1
X_11831_ _11831_/Y _23385_/Q _11836_/B VPWR VGND sg13g2_nand2b_1
XFILLER_2_1265 VPWR VGND sg13g2_decap_4
XFILLER_26_41 VPWR VGND sg13g2_decap_8
XFILLER_57_1212 VPWR VGND sg13g2_decap_4
XFILLER_73_589 VPWR VGND sg13g2_fill_1
XFILLER_76_1857 VPWR VGND sg13g2_decap_4
X_14550_ _14550_/Y _14550_/A _18857_/S VPWR VGND sg13g2_nor2_1
XFILLER_54_792 VPWR VGND sg13g2_fill_1
X_11762_ _11762_/Y _23384_/Q _11762_/B VPWR VGND sg13g2_nand2b_1
X_23748_ _23748_/Q clkload40/A _23748_/D fanout2729/X VPWR VGND sg13g2_dfrbpq_1
XFILLER_60_239 VPWR VGND sg13g2_fill_1
XFILLER_13_111 VPWR VGND sg13g2_decap_4
XFILLER_13_122 VPWR VGND sg13g2_fill_2
XFILLER_14_656 VPWR VGND sg13g2_decap_8
XFILLER_13_133 VPWR VGND sg13g2_decap_8
XFILLER_57_1278 VPWR VGND sg13g2_fill_1
X_13501_ _13501_/Y _13086_/B _13086_/A _13085_/Y VPWR VGND sg13g2_o21ai_1
XFILLER_35_1510 VPWR VGND sg13g2_fill_2
XFILLER_35_1521 VPWR VGND sg13g2_decap_8
X_14481_ _14497_/A _14481_/A _14481_/B _14481_/C _14481_/D VPWR VGND sg13g2_nor4_1
X_23679_ _23679_/Q clkload39/A _23679_/D fanout2737/X VPWR VGND sg13g2_dfrbpq_1
X_11693_ _11693_/Y _11688_/A _12203_/S VPWR VGND sg13g2_nand2b_2
XFILLER_13_166 VPWR VGND sg13g2_decap_4
X_16220_ _16220_/Y _22515_/Q _22514_/Q _16244_/B VPWR VGND sg13g2_nand3_1
XFILLER_13_177 VPWR VGND sg13g2_fill_1
XFILLER_70_1423 VPWR VGND sg13g2_decap_4
XFILLER_74_1592 VPWR VGND sg13g2_decap_8
XFILLER_35_1554 VPWR VGND sg13g2_decap_8
XFILLER_42_51 VPWR VGND sg13g2_decap_8
X_16151_ _16151_/Y _22502_/Q _16187_/B _16150_/Y VPWR VGND sg13g2_a21oi_1
XFILLER_70_1478 VPWR VGND sg13g2_decap_8
X_13363_ _13363_/Y _13296_/A _13363_/A2 _13370_/B VPWR VGND sg13g2_o21ai_1
XFILLER_6_833 VPWR VGND sg13g2_decap_8
X_15102_ _15102_/Y _22542_/Q VPWR VGND sg13g2_inv_1
XFILLER_100_1811 VPWR VGND sg13g2_decap_8
X_12314_ _12314_/X _23422_/Q _23486_/Q _23582_/Q _23646_/Q _12216_/S _11708_/B VPWR
+ VGND sg13g2_mux4_1
XFILLER_100_1822 VPWR VGND sg13g2_fill_2
XFILLER_5_332 VPWR VGND sg13g2_decap_4
X_16082_ _16082_/Y _22491_/Q _16207_/B VPWR VGND sg13g2_nand2_1
XFILLER_13_1885 VPWR VGND sg13g2_decap_8
X_13294_ _19423_/A _13373_/C _13373_/D VPWR VGND sg13g2_nor2_1
XFILLER_87_1953 VPWR VGND sg13g2_fill_2
X_19910_ _19910_/X _20098_/A3 _20095_/A0 _20222_/B VPWR VGND sg13g2_mux2_1
X_15033_ _15033_/X _23146_/Q _15033_/A1 _15120_/S VPWR VGND sg13g2_mux2_1
X_12245_ _12250_/B _12245_/A _12245_/B VPWR VGND sg13g2_nor2_1
XFILLER_9_1408 VPWR VGND sg13g2_decap_8
X_19841_ _19841_/Y _20335_/A _20263_/B _19840_/Y VPWR VGND sg13g2_o21ai_1
X_12176_ _12176_/Y _12169_/Y _12176_/B VPWR VGND sg13g2_nand2b_1
XFILLER_29_1358 VPWR VGND sg13g2_decap_8
XFILLER_96_615 VPWR VGND sg13g2_decap_8
XFILLER_68_328 VPWR VGND sg13g2_fill_2
X_19772_ _19772_/Y _19777_/B _19803_/B _19771_/Y VPWR VGND sg13g2_a21oi_1
XFILLER_49_531 VPWR VGND sg13g2_decap_8
XFILLER_27_1082 VPWR VGND sg13g2_decap_8
X_18723_ _18733_/D _18723_/A _18723_/B VPWR VGND sg13g2_nor2_1
X_15935_ _15935_/X _17202_/A _22478_/Q _15935_/S VPWR VGND sg13g2_mux2_1
XFILLER_7_1176 VPWR VGND sg13g2_fill_2
XFILLER_3_1007 VPWR VGND sg13g2_fill_1
XFILLER_3_1018 VPWR VGND sg13g2_decap_4
XFILLER_114_1074 VPWR VGND sg13g2_decap_4
XFILLER_92_821 VPWR VGND sg13g2_decap_4
XFILLER_37_726 VPWR VGND sg13g2_decap_4
X_18654_ _23008_/D _18648_/Y _18651_/Y _18653_/Y VPWR VGND sg13g2_a21oi_1
X_15866_ _17187_/A _20245_/B _14434_/Y _15865_/Y VPWR VGND sg13g2_a21o_1
XFILLER_97_1036 VPWR VGND sg13g2_decap_8
XFILLER_64_545 VPWR VGND sg13g2_decap_8
XFILLER_97_1069 VPWR VGND sg13g2_decap_4
XFILLER_18_962 VPWR VGND sg13g2_decap_8
XFILLER_0_1928 VPWR VGND sg13g2_decap_8
XFILLER_36_258 VPWR VGND sg13g2_fill_1
X_17605_ _17606_/B _22553_/Q _17624_/D VPWR VGND sg13g2_nand2_1
X_14817_ _14817_/X _22485_/Q _14912_/B VPWR VGND sg13g2_and2_1
X_18585_ _22996_/D _18585_/A _18585_/B _18585_/C _18585_/D VPWR VGND sg13g2_nor4_2
XFILLER_92_898 VPWR VGND sg13g2_decap_8
X_15797_ _15798_/D _15667_/B _15791_/Y _15796_/Y VPWR VGND sg13g2_a21oi_1
XFILLER_94_1935 VPWR VGND sg13g2_decap_8
XFILLER_91_386 VPWR VGND sg13g2_decap_8
XFILLER_51_217 VPWR VGND sg13g2_fill_2
XFILLER_91_397 VPWR VGND sg13g2_fill_1
X_17536_ _17536_/X _22964_/Q _22948_/Q _17622_/A VPWR VGND sg13g2_mux2_1
X_14748_ _14748_/Y _14222_/X _14747_/Y _14226_/B VPWR VGND sg13g2_o21ai_1
X_17467_ _17467_/Y _17467_/A _17467_/B VPWR VGND sg13g2_nand2_1
XFILLER_92_1681 VPWR VGND sg13g2_decap_8
XFILLER_18_1763 VPWR VGND sg13g2_decap_8
XFILLER_20_637 VPWR VGND sg13g2_fill_2
X_16418_ _22576_/D _18741_/A _16417_/B _16417_/Y VPWR VGND sg13g2_o21ai_1
XFILLER_32_497 VPWR VGND sg13g2_decap_8
X_19206_ _23163_/D _24252_/A _23163_/Q _19231_/S VPWR VGND sg13g2_mux2_1
XFILLER_34_1031 VPWR VGND sg13g2_fill_1
X_17398_ _22820_/D _17396_/Y _17395_/S _17397_/Y VPWR VGND sg13g2_a21oi_1
XFILLER_14_1627 VPWR VGND sg13g2_fill_1
Xplace3903 _18290_/A _18363_/B VPWR VGND sg13g2_buf_1
XFILLER_53_1676 VPWR VGND sg13g2_decap_8
Xplace3914 _18501_/S _18498_/A VPWR VGND sg13g2_buf_1
XFILLER_105_1755 VPWR VGND sg13g2_decap_8
X_19137_ _23113_/D _23113_/Q _18907_/B _19141_/S VPWR VGND sg13g2_mux2_1
Xplace3925 _13678_/A1 _11384_/Y VPWR VGND sg13g2_buf_1
X_16349_ _16350_/B _16852_/B _16349_/B VPWR VGND sg13g2_nor2_1
Xplace3936 _19197_/A _11929_/B VPWR VGND sg13g2_buf_1
Xplace3947 _19782_/A1 _19996_/B2 VPWR VGND sg13g2_buf_1
Xplace3958 _17710_/A1 _17586_/A VPWR VGND sg13g2_buf_1
XFILLER_69_1116 VPWR VGND sg13g2_decap_4
Xplace3969 _19019_/A _19041_/A VPWR VGND sg13g2_buf_1
XFILLER_66_0 VPWR VGND sg13g2_fill_1
X_19068_ _19068_/X _19126_/A1 _23103_/Q _19085_/S VPWR VGND sg13g2_mux2_1
XFILLER_69_1127 VPWR VGND sg13g2_decap_8
XFILLER_69_1138 VPWR VGND sg13g2_fill_2
XFILLER_12_1384 VPWR VGND sg13g2_decap_8
XFILLER_99_420 VPWR VGND sg13g2_decap_4
XFILLER_86_1463 VPWR VGND sg13g2_decap_8
Xhold4638 _17469_/A _22852_/Q VPWR VGND sg13g2_dlygate4sd3_1
Xhold4649 _17341_/A _22798_/Q VPWR VGND sg13g2_dlygate4sd3_1
X_21030_ _23551_/D _22280_/A1 _21029_/B _21029_/Y VPWR VGND sg13g2_o21ai_1
XFILLER_114_753 VPWR VGND sg13g2_decap_8
XFILLER_9_1920 VPWR VGND sg13g2_decap_8
XFILLER_113_252 VPWR VGND sg13g2_decap_8
XFILLER_102_926 VPWR VGND sg13g2_decap_8
XFILLER_82_1349 VPWR VGND sg13g2_decap_4
XFILLER_113_263 VPWR VGND sg13g2_fill_2
XFILLER_64_1750 VPWR VGND sg13g2_decap_4
XFILLER_101_414 VPWR VGND sg13g2_fill_1
XFILLER_113_285 VPWR VGND sg13g2_fill_1
XFILLER_60_1603 VPWR VGND sg13g2_fill_1
XFILLER_86_136 VPWR VGND sg13g2_decap_8
XFILLER_64_1783 VPWR VGND sg13g2_decap_4
XFILLER_86_147 VPWR VGND sg13g2_fill_1
XFILLER_60_1636 VPWR VGND sg13g2_fill_2
X_22981_ _22981_/Q clkload36/A _22981_/D fanout2935/X VPWR VGND sg13g2_dfrbpq_1
XFILLER_99_1835 VPWR VGND sg13g2_decap_8
XFILLER_83_821 VPWR VGND sg13g2_fill_1
X_21932_ _23961_/D _21932_/A1 _21942_/B _21931_/Y VPWR VGND sg13g2_o21ai_1
XFILLER_95_692 VPWR VGND sg13g2_fill_2
XFILLER_103_35 VPWR VGND sg13g2_decap_8
XFILLER_3_1574 VPWR VGND sg13g2_decap_8
X_21863_ _21863_/Y _21863_/A _21899_/S VPWR VGND sg13g2_nand2_1
XFILLER_83_898 VPWR VGND sg13g2_fill_1
XFILLER_63_28 VPWR VGND sg13g2_decap_8
XFILLER_70_515 VPWR VGND sg13g2_fill_2
XFILLER_93_1423 VPWR VGND sg13g2_decap_8
X_23602_ _23602_/Q clkload29/A _23602_/D fanout2669/X VPWR VGND sg13g2_dfrbpq_1
XFILLER_70_537 VPWR VGND sg13g2_decap_4
X_20814_ _20814_/Y _23456_/Q _20818_/B VPWR VGND sg13g2_nand2_1
X_21794_ _21794_/Y _21794_/A _21804_/B VPWR VGND sg13g2_nand2_1
XFILLER_35_291 VPWR VGND sg13g2_decap_8
XFILLER_58_1587 VPWR VGND sg13g2_fill_1
X_23533_ _23533_/Q clkload30/A _23533_/D fanout2659/X VPWR VGND sg13g2_dfrbpq_1
XFILLER_93_1478 VPWR VGND sg13g2_fill_1
XFILLER_19_1549 VPWR VGND sg13g2_fill_2
X_20745_ _20745_/Y _23423_/Q _20751_/B VPWR VGND sg13g2_nand2_1
XFILLER_51_773 VPWR VGND sg13g2_fill_2
XFILLER_10_103 VPWR VGND sg13g2_decap_8
XFILLER_23_497 VPWR VGND sg13g2_fill_1
X_23464_ _23464_/Q clkload50/A _23464_/D fanout2654/X VPWR VGND sg13g2_dfrbpq_1
X_20676_ _20676_/Y _23391_/Q _20682_/B VPWR VGND sg13g2_nand2_1
XFILLER_109_503 VPWR VGND sg13g2_decap_8
XFILLER_104_1221 VPWR VGND sg13g2_fill_2
XFILLER_10_147 VPWR VGND sg13g2_fill_1
XFILLER_12_21 VPWR VGND sg13g2_decap_8
XFILLER_10_158 VPWR VGND sg13g2_fill_1
X_22415_ _22415_/Y _22415_/A _22417_/B VPWR VGND sg13g2_nand2_1
X_23395_ _23395_/Q clkload34/A _23395_/D fanout2700/X VPWR VGND sg13g2_dfrbpq_1
XFILLER_104_1287 VPWR VGND sg13g2_decap_8
X_22346_ _22346_/Y _22346_/A _22350_/B VPWR VGND sg13g2_nand2_1
Xoutput4480 data_addr_o[22] _24267_/X VPWR VGND sg13g2_buf_1
Xoutput4491 data_addr_o[3] _24248_/X VPWR VGND sg13g2_buf_1
X_22277_ _24126_/D _19947_/Y _22276_/B _22276_/Y VPWR VGND sg13g2_o21ai_1
XFILLER_69_1672 VPWR VGND sg13g2_decap_8
XFILLER_2_324 VPWR VGND sg13g2_fill_1
X_12030_ _12030_/Y _13640_/S _12030_/B VPWR VGND sg13g2_nand2_1
X_21228_ _21228_/Y _21228_/A _21234_/B VPWR VGND sg13g2_nand2_1
X_24016_ _24016_/Q _24210_/CLK _24016_/D fanout2635/X VPWR VGND sg13g2_dfrbpq_1
XFILLER_65_1536 VPWR VGND sg13g2_fill_2
XFILLER_2_379 VPWR VGND sg13g2_fill_2
XFILLER_104_285 VPWR VGND sg13g2_decap_8
XFILLER_82_1872 VPWR VGND sg13g2_fill_2
XFILLER_78_659 VPWR VGND sg13g2_fill_1
XFILLER_59_840 VPWR VGND sg13g2_fill_1
X_13981_ _13981_/X _23444_/Q _23476_/Q _23508_/Q _23540_/Q _13173_/S _13981_/S1 VPWR
+ VGND sg13g2_mux4_1
XFILLER_63_1293 VPWR VGND sg13g2_fill_1
XFILLER_115_1372 VPWR VGND sg13g2_decap_8
XFILLER_93_629 VPWR VGND sg13g2_decap_4
XFILLER_86_670 VPWR VGND sg13g2_decap_8
XFILLER_86_681 VPWR VGND sg13g2_fill_2
XFILLER_18_203 VPWR VGND sg13g2_decap_8
X_15720_ _15720_/Y _22566_/Q _15889_/S VPWR VGND sg13g2_nand2_1
XFILLER_18_214 VPWR VGND sg13g2_fill_2
XFILLER_37_40 VPWR VGND sg13g2_fill_2
XFILLER_74_832 VPWR VGND sg13g2_decap_8
XFILLER_46_534 VPWR VGND sg13g2_decap_4
XFILLER_73_320 VPWR VGND sg13g2_fill_2
XFILLER_19_759 VPWR VGND sg13g2_decap_8
XFILLER_24_1299 VPWR VGND sg13g2_fill_2
XFILLER_46_545 VPWR VGND sg13g2_decap_4
X_15651_ _17130_/A _16113_/A _15651_/B VPWR VGND sg13g2_nand2b_1
X_12863_ _14053_/A _13528_/A _12863_/B VPWR VGND sg13g2_xnor2_1
XFILLER_27_770 VPWR VGND sg13g2_decap_4
XFILLER_61_526 VPWR VGND sg13g2_fill_2
X_14602_ _14602_/Y _24219_/Q _14609_/B _14609_/C _14602_/D VPWR VGND sg13g2_nor4_1
XFILLER_73_386 VPWR VGND sg13g2_decap_8
X_11814_ _11814_/Y _23897_/Q _13798_/A2 _11813_/X _12123_/A VPWR VGND sg13g2_a22oi_1
XFILLER_15_932 VPWR VGND sg13g2_decap_8
XFILLER_2_1084 VPWR VGND sg13g2_fill_1
X_18370_ _18370_/Y _18494_/A _18370_/B _18461_/A VPWR VGND sg13g2_nand3_1
XFILLER_27_792 VPWR VGND sg13g2_fill_2
XFILLER_76_1643 VPWR VGND sg13g2_fill_2
X_15582_ _15584_/C _22889_/Q _15182_/X _17439_/A _22851_/Q VPWR VGND sg13g2_a22oi_1
X_12794_ _12794_/X _23460_/Q _23524_/Q _23620_/Q _23684_/Q _13260_/A1 _12498_/S VPWR
+ VGND sg13g2_mux4_1
XFILLER_14_431 VPWR VGND sg13g2_decap_8
XFILLER_42_740 VPWR VGND sg13g2_decap_4
X_17321_ _17321_/Y _17321_/A _17321_/B VPWR VGND sg13g2_nand2_1
XFILLER_57_1064 VPWR VGND sg13g2_fill_2
X_14533_ _14533_/Y _14578_/B _14578_/A _14532_/Y VPWR VGND sg13g2_a21oi_2
X_11745_ _11745_/Y _11749_/S _23480_/Q _11744_/Y VPWR VGND sg13g2_o21ai_1
XFILLER_30_913 VPWR VGND sg13g2_decap_4
XFILLER_57_1097 VPWR VGND sg13g2_fill_2
X_17252_ _17252_/Y _22757_/Q _17252_/B VPWR VGND sg13g2_nand2_1
X_14464_ _16774_/B _14460_/Y _14463_/Y _14242_/B VPWR VGND sg13g2_a21oi_1
XFILLER_50_1805 VPWR VGND sg13g2_fill_1
X_11676_ _11676_/Y _12340_/A _11671_/Y _11675_/Y _16048_/S _19671_/A VPWR VGND sg13g2_a221oi_1
X_16203_ _16203_/Y _16203_/A _16203_/B VPWR VGND sg13g2_nor2_1
XFILLER_50_1827 VPWR VGND sg13g2_fill_2
X_13415_ _13428_/B _13580_/A1 _13412_/X _13414_/X VPWR VGND sg13g2_o21ai_1
XFILLER_50_1838 VPWR VGND sg13g2_decap_4
XFILLER_70_1264 VPWR VGND sg13g2_decap_8
X_17183_ _22739_/D _17197_/B _17181_/Y _17182_/Y VPWR VGND sg13g2_a21oi_1
X_14395_ _14395_/Y _17390_/B _14394_/Y _17390_/A VPWR VGND sg13g2_a21oi_1
X_16134_ _16136_/A _15735_/A _14434_/Y _15735_/Y VPWR VGND sg13g2_a21oi_1
XFILLER_13_1682 VPWR VGND sg13g2_fill_1
X_16065_ _16065_/Y _16065_/A _16073_/B VPWR VGND sg13g2_nand2_1
XFILLER_108_580 VPWR VGND sg13g2_decap_8
X_13277_ _13278_/D _13273_/Y _13274_/X _13275_/X _13276_/Y VPWR VGND sg13g2_a22oi_1
XFILLER_29_1111 VPWR VGND sg13g2_decap_8
X_15016_ _15016_/Y _15016_/A _15016_/B VPWR VGND sg13g2_nand2_1
XFILLER_97_902 VPWR VGND sg13g2_decap_8
XFILLER_83_1636 VPWR VGND sg13g2_fill_1
X_12228_ _12229_/B _23229_/Q _23261_/Q _12246_/S VPWR VGND sg13g2_mux2_1
XFILLER_9_1205 VPWR VGND sg13g2_fill_1
XFILLER_48_1756 VPWR VGND sg13g2_fill_2
XFILLER_48_1767 VPWR VGND sg13g2_decap_8
XFILLER_9_1216 VPWR VGND sg13g2_decap_8
XFILLER_111_723 VPWR VGND sg13g2_decap_8
X_19824_ _19824_/Y _19824_/A _19824_/B VPWR VGND sg13g2_nor2_1
XFILLER_9_1249 VPWR VGND sg13g2_decap_8
XFILLER_2_880 VPWR VGND sg13g2_fill_1
Xfanout2850 fanout2850/X fanout2854/X VPWR VGND sg13g2_buf_1
X_12159_ _12159_/X _12156_/X _12157_/X _12406_/A VPWR VGND sg13g2_mux2_1
XFILLER_25_1019 VPWR VGND sg13g2_decap_8
Xfanout2861 fanout2861/X fanout2902/X VPWR VGND sg13g2_buf_1
XFILLER_61_1923 VPWR VGND sg13g2_decap_8
XFILLER_64_1079 VPWR VGND sg13g2_decap_8
Xfanout2872 fanout2872/X fanout2873/X VPWR VGND sg13g2_buf_1
Xfanout2883 fanout2883/X fanout2891/X VPWR VGND sg13g2_buf_1
XFILLER_96_456 VPWR VGND sg13g2_decap_8
XFILLER_42_1322 VPWR VGND sg13g2_fill_2
Xfanout2894 fanout2894/X fanout2897/X VPWR VGND sg13g2_buf_1
X_19755_ _20005_/B _19349_/X _19418_/Y _19760_/A VPWR VGND sg13g2_mux2_1
X_16967_ _16967_/X _22703_/Q _16967_/B VPWR VGND sg13g2_xor2_1
XFILLER_83_128 VPWR VGND sg13g2_decap_8
X_18706_ _23019_/D _15022_/A _18703_/Y _18705_/Y VPWR VGND sg13g2_a21oi_1
X_15918_ _15921_/B _22867_/Q _15989_/A2 _15873_/B _22614_/Q VPWR VGND sg13g2_a22oi_1
XFILLER_37_534 VPWR VGND sg13g2_fill_1
XFILLER_65_843 VPWR VGND sg13g2_decap_4
X_16898_ _16899_/B _17030_/A _16902_/B VPWR VGND sg13g2_nor2b_1
X_19686_ _19686_/Y _20278_/A2 _19514_/Y _19682_/Y _20154_/S1 VPWR VGND sg13g2_a22oi_1
XFILLER_42_1399 VPWR VGND sg13g2_decap_8
XFILLER_65_865 VPWR VGND sg13g2_decap_8
XFILLER_4_1872 VPWR VGND sg13g2_decap_8
X_15849_ _18723_/A _23022_/Q VPWR VGND sg13g2_inv_1
X_18637_ _18638_/B _23005_/Q _18637_/B VPWR VGND sg13g2_and2_1
XFILLER_0_1725 VPWR VGND sg13g2_decap_4
XFILLER_65_898 VPWR VGND sg13g2_fill_1
XFILLER_59_1841 VPWR VGND sg13g2_fill_1
XFILLER_59_1874 VPWR VGND sg13g2_fill_1
XFILLER_80_879 VPWR VGND sg13g2_decap_8
XFILLER_55_1727 VPWR VGND sg13g2_fill_1
XFILLER_21_902 VPWR VGND sg13g2_decap_4
X_17519_ _17519_/Y _22874_/Q _17528_/B VPWR VGND sg13g2_nand2_1
XFILLER_71_1006 VPWR VGND sg13g2_decap_8
XFILLER_94_1798 VPWR VGND sg13g2_fill_2
X_18499_ _18499_/Y _18297_/A _18451_/C _18498_/X VPWR VGND sg13g2_o21ai_1
XFILLER_21_924 VPWR VGND sg13g2_decap_8
XFILLER_107_1839 VPWR VGND sg13g2_decap_8
X_20530_ _23321_/D _21303_/A1 _20539_/B _20529_/Y VPWR VGND sg13g2_o21ai_1
Xrebuffer5413 _13155_/B _13101_/Y VPWR VGND sg13g2_buf_1
Xrebuffer5424 rebuffer5424/X _11882_/B VPWR VGND sg13g2_buf_1
XFILLER_21_979 VPWR VGND sg13g2_fill_1
Xplace3700 _20009_/B _12762_/B VPWR VGND sg13g2_buf_1
XFILLER_20_467 VPWR VGND sg13g2_decap_8
Xplace3711 _13368_/A _20164_/A VPWR VGND sg13g2_buf_2
X_20461_ _23292_/D _22405_/A1 _20464_/B _20460_/Y VPWR VGND sg13g2_o21ai_1
Xrebuffer5435 _11352_/A _22983_/Q VPWR VGND sg13g2_buf_2
Xplace3722 _15262_/A _14304_/C VPWR VGND sg13g2_buf_1
Xrebuffer5457 _13518_/A1 place3556/A VPWR VGND sg13g2_buf_1
Xplace3733 _20085_/B _20233_/A2 VPWR VGND sg13g2_buf_1
Xplace3744 _19412_/B _19576_/B VPWR VGND sg13g2_buf_1
Xrebuffer5468 _12998_/A2 _11346_/Y VPWR VGND sg13g2_buf_1
Xplace3755 _15255_/B _14336_/C VPWR VGND sg13g2_buf_1
X_22200_ _24089_/D _22266_/A1 _22210_/B _22199_/Y VPWR VGND sg13g2_o21ai_1
XFILLER_14_1468 VPWR VGND sg13g2_decap_8
Xrebuffer5479 _13075_/B _13073_/Y VPWR VGND sg13g2_buf_2
X_23180_ _23180_/Q clkload13/A _23180_/D fanout2847/X VPWR VGND sg13g2_dfrbpq_1
Xplace3766 _13736_/A _13861_/A VPWR VGND sg13g2_buf_2
Xhold5103 _22203_/A _24091_/Q VPWR VGND sg13g2_dlygate4sd3_1
XFILLER_88_1547 VPWR VGND sg13g2_fill_2
Xhold5114 _21306_/A _23675_/Q VPWR VGND sg13g2_dlygate4sd3_1
Xplace3777 _13723_/A _14104_/A VPWR VGND sg13g2_buf_1
XFILLER_106_517 VPWR VGND sg13g2_decap_8
Xplace3788 _19589_/A _19582_/A VPWR VGND sg13g2_buf_1
Xhold5125 _22244_/A _24112_/Q VPWR VGND sg13g2_dlygate4sd3_1
XFILLER_49_1509 VPWR VGND sg13g2_decap_8
XFILLER_88_1569 VPWR VGND sg13g2_decap_8
Xplace3799 _20287_/B _20292_/B VPWR VGND sg13g2_buf_1
Xhold5136 _20671_/A _23389_/Q VPWR VGND sg13g2_dlygate4sd3_1
Xhold5147 _22281_/A _24128_/Q VPWR VGND sg13g2_dlygate4sd3_1
XFILLER_12_1192 VPWR VGND sg13g2_fill_2
Xhold5158 _21035_/A _23553_/Q VPWR VGND sg13g2_dlygate4sd3_1
Xhold5169 _21071_/A _23566_/Q VPWR VGND sg13g2_dlygate4sd3_1
X_22062_ _22062_/Y _24024_/Q _22065_/B VPWR VGND sg13g2_nand2_1
XFILLER_88_902 VPWR VGND sg13g2_decap_8
XFILLER_114_550 VPWR VGND sg13g2_decap_8
XFILLER_82_1113 VPWR VGND sg13g2_fill_1
XFILLER_0_817 VPWR VGND sg13g2_fill_2
X_21013_ _21013_/Y _23546_/Q _21013_/B VPWR VGND sg13g2_nand2_1
XFILLER_87_412 VPWR VGND sg13g2_fill_2
XFILLER_102_756 VPWR VGND sg13g2_decap_8
XFILLER_25_1531 VPWR VGND sg13g2_fill_1
XFILLER_60_1433 VPWR VGND sg13g2_fill_1
XFILLER_9_1794 VPWR VGND sg13g2_decap_8
XFILLER_28_501 VPWR VGND sg13g2_decap_8
XFILLER_68_670 VPWR VGND sg13g2_decap_8
XFILLER_60_1455 VPWR VGND sg13g2_decap_4
XFILLER_114_56 VPWR VGND sg13g2_decap_8
XFILLER_56_832 VPWR VGND sg13g2_decap_8
XFILLER_99_1654 VPWR VGND sg13g2_fill_1
X_22964_ _22964_/Q _23187_/CLK _22964_/D fanout2923/X VPWR VGND sg13g2_dfrbpq_1
XFILLER_83_651 VPWR VGND sg13g2_decap_4
XFILLER_55_342 VPWR VGND sg13g2_fill_2
XFILLER_60_1499 VPWR VGND sg13g2_fill_1
X_21915_ _23955_/D _22249_/A0 _23955_/Q _21915_/S VPWR VGND sg13g2_mux2_1
X_22895_ _22895_/Q clkload10/A _22895_/D fanout2816/X VPWR VGND sg13g2_dfrbpq_1
XFILLER_55_375 VPWR VGND sg13g2_decap_8
XFILLER_56_898 VPWR VGND sg13g2_fill_1
XFILLER_43_526 VPWR VGND sg13g2_decap_8
XFILLER_71_835 VPWR VGND sg13g2_fill_2
XFILLER_38_1903 VPWR VGND sg13g2_fill_1
X_21846_ _21846_/Y _23922_/Q _21850_/B VPWR VGND sg13g2_nand2_1
XFILLER_71_857 VPWR VGND sg13g2_fill_1
XFILLER_93_1242 VPWR VGND sg13g2_decap_8
XFILLER_93_1253 VPWR VGND sg13g2_fill_2
XFILLER_90_15 VPWR VGND sg13g2_decap_8
Xinput4356 _17879_/A1 boot_addr_i[14] VPWR VGND sg13g2_buf_1
XFILLER_70_367 VPWR VGND sg13g2_fill_1
Xinput4367 _17911_/A1 boot_addr_i[25] VPWR VGND sg13g2_buf_1
X_21777_ _23889_/D _23889_/Q _21978_/A0 _21781_/S VPWR VGND sg13g2_mux2_1
XFILLER_12_935 VPWR VGND sg13g2_decap_4
Xinput4378 _20249_/A2 data_rdata_i[0] VPWR VGND sg13g2_buf_1
XFILLER_11_412 VPWR VGND sg13g2_decap_8
Xinput4389 _20255_/A2 data_rdata_i[1] VPWR VGND sg13g2_buf_1
X_23516_ _23516_/Q clkload53/A _23516_/D fanout2782/X VPWR VGND sg13g2_dfrbpq_1
XFILLER_51_592 VPWR VGND sg13g2_decap_4
X_20728_ _23415_/D _20931_/A1 _20727_/B _20727_/Y VPWR VGND sg13g2_o21ai_1
XFILLER_23_53 VPWR VGND sg13g2_decap_8
XFILLER_109_300 VPWR VGND sg13g2_fill_2
X_23447_ _23447_/Q clkload57/A _23447_/D fanout2762/X VPWR VGND sg13g2_dfrbpq_1
X_11461_ _11461_/X _23286_/Q _23318_/Q _23350_/Q _23382_/Q _11477_/A _11449_/B VPWR
+ VGND sg13g2_mux4_1
X_20659_ _23383_/D _20931_/A1 _20712_/S _20658_/Y VPWR VGND sg13g2_o21ai_1
X_13200_ _13201_/B _23753_/Q _23881_/Q _13796_/B VPWR VGND sg13g2_mux2_1
XFILLER_99_35 VPWR VGND sg13g2_decap_8
X_11392_ _11392_/Y _13675_/A1 _11382_/X _11383_/X _13165_/A1 _11391_/Y VPWR VGND sg13g2_a221oi_1
X_23378_ _23378_/Q _24212_/CLK _23378_/D fanout2628/X VPWR VGND sg13g2_dfrbpq_1
XFILLER_67_1609 VPWR VGND sg13g2_decap_8
XFILLER_101_1950 VPWR VGND sg13g2_decap_4
XFILLER_10_1844 VPWR VGND sg13g2_decap_8
X_13131_ _13136_/B _13131_/A _14134_/D _13131_/C VPWR VGND sg13g2_nor3_1
X_22329_ _24152_/D _19750_/Y _22328_/B _22328_/Y VPWR VGND sg13g2_o21ai_1
XFILLER_48_1008 VPWR VGND sg13g2_decap_4
XFILLER_30_1292 VPWR VGND sg13g2_decap_8
XFILLER_65_1300 VPWR VGND sg13g2_decap_8
XFILLER_79_902 VPWR VGND sg13g2_fill_2
XFILLER_112_509 VPWR VGND sg13g2_decap_8
X_13062_ _13065_/B _13067_/B _13072_/B _13072_/A VPWR VGND sg13g2_mux2_1
XFILLER_78_401 VPWR VGND sg13g2_decap_8
XFILLER_105_572 VPWR VGND sg13g2_decap_8
X_12013_ _12014_/B _23227_/Q _23355_/Q _12015_/S VPWR VGND sg13g2_mux2_1
XFILLER_2_176 VPWR VGND sg13g2_fill_1
Xhold4980 _20945_/A _23518_/Q VPWR VGND sg13g2_dlygate4sd3_1
X_17870_ _17871_/A _17870_/A1 _17855_/A _17927_/B _22921_/Q _17869_/Y VPWR VGND sg13g2_a221oi_1
Xhold4991 _20631_/A _23370_/Q VPWR VGND sg13g2_dlygate4sd3_1
XFILLER_79_968 VPWR VGND sg13g2_fill_2
XFILLER_43_1620 VPWR VGND sg13g2_decap_8
XFILLER_78_467 VPWR VGND sg13g2_fill_1
X_16821_ _16822_/B _22676_/Q _16821_/B VPWR VGND sg13g2_xnor2_1
XFILLER_93_404 VPWR VGND sg13g2_fill_1
XFILLER_19_501 VPWR VGND sg13g2_fill_1
XFILLER_93_426 VPWR VGND sg13g2_decap_8
XFILLER_87_990 VPWR VGND sg13g2_decap_8
XFILLER_115_1180 VPWR VGND sg13g2_decap_8
XFILLER_111_1011 VPWR VGND sg13g2_decap_8
X_16752_ _22665_/D _16109_/A _16755_/A _16751_/Y VPWR VGND sg13g2_a21oi_1
X_19540_ _19541_/A _20030_/S _19735_/B VPWR VGND sg13g2_nor2_1
XFILLER_43_1686 VPWR VGND sg13g2_fill_2
X_13964_ _13964_/X _23732_/Q _23764_/Q _23796_/Q _23828_/Q _12577_/C _13964_/S1 VPWR
+ VGND sg13g2_mux4_1
XFILLER_78_1705 VPWR VGND sg13g2_fill_1
XFILLER_0_35 VPWR VGND sg13g2_decap_8
XFILLER_46_342 VPWR VGND sg13g2_decap_8
X_15703_ _15704_/C _22799_/Q _16007_/B VPWR VGND sg13g2_nand2_1
XFILLER_74_651 VPWR VGND sg13g2_decap_4
X_12915_ _12915_/X _12913_/X _12914_/X _13244_/S VPWR VGND sg13g2_mux2_1
XFILLER_59_1115 VPWR VGND sg13g2_decap_4
X_16683_ _16683_/Y _16683_/A _16683_/B _16683_/C _16683_/D VPWR VGND sg13g2_nor4_1
X_19471_ _19471_/Y _19471_/A VPWR VGND sg13g2_inv_1
X_13895_ _13896_/B _13640_/S _13894_/Y _11457_/Y VPWR VGND sg13g2_o21ai_1
XFILLER_78_1749 VPWR VGND sg13g2_decap_8
XFILLER_47_898 VPWR VGND sg13g2_decap_8
X_18422_ _18422_/Y _18238_/A _18420_/Y _18426_/B VPWR VGND sg13g2_o21ai_1
X_15634_ _15634_/Y _16025_/A _16111_/A VPWR VGND sg13g2_nor2_1
XFILLER_73_183 VPWR VGND sg13g2_fill_1
X_12846_ _12847_/C _15629_/A _12841_/Y _12845_/Y VPWR VGND sg13g2_o21ai_1
XFILLER_91_1927 VPWR VGND sg13g2_decap_8
XFILLER_15_762 VPWR VGND sg13g2_decap_4
X_18353_ _18353_/Y _18461_/A _18349_/X _18350_/A _18380_/A _18352_/Y VPWR VGND sg13g2_a221oi_1
X_15565_ _17107_/A _16090_/S _16353_/B _15564_/Y VPWR VGND sg13g2_o21ai_1
X_12777_ _12778_/C _12782_/A _13028_/A _12777_/C VPWR VGND sg13g2_nand3b_1
XFILLER_42_581 VPWR VGND sg13g2_fill_1
X_14516_ _14518_/C _22614_/Q _23025_/Q VPWR VGND sg13g2_xnor2_1
XFILLER_42_592 VPWR VGND sg13g2_decap_8
X_11728_ _11728_/X _24024_/Q _24056_/Q _24088_/Q _24120_/Q _13961_/S0 _11726_/S VPWR
+ VGND sg13g2_mux4_1
X_18284_ _18284_/Y _18399_/A _18284_/B VPWR VGND sg13g2_nor2_1
XFILLER_54_1760 VPWR VGND sg13g2_decap_8
X_15496_ _15496_/X _17092_/A _22458_/Q _15496_/S VPWR VGND sg13g2_mux2_1
XFILLER_19_1891 VPWR VGND sg13g2_decap_8
XFILLER_9_99 VPWR VGND sg13g2_fill_2
Xplace3007 _22374_/B _22377_/B VPWR VGND sg13g2_buf_1
Xplace3018 _22210_/B _22249_/S VPWR VGND sg13g2_buf_1
X_11659_ _11660_/B _14026_/A _11653_/Y _11658_/Y VPWR VGND sg13g2_a21o_1
XFILLER_89_1812 VPWR VGND sg13g2_fill_2
XFILLER_80_92 VPWR VGND sg13g2_decap_8
Xplace3029 _22184_/B _22172_/B VPWR VGND sg13g2_buf_1
XFILLER_35_1192 VPWR VGND sg13g2_decap_8
XFILLER_31_1034 VPWR VGND sg13g2_decap_4
XFILLER_102_1736 VPWR VGND sg13g2_fill_2
X_17166_ _17171_/A _22736_/Q VPWR VGND sg13g2_inv_1
X_14378_ _14378_/Y _14378_/A _14378_/B _14378_/C _14378_/D VPWR VGND sg13g2_nand4_1
XFILLER_89_1856 VPWR VGND sg13g2_fill_2
X_16117_ _16117_/Y _16117_/A _16132_/B VPWR VGND sg13g2_nand2_1
X_17097_ _17097_/Y _17100_/A _17097_/B VPWR VGND sg13g2_xnor2_1
XFILLER_6_482 VPWR VGND sg13g2_fill_2
XFILLER_115_336 VPWR VGND sg13g2_decap_8
XFILLER_83_1422 VPWR VGND sg13g2_decap_8
X_16048_ _16048_/X _15333_/Y _16353_/B _16048_/S VPWR VGND sg13g2_mux2_1
XFILLER_9_1013 VPWR VGND sg13g2_decap_8
XFILLER_111_520 VPWR VGND sg13g2_decap_8
XFILLER_69_445 VPWR VGND sg13g2_decap_8
XFILLER_69_456 VPWR VGND sg13g2_fill_1
Xfanout2680 fanout2680/X fanout2681/X VPWR VGND sg13g2_buf_1
X_19807_ _19807_/Y _19807_/A1 _19977_/B _19800_/Y _19769_/A _19806_/Y VPWR VGND sg13g2_a221oi_1
XFILLER_29_0 VPWR VGND sg13g2_decap_8
XFILLER_97_787 VPWR VGND sg13g2_fill_2
XFILLER_96_264 VPWR VGND sg13g2_decap_8
Xfanout2691 fanout2691/X fanout2692/X VPWR VGND sg13g2_buf_1
XFILLER_26_1873 VPWR VGND sg13g2_fill_1
XFILLER_6_1945 VPWR VGND sg13g2_decap_8
X_17999_ _18458_/A _18501_/S _17999_/B VPWR VGND sg13g2_nor2_1
XFILLER_111_597 VPWR VGND sg13g2_decap_8
XFILLER_113_1843 VPWR VGND sg13g2_decap_8
XFILLER_26_1895 VPWR VGND sg13g2_fill_2
XFILLER_61_1775 VPWR VGND sg13g2_fill_1
X_19738_ _20307_/B _20092_/A2 _19737_/Y _19767_/A VPWR VGND sg13g2_a21oi_1
XFILLER_56_139 VPWR VGND sg13g2_decap_4
XFILLER_61_1797 VPWR VGND sg13g2_decap_8
XFILLER_96_1816 VPWR VGND sg13g2_decap_8
XFILLER_65_651 VPWR VGND sg13g2_decap_4
XFILLER_53_802 VPWR VGND sg13g2_decap_8
X_19669_ _19669_/Y _19673_/B _19930_/B VPWR VGND sg13g2_nor2_1
XFILLER_77_1237 VPWR VGND sg13g2_fill_1
XFILLER_37_386 VPWR VGND sg13g2_decap_8
XFILLER_52_312 VPWR VGND sg13g2_decap_8
XFILLER_64_172 VPWR VGND sg13g2_decap_8
X_21700_ _21700_/Y _23862_/Q _21716_/B VPWR VGND sg13g2_nand2_1
XFILLER_0_1533 VPWR VGND sg13g2_decap_4
XFILLER_37_397 VPWR VGND sg13g2_fill_1
XFILLER_25_548 VPWR VGND sg13g2_decap_8
X_22680_ _22680_/Q clkload20/A _22680_/D fanout2866/X VPWR VGND sg13g2_dfrbpq_1
XFILLER_0_1566 VPWR VGND sg13g2_fill_1
XFILLER_20_1494 VPWR VGND sg13g2_decap_8
XFILLER_52_367 VPWR VGND sg13g2_decap_8
X_21631_ _21631_/Y _23830_/Q _21642_/B VPWR VGND sg13g2_nand2_1
XFILLER_94_1573 VPWR VGND sg13g2_decap_8
XFILLER_100_14 VPWR VGND sg13g2_decap_8
XFILLER_94_1584 VPWR VGND sg13g2_decap_8
XFILLER_16_1508 VPWR VGND sg13g2_fill_2
XFILLER_55_1568 VPWR VGND sg13g2_decap_8
X_21562_ _21562_/Y _23797_/Q _21574_/B VPWR VGND sg13g2_nand2_1
XFILLER_33_1800 VPWR VGND sg13g2_fill_2
Xplace4220 _12128_/A _22984_/Q VPWR VGND sg13g2_buf_1
XFILLER_20_242 VPWR VGND sg13g2_decap_8
X_23301_ _23301_/Q clkload33/A _23301_/D fanout2699/X VPWR VGND sg13g2_dfrbpq_1
Xplace4231 _13978_/S1 _13582_/A VPWR VGND sg13g2_buf_1
Xplace4242 _13919_/S1 _13911_/B2 VPWR VGND sg13g2_buf_1
Xrebuffer5221 _19443_/A _19801_/A VPWR VGND sg13g2_buf_1
X_20513_ _23316_/D _22451_/A1 _20512_/B _20512_/Y VPWR VGND sg13g2_o21ai_1
XFILLER_53_1270 VPWR VGND sg13g2_fill_2
Xrebuffer5232 place3840/A _12219_/Y VPWR VGND sg13g2_buf_8
Xplace4253 _12050_/C _13983_/S1 VPWR VGND sg13g2_buf_4
Xrebuffer5243 _11673_/B _11662_/B VPWR VGND sg13g2_buf_1
XFILLER_33_1855 VPWR VGND sg13g2_decap_8
Xplace4264 _11390_/A _13680_/S1 VPWR VGND sg13g2_buf_2
XFILLER_88_1300 VPWR VGND sg13g2_decap_8
Xplace4275 _13236_/S0 _13039_/S VPWR VGND sg13g2_buf_1
Xplace3530 _15945_/B1 _15284_/Y VPWR VGND sg13g2_buf_1
Xplace3541 _15893_/B1 _15804_/B1 VPWR VGND sg13g2_buf_1
Xrebuffer5254 place3714/A _12928_/Y VPWR VGND sg13g2_buf_2
Xrebuffer5265 _11302_/B _11301_/X VPWR VGND sg13g2_buf_8
Xplace4286 _13910_/S _13621_/S VPWR VGND sg13g2_buf_4
X_23232_ _23232_/Q _23682_/CLK _23232_/D fanout2722/X VPWR VGND sg13g2_dfrbpq_1
XFILLER_101_1224 VPWR VGND sg13g2_decap_8
Xplace3552 _15825_/B _15296_/Y VPWR VGND sg13g2_buf_1
Xrebuffer5276 _11556_/A place3946/A VPWR VGND sg13g2_buf_1
Xplace4297 _12166_/B _13039_/S VPWR VGND sg13g2_buf_2
XFILLER_107_815 VPWR VGND sg13g2_decap_4
Xplace3563 _14732_/S _14728_/S VPWR VGND sg13g2_buf_1
Xrebuffer5287 _13724_/A2 _20271_/B VPWR VGND sg13g2_buf_2
Xrebuffer5298 _19401_/B _14284_/Y VPWR VGND sg13g2_buf_8
Xplace3574 _20060_/A _19764_/A VPWR VGND sg13g2_buf_1
Xplace3585 _19987_/A _20030_/S VPWR VGND sg13g2_buf_1
XFILLER_109_56 VPWR VGND sg13g2_decap_8
XFILLER_88_1366 VPWR VGND sg13g2_decap_4
Xplace3596 _17918_/A2 _17926_/A2 VPWR VGND sg13g2_buf_1
X_23163_ _23163_/Q clkload17/A _23163_/D fanout2857/X VPWR VGND sg13g2_dfrbpq_1
Xrebuffer4575 _14977_/A1 _13014_/Y VPWR VGND sg13g2_buf_8
XFILLER_107_7 VPWR VGND sg13g2_decap_8
Xrebuffer4586 _13282_/A1 _13278_/Y VPWR VGND sg13g2_buf_2
XFILLER_84_1219 VPWR VGND sg13g2_decap_8
Xrebuffer4597 _19195_/B _14036_/C VPWR VGND sg13g2_buf_1
XFILLER_106_358 VPWR VGND sg13g2_decap_8
X_22114_ _22114_/Y _24050_/Q _22117_/B VPWR VGND sg13g2_nand2_1
XFILLER_106_369 VPWR VGND sg13g2_fill_1
X_23094_ _23094_/Q clkload14/A _23094_/D fanout2842/X VPWR VGND sg13g2_dfrbpq_1
X_22045_ _22045_/Y _22045_/A _22045_/B VPWR VGND sg13g2_nand2_1
XFILLER_66_1686 VPWR VGND sg13g2_decap_8
XFILLER_47_1085 VPWR VGND sg13g2_fill_1
XFILLER_48_618 VPWR VGND sg13g2_fill_2
XFILLER_102_575 VPWR VGND sg13g2_decap_8
XFILLER_87_264 VPWR VGND sg13g2_decap_8
XFILLER_76_938 VPWR VGND sg13g2_decap_4
XFILLER_75_415 VPWR VGND sg13g2_decap_8
XFILLER_85_48 VPWR VGND sg13g2_decap_4
XFILLER_60_1241 VPWR VGND sg13g2_decap_4
XFILLER_40_1826 VPWR VGND sg13g2_decap_8
XFILLER_40_1837 VPWR VGND sg13g2_fill_2
X_23996_ _23996_/Q clkload56/A _23996_/D fanout2677/X VPWR VGND sg13g2_dfrbpq_1
XFILLER_18_42 VPWR VGND sg13g2_decap_8
XFILLER_60_1274 VPWR VGND sg13g2_fill_2
XFILLER_112_1353 VPWR VGND sg13g2_decap_8
XFILLER_5_1488 VPWR VGND sg13g2_decap_8
XFILLER_1_1319 VPWR VGND sg13g2_fill_2
XFILLER_62_109 VPWR VGND sg13g2_decap_8
X_22947_ _22947_/Q clkload16/A _22947_/D fanout2920/X VPWR VGND sg13g2_dfrbpq_1
XFILLER_95_1326 VPWR VGND sg13g2_fill_1
XFILLER_29_898 VPWR VGND sg13g2_fill_1
XFILLER_43_323 VPWR VGND sg13g2_decap_8
X_13680_ _13680_/X _23728_/Q _23760_/Q _23792_/Q _23824_/Q _13671_/B _13680_/S1 VPWR
+ VGND sg13g2_mux4_1
XFILLER_44_868 VPWR VGND sg13g2_decap_8
X_22878_ _22878_/Q _22917_/CLK _22878_/D fanout2893/X VPWR VGND sg13g2_dfrbpq_1
XFILLER_73_1613 VPWR VGND sg13g2_fill_1
XFILLER_31_518 VPWR VGND sg13g2_decap_4
X_12631_ _12638_/C _12831_/B _12762_/B VPWR VGND sg13g2_nand2_1
X_21829_ _23911_/D _20156_/Y _21843_/B _21828_/Y VPWR VGND sg13g2_o21ai_1
XFILLER_19_1165 VPWR VGND sg13g2_fill_1
XFILLER_54_1045 VPWR VGND sg13g2_decap_8
X_15350_ _15373_/C _22877_/Q _15347_/Y _15349_/Y VPWR VGND sg13g2_a21oi_1
X_12562_ _12562_/X _23297_/Q _23329_/Q _23361_/Q _23393_/Q _13274_/S0 _13260_/A1 VPWR
+ VGND sg13g2_mux4_1
XFILLER_34_96 VPWR VGND sg13g2_decap_8
XFILLER_54_1089 VPWR VGND sg13g2_decap_4
X_11513_ _12316_/A _22987_/Q _12577_/B VPWR VGND sg13g2_nor2b_2
X_15281_ _16052_/A _15279_/Y _16023_/B _15280_/Y VPWR VGND sg13g2_o21ai_1
X_12493_ _12493_/X _24032_/Q _24064_/Q _24096_/Q _24128_/Q _11465_/A _11449_/B VPWR
+ VGND sg13g2_mux4_1
XFILLER_106_1179 VPWR VGND sg13g2_decap_8
X_17020_ _17020_/Y _22713_/Q _17020_/B VPWR VGND sg13g2_xnor2_1
X_14232_ _15133_/B _14253_/A _14229_/Y _14861_/A VPWR VGND sg13g2_a21oi_2
X_11444_ _11444_/Y _11435_/Y _11993_/A _11441_/X _13987_/B _11443_/Y VPWR VGND sg13g2_a221oi_1
XFILLER_12_1939 VPWR VGND sg13g2_decap_8
XFILLER_50_51 VPWR VGND sg13g2_fill_2
XFILLER_32_1376 VPWR VGND sg13g2_decap_4
XFILLER_50_62 VPWR VGND sg13g2_fill_2
X_14163_ _14166_/A _22749_/Q _22748_/Q _22581_/Q VPWR VGND sg13g2_nand3_1
XFILLER_109_196 VPWR VGND sg13g2_decap_8
X_11375_ _11993_/A _13123_/A _13179_/B VPWR VGND sg13g2_and2_2
X_13114_ _13115_/B _23592_/Q _23624_/Q _23656_/Q _23688_/Q _13614_/S0 _13614_/S1 VPWR
+ VGND sg13g2_mux4_1
X_18971_ _18971_/Y _23054_/Q _19008_/A _19048_/B1 VPWR VGND sg13g2_o21ai_1
XFILLER_49_1862 VPWR VGND sg13g2_fill_1
X_14094_ _14094_/Y _19320_/A _19480_/C _14094_/C VPWR VGND sg13g2_nand3_1
XFILLER_79_710 VPWR VGND sg13g2_decap_8
XFILLER_10_1696 VPWR VGND sg13g2_fill_1
X_17922_ _22938_/D _17922_/A _17922_/B VPWR VGND sg13g2_nand2_1
X_13045_ _13045_/X _24167_/Q _24199_/Q _23239_/Q _23271_/Q _13236_/S0 _13236_/S1 VPWR
+ VGND sg13g2_mux4_1
XFILLER_26_1103 VPWR VGND sg13g2_decap_4
XFILLER_84_1786 VPWR VGND sg13g2_fill_1
XFILLER_79_743 VPWR VGND sg13g2_fill_1
XFILLER_3_496 VPWR VGND sg13g2_decap_8
XFILLER_65_1196 VPWR VGND sg13g2_fill_1
XFILLER_67_916 VPWR VGND sg13g2_decap_8
XFILLER_22_7 VPWR VGND sg13g2_decap_8
XFILLER_61_1038 VPWR VGND sg13g2_decap_8
XFILLER_26_1158 VPWR VGND sg13g2_fill_1
X_17853_ _17853_/Y _22917_/Q _17853_/B _17853_/C VPWR VGND sg13g2_nand3_1
XFILLER_26_1169 VPWR VGND sg13g2_decap_8
XFILLER_66_426 VPWR VGND sg13g2_decap_8
XFILLER_94_746 VPWR VGND sg13g2_fill_1
X_16804_ _16804_/Y _16830_/A _16804_/B VPWR VGND sg13g2_nand2_1
XFILLER_38_139 VPWR VGND sg13g2_decap_8
XFILLER_82_908 VPWR VGND sg13g2_decap_8
XFILLER_19_331 VPWR VGND sg13g2_decap_8
X_14996_ _14999_/B _22470_/Q _15006_/B _15075_/B1 _22929_/Q VPWR VGND sg13g2_a22oi_1
X_17784_ _17799_/C _17784_/A _17784_/B VPWR VGND sg13g2_nor2_1
XFILLER_43_1483 VPWR VGND sg13g2_fill_1
XFILLER_75_960 VPWR VGND sg13g2_decap_4
XFILLER_47_662 VPWR VGND sg13g2_fill_2
X_19523_ _19523_/Y _19545_/A _19523_/B VPWR VGND sg13g2_nor2_1
X_16735_ _16748_/C _16735_/A _16735_/B _16735_/C _16735_/D VPWR VGND sg13g2_nor4_2
X_13947_ _13952_/B _13947_/A _13951_/C VPWR VGND sg13g2_nor2_1
XFILLER_35_824 VPWR VGND sg13g2_fill_1
XFILLER_46_172 VPWR VGND sg13g2_fill_1
XFILLER_47_695 VPWR VGND sg13g2_decap_8
XFILLER_19_397 VPWR VGND sg13g2_fill_2
XFILLER_1_1853 VPWR VGND sg13g2_decap_8
XFILLER_46_183 VPWR VGND sg13g2_fill_2
X_19454_ _19454_/Y _20322_/A _19576_/B VPWR VGND sg13g2_nand2_1
X_16666_ _22648_/D _16665_/Y _17209_/A _16666_/S VPWR VGND sg13g2_mux2_1
XFILLER_61_120 VPWR VGND sg13g2_fill_1
X_13878_ _13932_/D _13436_/Y _13099_/Y _13438_/Y _13440_/Y _13877_/Y VPWR VGND sg13g2_a221oi_1
X_18405_ _18406_/B _18405_/A _18427_/B VPWR VGND sg13g2_nand2_1
X_15617_ _15623_/A _15617_/A _15617_/B VPWR VGND sg13g2_nand2_1
XFILLER_22_518 VPWR VGND sg13g2_decap_8
XFILLER_56_1844 VPWR VGND sg13g2_fill_2
X_12829_ _12829_/X _12837_/A _12829_/B _12829_/C VPWR VGND sg13g2_and3_1
X_19385_ _19386_/B _15218_/A _19367_/B _19384_/Y VPWR VGND sg13g2_a21oi_1
X_16597_ _16598_/B _22634_/Q _16604_/C VPWR VGND sg13g2_xor2_1
X_18336_ _18336_/Y _18457_/S _18336_/B _18336_/C VPWR VGND sg13g2_nor3_1
X_15548_ _15548_/Y _15695_/S _15548_/B VPWR VGND sg13g2_nor2_1
X_18267_ _18267_/Y _18517_/B _18265_/Y _18266_/Y VPWR VGND sg13g2_a21oi_1
X_15479_ _15481_/C _22917_/Q _17835_/A _15478_/Y _15479_/B2 VPWR VGND sg13g2_a22oi_1
X_17218_ _17219_/B _17218_/A _17218_/B _17224_/A VPWR VGND sg13g2_nor3_1
X_18198_ _18198_/X _18144_/Y _18379_/B _18380_/A VPWR VGND sg13g2_a21o_1
XFILLER_50_1476 VPWR VGND sg13g2_decap_8
XFILLER_11_1449 VPWR VGND sg13g2_decap_4
X_17149_ _17160_/D _17149_/A _17149_/B VPWR VGND sg13g2_nor2_1
XFILLER_115_133 VPWR VGND sg13g2_decap_8
XFILLER_89_507 VPWR VGND sg13g2_decap_4
X_20160_ _23239_/D _20269_/B _22429_/A1 _20159_/Y VPWR VGND sg13g2_o21ai_1
XFILLER_89_518 VPWR VGND sg13g2_decap_8
XFILLER_28_1935 VPWR VGND sg13g2_decap_8
XFILLER_44_1203 VPWR VGND sg13g2_decap_8
XFILLER_63_1826 VPWR VGND sg13g2_decap_4
X_20091_ _20094_/B _24260_/A _20091_/B VPWR VGND sg13g2_nand2_1
XFILLER_48_1394 VPWR VGND sg13g2_fill_2
XFILLER_58_905 VPWR VGND sg13g2_decap_8
XFILLER_58_916 VPWR VGND sg13g2_decap_8
XFILLER_69_253 VPWR VGND sg13g2_decap_8
XFILLER_115_1938 VPWR VGND sg13g2_decap_8
XFILLER_112_873 VPWR VGND sg13g2_decap_8
XFILLER_85_713 VPWR VGND sg13g2_decap_8
XFILLER_84_201 VPWR VGND sg13g2_decap_4
XFILLER_6_1742 VPWR VGND sg13g2_decap_8
XFILLER_111_394 VPWR VGND sg13g2_decap_8
XFILLER_29_139 VPWR VGND sg13g2_fill_2
X_23850_ _23850_/Q clkload45/A _23850_/D fanout2711/X VPWR VGND sg13g2_dfrbpq_1
XFILLER_61_1572 VPWR VGND sg13g2_decap_8
XFILLER_113_1673 VPWR VGND sg13g2_fill_1
X_22801_ _22801_/Q _22893_/CLK _22801_/D fanout2817/X VPWR VGND sg13g2_dfrbpq_1
XFILLER_84_289 VPWR VGND sg13g2_decap_8
XFILLER_37_150 VPWR VGND sg13g2_fill_2
X_23781_ _23781_/Q clkload39/A _23781_/D fanout2738/X VPWR VGND sg13g2_dfrbpq_1
XFILLER_25_301 VPWR VGND sg13g2_decap_8
X_20993_ _21079_/B _21984_/A _22119_/A VPWR VGND sg13g2_nand2_1
XFILLER_53_621 VPWR VGND sg13g2_fill_2
X_22732_ _22732_/Q _22733_/CLK _22732_/D fanout2881/X VPWR VGND sg13g2_dfrbpq_1
XFILLER_26_857 VPWR VGND sg13g2_decap_8
XFILLER_26_868 VPWR VGND sg13g2_fill_1
XFILLER_111_35 VPWR VGND sg13g2_decap_8
XFILLER_109_1709 VPWR VGND sg13g2_fill_1
XFILLER_41_805 VPWR VGND sg13g2_decap_4
X_22663_ _22663_/Q clkload23/A _22663_/D fanout2883/X VPWR VGND sg13g2_dfrbpq_1
XFILLER_40_315 VPWR VGND sg13g2_fill_2
XFILLER_53_698 VPWR VGND sg13g2_decap_8
XFILLER_71_28 VPWR VGND sg13g2_fill_1
X_21614_ _23823_/D _21975_/A0 _23823_/Q _21620_/S VPWR VGND sg13g2_mux2_1
XFILLER_90_1245 VPWR VGND sg13g2_decap_8
X_22594_ _22594_/Q clkload22/A _22594_/D fanout2895/X VPWR VGND sg13g2_dfrbpq_1
XFILLER_21_551 VPWR VGND sg13g2_decap_8
XFILLER_107_1455 VPWR VGND sg13g2_fill_1
X_21545_ _23789_/D _21972_/A0 _23789_/Q _21554_/S VPWR VGND sg13g2_mux2_1
Xplace4050 _18959_/A _19023_/B VPWR VGND sg13g2_buf_1
Xplace4061 _18573_/A _17987_/B VPWR VGND sg13g2_buf_1
Xplace4072 _18052_/S _18899_/A VPWR VGND sg13g2_buf_1
Xplace4083 _19505_/A _23196_/Q VPWR VGND sg13g2_buf_1
X_24264_ _24264_/X _24264_/A VPWR VGND sg13g2_buf_1
Xplace4094 _19268_/A _23193_/Q VPWR VGND sg13g2_buf_1
X_21476_ _23755_/D _21677_/A1 _21489_/B _21475_/Y VPWR VGND sg13g2_o21ai_1
Xplace3360 _21936_/A1 _22270_/A1 VPWR VGND sg13g2_buf_1
XFILLER_14_1084 VPWR VGND sg13g2_decap_8
Xplace3371 _22260_/A1 _19628_/Y VPWR VGND sg13g2_buf_1
X_23215_ _23215_/Q _23215_/CLK _23215_/D fanout2926/X VPWR VGND sg13g2_dfrbpq_1
XFILLER_4_216 VPWR VGND sg13g2_decap_8
X_20427_ _23278_/D _22442_/A1 _20429_/B _20426_/Y VPWR VGND sg13g2_o21ai_1
Xplace3382 _17480_/A1 _17887_/A VPWR VGND sg13g2_buf_1
X_24195_ _24195_/Q clkload34/A _24195_/D fanout2695/X VPWR VGND sg13g2_dfrbpq_1
XFILLER_49_1114 VPWR VGND sg13g2_decap_8
Xplace3393 _17462_/B _17502_/S VPWR VGND sg13g2_buf_1
XFILLER_106_133 VPWR VGND sg13g2_decap_8
XFILLER_49_1125 VPWR VGND sg13g2_fill_1
XFILLER_68_1748 VPWR VGND sg13g2_fill_1
X_23146_ _23146_/Q clkload14/A _23146_/D fanout2840/X VPWR VGND sg13g2_dfrbpq_1
X_20358_ _20358_/Y _20354_/Y _20355_/Y _20357_/Y _20355_/B _19956_/A VPWR VGND sg13g2_a221oi_1
XFILLER_96_14 VPWR VGND sg13g2_decap_8
XFILLER_1_934 VPWR VGND sg13g2_fill_1
XFILLER_27_1412 VPWR VGND sg13g2_fill_1
X_23077_ _23077_/Q _23114_/CLK _23077_/D fanout2906/X VPWR VGND sg13g2_dfrbpq_1
X_20289_ _20291_/A _20290_/A _20289_/B VPWR VGND sg13g2_nand2b_1
XFILLER_27_1434 VPWR VGND sg13g2_fill_2
X_22028_ _24007_/D _20156_/Y _22039_/B _22027_/Y VPWR VGND sg13g2_o21ai_1
XFILLER_103_884 VPWR VGND sg13g2_decap_4
XFILLER_49_949 VPWR VGND sg13g2_fill_1
XFILLER_76_724 VPWR VGND sg13g2_decap_8
XFILLER_29_74 VPWR VGND sg13g2_decap_8
XFILLER_40_1612 VPWR VGND sg13g2_fill_2
XFILLER_48_448 VPWR VGND sg13g2_decap_4
X_14850_ _14874_/B _14883_/B _17932_/B VPWR VGND sg13g2_nor2_1
XFILLER_21_1011 VPWR VGND sg13g2_decap_8
XFILLER_29_651 VPWR VGND sg13g2_decap_8
X_13801_ _13801_/Y _13801_/A1 _13787_/Y _13791_/Y _13267_/A _13800_/Y VPWR VGND sg13g2_a221oi_1
XFILLER_91_727 VPWR VGND sg13g2_fill_2
XFILLER_35_109 VPWR VGND sg13g2_decap_8
XFILLER_57_971 VPWR VGND sg13g2_fill_1
XFILLER_95_1101 VPWR VGND sg13g2_fill_2
XFILLER_28_150 VPWR VGND sg13g2_decap_4
XFILLER_112_1172 VPWR VGND sg13g2_decap_8
X_11993_ _11993_/Y _11993_/A _11993_/B VPWR VGND sg13g2_nand2_1
XFILLER_17_824 VPWR VGND sg13g2_decap_8
X_23979_ _23979_/Q _24210_/CLK _23979_/D fanout2642/X VPWR VGND sg13g2_dfrbpq_1
XFILLER_29_695 VPWR VGND sg13g2_decap_8
XFILLER_40_1689 VPWR VGND sg13g2_fill_2
X_16520_ _16666_/S _16681_/B _16681_/C _17399_/A VPWR VGND sg13g2_and3_1
XFILLER_17_846 VPWR VGND sg13g2_decap_8
XFILLER_44_632 VPWR VGND sg13g2_decap_8
X_13732_ _13732_/Y _13534_/Y _13540_/Y _13731_/Y VPWR VGND sg13g2_o21ai_1
XFILLER_75_1708 VPWR VGND sg13g2_decap_4
XFILLER_16_334 VPWR VGND sg13g2_decap_8
XFILLER_75_1719 VPWR VGND sg13g2_fill_2
XFILLER_21_1099 VPWR VGND sg13g2_decap_4
XFILLER_44_654 VPWR VGND sg13g2_decap_8
XFILLER_32_816 VPWR VGND sg13g2_decap_4
XFILLER_95_1178 VPWR VGND sg13g2_decap_8
X_13663_ _14001_/B _20258_/A _15884_/A VPWR VGND sg13g2_nor2_1
XFILLER_77_1590 VPWR VGND sg13g2_decap_4
X_15402_ _15403_/B _22688_/Q _15487_/A2 _15487_/B1 _22624_/Q VPWR VGND sg13g2_a22oi_1
X_19170_ _23142_/D _23142_/Q _14992_/X _19181_/S VPWR VGND sg13g2_mux2_1
XFILLER_38_1563 VPWR VGND sg13g2_decap_8
XFILLER_43_197 VPWR VGND sg13g2_decap_8
X_12614_ _12614_/Y _14055_/A _12768_/S VPWR VGND sg13g2_xnor2_1
XFILLER_38_1574 VPWR VGND sg13g2_fill_2
X_16382_ _22554_/D _23004_/Q _22554_/Q _16388_/B VPWR VGND sg13g2_mux2_1
X_13594_ _13594_/Y _23566_/Q _13975_/A2 _13593_/X _13582_/A _13686_/A VPWR VGND sg13g2_a221oi_1
X_18121_ _18121_/Y _22954_/Q _18557_/B VPWR VGND sg13g2_nand2_1
X_15333_ _15333_/Y _15996_/A _15333_/B VPWR VGND sg13g2_nand2_1
XFILLER_12_573 VPWR VGND sg13g2_fill_1
X_12545_ _24256_/A _14051_/B VPWR VGND sg13g2_inv_2
XFILLER_61_83 VPWR VGND sg13g2_fill_1
X_18052_ _18052_/X _18951_/B _23053_/Q _18052_/S VPWR VGND sg13g2_mux2_1
X_15264_ _16786_/B _15300_/A _15264_/B VPWR VGND sg13g2_nand2_1
X_12476_ _12477_/B _23584_/Q _23648_/Q _12478_/S VPWR VGND sg13g2_mux2_1
XFILLER_6_34 VPWR VGND sg13g2_fill_1
X_17003_ _17004_/A _22709_/Q VPWR VGND sg13g2_inv_1
XFILLER_103_1875 VPWR VGND sg13g2_decap_8
XFILLER_86_1815 VPWR VGND sg13g2_decap_8
X_14215_ _14215_/X _14215_/A _22823_/Q VPWR VGND sg13g2_and2_1
X_11427_ _12245_/A _11423_/B _11427_/B VPWR VGND sg13g2_nand2b_2
XANTENNA_5 _14614_/Y VPWR VGND sg13g2_antennanp
XFILLER_86_1826 VPWR VGND sg13g2_decap_8
X_14146_ _14435_/A _14441_/A _14146_/B VPWR VGND sg13g2_nor2_1
X_11358_ _11358_/X _23703_/Q _23735_/Q _23767_/Q _23799_/Q _11768_/S0 _11768_/S1 VPWR
+ VGND sg13g2_mux4_1
XFILLER_4_761 VPWR VGND sg13g2_decap_4
XFILLER_113_659 VPWR VGND sg13g2_decap_8
X_18954_ _18955_/B _18953_/Y _23053_/Q _18956_/B VPWR VGND sg13g2_mux2_1
X_14077_ _14423_/B _19320_/A _19320_/C VPWR VGND sg13g2_nand2_1
XFILLER_80_1414 VPWR VGND sg13g2_decap_8
X_11289_ _12889_/A _11456_/B VPWR VGND sg13g2_inv_2
XFILLER_112_147 VPWR VGND sg13g2_decap_8
X_17905_ _17907_/A _17905_/A1 _17918_/A2 _17920_/B1 _17182_/A VPWR VGND sg13g2_a22oi_1
X_13028_ _13028_/X _13028_/A _13028_/B _13028_/C VPWR VGND sg13g2_or3_1
X_18885_ _18886_/C _18890_/B _23079_/Q VPWR VGND sg13g2_nand2_1
XFILLER_79_595 VPWR VGND sg13g2_decap_8
XFILLER_23_1810 VPWR VGND sg13g2_decap_8
XFILLER_94_521 VPWR VGND sg13g2_fill_1
XFILLER_66_212 VPWR VGND sg13g2_fill_1
XFILLER_3_1904 VPWR VGND sg13g2_decap_8
XFILLER_62_1881 VPWR VGND sg13g2_decap_8
XFILLER_94_554 VPWR VGND sg13g2_decap_4
XFILLER_55_908 VPWR VGND sg13g2_decap_8
XFILLER_66_245 VPWR VGND sg13g2_decap_8
XFILLER_97_1911 VPWR VGND sg13g2_decap_8
XFILLER_48_960 VPWR VGND sg13g2_decap_8
XFILLER_48_971 VPWR VGND sg13g2_fill_1
XFILLER_110_1824 VPWR VGND sg13g2_decap_8
X_17767_ _17767_/Y _22901_/Q _17789_/B VPWR VGND sg13g2_nor2_1
XFILLER_78_1332 VPWR VGND sg13g2_decap_8
X_14979_ _16282_/B _17888_/A1 _14801_/B _16304_/A VPWR VGND sg13g2_o21ai_1
XFILLER_78_1343 VPWR VGND sg13g2_fill_1
XFILLER_35_632 VPWR VGND sg13g2_decap_4
XFILLER_39_1316 VPWR VGND sg13g2_decap_8
XFILLER_39_1327 VPWR VGND sg13g2_fill_2
X_17698_ _17698_/Y _14129_/C _17697_/A _17697_/Y VPWR VGND sg13g2_o21ai_1
XFILLER_35_676 VPWR VGND sg13g2_decap_4
XFILLER_63_985 VPWR VGND sg13g2_fill_2
X_19437_ _20030_/S _19437_/A _19437_/B VPWR VGND sg13g2_xnor2_1
XFILLER_34_164 VPWR VGND sg13g2_decap_8
XFILLER_50_613 VPWR VGND sg13g2_decap_8
XFILLER_62_473 VPWR VGND sg13g2_decap_8
XFILLER_56_1630 VPWR VGND sg13g2_fill_1
XFILLER_91_1532 VPWR VGND sg13g2_decap_8
XFILLER_96_0 VPWR VGND sg13g2_decap_8
X_19368_ _19368_/Y _20290_/A _19367_/B _19367_/Y VPWR VGND sg13g2_o21ai_1
XFILLER_22_359 VPWR VGND sg13g2_decap_8
XFILLER_91_1565 VPWR VGND sg13g2_decap_8
XFILLER_17_1658 VPWR VGND sg13g2_fill_1
X_18319_ _18320_/B _18318_/A _17999_/B _18318_/Y VPWR VGND sg13g2_o21ai_1
X_19299_ _23216_/D _23216_/Q _20284_/A0 _19299_/S VPWR VGND sg13g2_mux2_1
XFILLER_30_370 VPWR VGND sg13g2_decap_8
XFILLER_104_1639 VPWR VGND sg13g2_decap_8
X_21330_ _21330_/Y _23686_/Q _21330_/B VPWR VGND sg13g2_nand2_1
XFILLER_89_1461 VPWR VGND sg13g2_decap_8
XFILLER_11_1246 VPWR VGND sg13g2_decap_8
X_21261_ _23652_/D _21261_/A1 _21266_/B _21260_/Y VPWR VGND sg13g2_o21ai_1
XFILLER_89_1483 VPWR VGND sg13g2_fill_2
X_23000_ _23000_/Q clkload17/A _23000_/D fanout2848/X VPWR VGND sg13g2_dfrbpq_1
X_20212_ _20214_/B _19769_/A _19937_/Y _19938_/Y _20295_/A1 VPWR VGND sg13g2_a22oi_1
X_21192_ _23619_/D _21325_/A1 _21197_/B _21191_/Y VPWR VGND sg13g2_o21ai_1
XFILLER_67_1770 VPWR VGND sg13g2_decap_8
XFILLER_8_1804 VPWR VGND sg13g2_decap_8
XFILLER_44_1000 VPWR VGND sg13g2_fill_1
XFILLER_63_1634 VPWR VGND sg13g2_fill_1
XFILLER_106_35 VPWR VGND sg13g2_decap_8
X_20074_ _20074_/Y _20100_/A1 _20071_/Y _20073_/Y _20130_/B _20100_/C1 VPWR VGND sg13g2_a221oi_1
XFILLER_115_1735 VPWR VGND sg13g2_decap_8
XFILLER_112_670 VPWR VGND sg13g2_decap_8
XFILLER_85_510 VPWR VGND sg13g2_decap_4
X_23902_ _23902_/Q clkload44/A _23902_/D fanout2749/X VPWR VGND sg13g2_dfrbpq_1
XFILLER_57_234 VPWR VGND sg13g2_decap_8
XFILLER_41_1932 VPWR VGND sg13g2_decap_4
XFILLER_44_1099 VPWR VGND sg13g2_decap_4
XFILLER_41_1954 VPWR VGND sg13g2_fill_1
XFILLER_45_407 VPWR VGND sg13g2_decap_8
X_23833_ _23833_/Q _23966_/CLK _23833_/D fanout2783/X VPWR VGND sg13g2_dfrbpq_1
XFILLER_57_278 VPWR VGND sg13g2_fill_2
XFILLER_72_204 VPWR VGND sg13g2_decap_8
XFILLER_73_727 VPWR VGND sg13g2_decap_8
XFILLER_85_598 VPWR VGND sg13g2_decap_8
XFILLER_26_610 VPWR VGND sg13g2_decap_8
XFILLER_26_621 VPWR VGND sg13g2_fill_1
XFILLER_72_237 VPWR VGND sg13g2_fill_1
XFILLER_22_1397 VPWR VGND sg13g2_decap_8
X_23764_ _23764_/Q clkload49/A _23764_/D fanout2670/X VPWR VGND sg13g2_dfrbpq_1
X_20976_ _23532_/D _21342_/A1 _20983_/B _20975_/Y VPWR VGND sg13g2_o21ai_1
X_22715_ _22715_/Q clkload23/A _22715_/D fanout2884/X VPWR VGND sg13g2_dfrbpq_1
XFILLER_54_996 VPWR VGND sg13g2_fill_2
X_23695_ _23695_/Q clkload51/A _23695_/D fanout2658/X VPWR VGND sg13g2_dfrbpq_1
XFILLER_25_175 VPWR VGND sg13g2_decap_4
XFILLER_41_624 VPWR VGND sg13g2_fill_1
XFILLER_53_484 VPWR VGND sg13g2_decap_8
XFILLER_15_43 VPWR VGND sg13g2_decap_8
X_22646_ _22646_/Q clkload19/A _22646_/D fanout2862/X VPWR VGND sg13g2_dfrbpq_1
XFILLER_70_1605 VPWR VGND sg13g2_decap_8
XFILLER_40_145 VPWR VGND sg13g2_decap_8
XFILLER_15_98 VPWR VGND sg13g2_decap_8
XFILLER_70_1627 VPWR VGND sg13g2_decap_8
X_22577_ _22577_/Q clkload11/A _22577_/D fanout2837/X VPWR VGND sg13g2_dfrbpq_1
XFILLER_51_1048 VPWR VGND sg13g2_decap_8
XFILLER_21_381 VPWR VGND sg13g2_fill_2
XFILLER_103_1127 VPWR VGND sg13g2_decap_8
X_12330_ _12353_/A _19928_/A _12426_/B VPWR VGND sg13g2_xnor2_1
XFILLER_33_1460 VPWR VGND sg13g2_decap_8
X_21528_ _21528_/Y _21528_/A _21539_/B VPWR VGND sg13g2_nand2_1
XFILLER_5_514 VPWR VGND sg13g2_fill_1
X_24247_ _24247_/X _24247_/A VPWR VGND sg13g2_buf_1
X_21459_ _21459_/Y _21459_/A _21467_/B VPWR VGND sg13g2_nand2_1
XFILLER_107_442 VPWR VGND sg13g2_decap_8
Xplace3190 _20500_/B _20504_/B VPWR VGND sg13g2_buf_1
X_14000_ _14000_/Y _13661_/Y _14014_/S VPWR VGND sg13g2_nand2b_1
X_11212_ _11212_/Y _11569_/A _14461_/A _14461_/B _14614_/B VPWR VGND sg13g2_nor4_1
X_12192_ _12195_/C _12475_/A _12192_/B VPWR VGND sg13g2_nor2_1
X_24178_ _24178_/Q _24212_/CLK _24178_/D fanout2622/X VPWR VGND sg13g2_dfrbpq_1
XFILLER_68_1578 VPWR VGND sg13g2_decap_8
XFILLER_68_1589 VPWR VGND sg13g2_fill_1
X_23129_ _23129_/Q clkload5/A _23129_/D fanout2835/X VPWR VGND sg13g2_dfrbpq_1
XFILLER_46_1821 VPWR VGND sg13g2_fill_2
XFILLER_85_1892 VPWR VGND sg13g2_decap_4
XFILLER_66_1280 VPWR VGND sg13g2_decap_8
X_15951_ _17209_/A _13864_/A _15407_/Y _15950_/X VPWR VGND sg13g2_o21ai_1
XFILLER_7_1336 VPWR VGND sg13g2_decap_4
XFILLER_27_1264 VPWR VGND sg13g2_fill_1
XFILLER_0_274 VPWR VGND sg13g2_decap_8
XFILLER_49_735 VPWR VGND sg13g2_decap_8
XFILLER_76_521 VPWR VGND sg13g2_decap_8
X_14902_ _14902_/Y _14953_/A _16262_/A _14901_/Y VPWR VGND sg13g2_o21ai_1
XFILLER_27_1297 VPWR VGND sg13g2_decap_4
X_18670_ _18684_/B _23012_/Q _23013_/Q _18670_/C VPWR VGND sg13g2_and3_1
X_15882_ _20265_/A _15882_/A _15882_/B _15882_/C _15882_/D VPWR VGND sg13g2_and4_1
XFILLER_64_705 VPWR VGND sg13g2_decap_4
XFILLER_110_1109 VPWR VGND sg13g2_fill_2
XFILLER_36_418 VPWR VGND sg13g2_decap_8
X_17621_ _17628_/A _23164_/Q _17621_/B VPWR VGND sg13g2_nand2_1
XFILLER_36_429 VPWR VGND sg13g2_fill_1
X_14833_ _14833_/Y _14788_/A _14756_/Y _14831_/Y _14832_/Y VPWR VGND sg13g2_a22oi_1
XFILLER_48_289 VPWR VGND sg13g2_decap_8
XFILLER_79_1641 VPWR VGND sg13g2_decap_4
XFILLER_16_120 VPWR VGND sg13g2_decap_8
X_17552_ _17557_/A _23157_/Q _17590_/B VPWR VGND sg13g2_nand2_1
X_14764_ _14765_/A _14782_/A _14786_/B VPWR VGND sg13g2_nor2_1
XFILLER_75_1505 VPWR VGND sg13g2_decap_4
X_11976_ _12104_/B _14143_/C _11938_/Y _11975_/Y VPWR VGND sg13g2_a21o_1
XFILLER_17_665 VPWR VGND sg13g2_fill_2
X_16503_ _22612_/D _16500_/Y _16508_/B _16502_/Y VPWR VGND sg13g2_o21ai_1
X_13715_ _13861_/C _13970_/A _13858_/B VPWR VGND sg13g2_nor2_1
XFILLER_72_771 VPWR VGND sg13g2_decap_4
X_17483_ _22858_/D _16136_/A _17503_/B _17482_/Y VPWR VGND sg13g2_o21ai_1
X_14695_ _14695_/Y _14653_/X _14714_/A2 _14694_/Y VPWR VGND sg13g2_o21ai_1
XFILLER_44_495 VPWR VGND sg13g2_decap_4
X_19222_ _23177_/D _24266_/A _23177_/Q _19232_/B VPWR VGND sg13g2_mux2_1
X_13646_ _13647_/B _13642_/X _13643_/X _13644_/X _13645_/X _13640_/S _13131_/A VPWR
+ VGND sg13g2_mux4_1
XFILLER_73_1240 VPWR VGND sg13g2_fill_1
XFILLER_32_679 VPWR VGND sg13g2_decap_8
XFILLER_105_1926 VPWR VGND sg13g2_decap_8
XFILLER_14_1809 VPWR VGND sg13g2_decap_8
X_19153_ _23126_/D _23126_/Q _14805_/Y _19159_/S VPWR VGND sg13g2_mux2_1
XFILLER_34_1235 VPWR VGND sg13g2_decap_8
X_16365_ _16365_/Y _16365_/A VPWR VGND sg13g2_inv_1
X_13577_ _13577_/X _24174_/Q _24206_/Q _23310_/Q _23342_/Q _13578_/S0 _13578_/S1 VPWR
+ VGND sg13g2_mux4_1
XFILLER_8_330 VPWR VGND sg13g2_decap_8
XFILLER_8_341 VPWR VGND sg13g2_fill_1
X_18104_ _22947_/D _17706_/A _18471_/S _18103_/Y VPWR VGND sg13g2_a21oi_1
X_15316_ _15322_/C _22752_/Q _15312_/Y _15561_/B _22842_/Q VPWR VGND sg13g2_a22oi_1
X_16296_ _22533_/D _16296_/A _16296_/B VPWR VGND sg13g2_xor2_1
X_19084_ _23078_/D _23078_/Q _19083_/X _19099_/S VPWR VGND sg13g2_mux2_1
XFILLER_8_363 VPWR VGND sg13g2_decap_8
X_15247_ _15247_/Y _15247_/A _15247_/B VPWR VGND sg13g2_nor2_1
XFILLER_8_396 VPWR VGND sg13g2_decap_4
X_18035_ _18264_/A _18358_/S _18022_/X _18025_/Y VPWR VGND sg13g2_a21o_1
X_12459_ _12460_/B _23840_/Q _23872_/Q _23936_/Q _23968_/Q _12459_/S0 _13242_/S1 VPWR
+ VGND sg13g2_mux4_1
XFILLER_86_1623 VPWR VGND sg13g2_decap_4
Xhold4809 _21640_/A _23834_/Q VPWR VGND sg13g2_dlygate4sd3_1
X_15178_ _15182_/A _15186_/A _15178_/B _15178_/C VPWR VGND sg13g2_nor3_1
XFILLER_67_1044 VPWR VGND sg13g2_decap_8
XFILLER_67_1055 VPWR VGND sg13g2_fill_1
XFILLER_67_1066 VPWR VGND sg13g2_decap_4
XFILLER_28_1028 VPWR VGND sg13g2_fill_1
X_14129_ _14129_/Y _14129_/A _14129_/B _14129_/C _14129_/D VPWR VGND sg13g2_nand4_1
X_19986_ _19988_/B _19986_/A _19986_/B VPWR VGND sg13g2_nand2_1
XFILLER_113_456 VPWR VGND sg13g2_decap_8
XFILLER_115_1009 VPWR VGND sg13g2_decap_8
XFILLER_101_607 VPWR VGND sg13g2_decap_8
XFILLER_64_1954 VPWR VGND sg13g2_fill_1
X_18937_ _18937_/Y _18959_/A _23083_/Q _18959_/C VPWR VGND sg13g2_nand3_1
XFILLER_80_1244 VPWR VGND sg13g2_decap_8
XFILLER_39_201 VPWR VGND sg13g2_fill_2
XFILLER_79_381 VPWR VGND sg13g2_decap_4
XFILLER_80_1277 VPWR VGND sg13g2_decap_8
X_18868_ _18870_/B _18866_/Y _18867_/Y _18868_/S VPWR VGND sg13g2_mux2_1
XFILLER_28_908 VPWR VGND sg13g2_decap_4
XFILLER_11_0 VPWR VGND sg13g2_decap_8
XFILLER_3_1701 VPWR VGND sg13g2_decap_8
XFILLER_27_407 VPWR VGND sg13g2_fill_1
XFILLER_95_885 VPWR VGND sg13g2_fill_2
XFILLER_67_576 VPWR VGND sg13g2_fill_1
X_17819_ _22908_/D _17825_/B _17817_/Y _17818_/Y VPWR VGND sg13g2_a21oi_1
XFILLER_114_1790 VPWR VGND sg13g2_decap_8
XFILLER_23_1684 VPWR VGND sg13g2_decap_8
X_18799_ _18801_/B _18797_/Y _18798_/Y _18824_/S VPWR VGND sg13g2_mux2_1
XFILLER_82_557 VPWR VGND sg13g2_decap_8
XFILLER_3_1778 VPWR VGND sg13g2_decap_8
X_20830_ _23463_/D _22296_/A1 _20841_/B _20829_/Y VPWR VGND sg13g2_o21ai_1
XFILLER_54_248 VPWR VGND sg13g2_decap_4
XFILLER_63_760 VPWR VGND sg13g2_fill_2
XFILLER_51_911 VPWR VGND sg13g2_decap_4
XFILLER_78_1184 VPWR VGND sg13g2_decap_8
XFILLER_74_1015 VPWR VGND sg13g2_fill_2
X_20761_ _23430_/D _21331_/A1 _20772_/B _20760_/Y VPWR VGND sg13g2_o21ai_1
XFILLER_74_1048 VPWR VGND sg13g2_decap_8
X_22500_ _22500_/Q clkload8/A _22500_/D fanout2806/X VPWR VGND sg13g2_dfrbpq_1
XFILLER_52_19 VPWR VGND sg13g2_fill_2
XFILLER_62_292 VPWR VGND sg13g2_decap_8
X_23480_ _23480_/Q clkload53/A _23480_/D fanout2782/X VPWR VGND sg13g2_dfrbpq_1
XFILLER_51_977 VPWR VGND sg13g2_decap_8
X_20692_ _20692_/Y _20692_/A _20704_/B VPWR VGND sg13g2_nand2_1
XFILLER_51_988 VPWR VGND sg13g2_fill_1
XFILLER_56_1471 VPWR VGND sg13g2_fill_2
XFILLER_108_1583 VPWR VGND sg13g2_decap_4
XFILLER_104_1447 VPWR VGND sg13g2_decap_8
XFILLER_17_1499 VPWR VGND sg13g2_decap_8
X_22362_ _24167_/D _22429_/A1 _22374_/B _22361_/Y VPWR VGND sg13g2_o21ai_1
XFILLER_34_1780 VPWR VGND sg13g2_fill_2
XFILLER_108_217 VPWR VGND sg13g2_decap_8
X_24101_ _24101_/Q clkload41/A _24101_/D fanout2714/X VPWR VGND sg13g2_dfrbpq_1
X_21313_ _21313_/Y _21313_/A _21313_/B VPWR VGND sg13g2_nand2_1
XFILLER_11_1043 VPWR VGND sg13g2_decap_8
X_22293_ _22293_/Y _22293_/A _22300_/B VPWR VGND sg13g2_nand2_1
XFILLER_85_1100 VPWR VGND sg13g2_decap_4
XFILLER_11_1054 VPWR VGND sg13g2_fill_2
X_24032_ _24032_/Q _24131_/CLK _24032_/D fanout2750/X VPWR VGND sg13g2_dfrbpq_1
XFILLER_85_1144 VPWR VGND sg13g2_fill_2
XFILLER_104_423 VPWR VGND sg13g2_fill_1
XFILLER_11_1098 VPWR VGND sg13g2_fill_1
XFILLER_2_539 VPWR VGND sg13g2_fill_1
XFILLER_46_1117 VPWR VGND sg13g2_decap_4
X_21175_ _21175_/Y _21175_/A _21175_/B VPWR VGND sg13g2_nand2_1
XFILLER_105_979 VPWR VGND sg13g2_decap_4
XFILLER_85_1199 VPWR VGND sg13g2_fill_1
XFILLER_8_1612 VPWR VGND sg13g2_decap_8
XFILLER_89_167 VPWR VGND sg13g2_fill_2
XFILLER_28_1562 VPWR VGND sg13g2_fill_2
XFILLER_24_1426 VPWR VGND sg13g2_fill_2
X_20057_ _20069_/B _20294_/A _20138_/B VPWR VGND sg13g2_or2_1
XFILLER_86_863 VPWR VGND sg13g2_decap_8
XFILLER_100_673 VPWR VGND sg13g2_fill_1
XFILLER_39_790 VPWR VGND sg13g2_fill_1
XFILLER_45_226 VPWR VGND sg13g2_decap_4
X_23816_ _23816_/Q clkload31/A _23816_/D fanout2653/X VPWR VGND sg13g2_dfrbpq_1
X_11830_ _11830_/Y _11836_/B _23289_/Q _11829_/Y VPWR VGND sg13g2_o21ai_1
XFILLER_76_1825 VPWR VGND sg13g2_decap_8
XFILLER_27_996 VPWR VGND sg13g2_decap_4
X_11761_ _11761_/Y _13675_/B2 _11756_/Y _11758_/Y _13165_/A1 _11760_/Y VPWR VGND sg13g2_a221oi_1
X_23747_ _23747_/Q clkload39/A _23747_/D fanout2735/X VPWR VGND sg13g2_dfrbpq_1
XFILLER_60_229 VPWR VGND sg13g2_fill_2
XFILLER_26_86 VPWR VGND sg13g2_fill_1
X_20959_ _23524_/D _21327_/A1 _20971_/B _20958_/Y VPWR VGND sg13g2_o21ai_1
XFILLER_76_1869 VPWR VGND sg13g2_decap_8
XFILLER_14_635 VPWR VGND sg13g2_decap_4
X_13500_ _13523_/B _13528_/C VPWR VGND sg13g2_inv_1
X_14480_ _14481_/D _22604_/Q _23015_/Q VPWR VGND sg13g2_xor2_1
XFILLER_109_1358 VPWR VGND sg13g2_fill_1
X_11692_ _11701_/B _13208_/A _11692_/B VPWR VGND sg13g2_nor2_1
X_23678_ _23678_/Q clkload55/A _23678_/D fanout2777/X VPWR VGND sg13g2_dfrbpq_1
XFILLER_41_454 VPWR VGND sg13g2_decap_4
XFILLER_39_1691 VPWR VGND sg13g2_decap_8
XFILLER_70_1402 VPWR VGND sg13g2_decap_8
X_13431_ _13433_/B _13989_/A1 _13428_/X _13430_/Y VPWR VGND sg13g2_a21o_1
X_22629_ _22629_/Q clkload23/A _22629_/D fanout2887/X VPWR VGND sg13g2_dfrbpq_1
XFILLER_22_690 VPWR VGND sg13g2_decap_4
X_16150_ _16150_/Y _16150_/A _16187_/B VPWR VGND sg13g2_nor2_1
XFILLER_10_841 VPWR VGND sg13g2_decap_8
XFILLER_35_1599 VPWR VGND sg13g2_decap_4
X_13362_ _13370_/B _20193_/B _13362_/B VPWR VGND sg13g2_nand2b_1
XFILLER_6_812 VPWR VGND sg13g2_decap_8
X_15101_ _15101_/X _23153_/Q _16326_/B _15120_/S VPWR VGND sg13g2_mux2_1
XFILLER_87_1910 VPWR VGND sg13g2_decap_4
X_12313_ _12313_/X _23454_/Q _23518_/Q _23614_/Q _23678_/Q _12216_/S _11708_/B VPWR
+ VGND sg13g2_mux4_1
XFILLER_13_1864 VPWR VGND sg13g2_decap_8
X_13293_ _13293_/Y _13296_/A _14032_/A _20181_/A VPWR VGND sg13g2_nor3_1
X_15032_ _15032_/Y _15024_/Y _15070_/B _15030_/Y VPWR VGND sg13g2_o21ai_1
X_12244_ _12245_/B _23485_/Q _23517_/Q _12246_/S VPWR VGND sg13g2_mux2_1
XFILLER_48_1916 VPWR VGND sg13g2_decap_8
XFILLER_108_784 VPWR VGND sg13g2_fill_2
XFILLER_48_1927 VPWR VGND sg13g2_fill_1
XFILLER_83_1829 VPWR VGND sg13g2_fill_2
XFILLER_64_1206 VPWR VGND sg13g2_fill_1
X_19840_ _19840_/Y _12092_/A _19835_/Y _19837_/Y _12960_/Y _19839_/Y VPWR VGND sg13g2_a221oi_1
X_12175_ _12176_/B _12174_/X _12175_/B VPWR VGND sg13g2_nand2b_1
XFILLER_111_905 VPWR VGND sg13g2_decap_4
XFILLER_111_916 VPWR VGND sg13g2_fill_1
XFILLER_96_605 VPWR VGND sg13g2_decap_4
XFILLER_3_35 VPWR VGND sg13g2_decap_8
X_19771_ _19771_/Y _20229_/A _19777_/B VPWR VGND sg13g2_nor2_1
XFILLER_27_1050 VPWR VGND sg13g2_fill_2
X_16983_ _16983_/Y _22706_/Q _16983_/B VPWR VGND sg13g2_xnor2_1
XFILLER_81_1575 VPWR VGND sg13g2_decap_8
X_18722_ _23022_/D _18723_/A _18718_/Y _18720_/Y _18721_/Y VPWR VGND sg13g2_a22oi_1
XFILLER_7_1155 VPWR VGND sg13g2_decap_8
X_15934_ _17202_/A _15934_/A VPWR VGND sg13g2_inv_1
XFILLER_77_896 VPWR VGND sg13g2_decap_8
XFILLER_97_1015 VPWR VGND sg13g2_decap_8
X_18653_ _18653_/Y _18689_/A _18652_/Y _23008_/Q VPWR VGND sg13g2_a21oi_1
XFILLER_37_738 VPWR VGND sg13g2_fill_2
XFILLER_76_373 VPWR VGND sg13g2_decap_8
XFILLER_20_1813 VPWR VGND sg13g2_decap_8
X_15865_ _15865_/Y _20245_/B _15930_/A _15865_/C VPWR VGND sg13g2_nor3_1
XFILLER_64_524 VPWR VGND sg13g2_decap_8
XFILLER_111_1941 VPWR VGND sg13g2_decap_8
XFILLER_18_930 VPWR VGND sg13g2_fill_2
XFILLER_36_226 VPWR VGND sg13g2_fill_2
XFILLER_64_535 VPWR VGND sg13g2_fill_1
XFILLER_18_941 VPWR VGND sg13g2_decap_8
XFILLER_0_1907 VPWR VGND sg13g2_decap_8
XFILLER_36_248 VPWR VGND sg13g2_fill_1
X_17604_ _17604_/Y _11270_/B _17687_/A _17603_/Y VPWR VGND sg13g2_o21ai_1
X_14816_ _14816_/Y _14872_/A _14814_/Y _14815_/Y VPWR VGND sg13g2_a21oi_1
XFILLER_92_877 VPWR VGND sg13g2_decap_8
XFILLER_79_1460 VPWR VGND sg13g2_fill_2
X_18584_ _18585_/D _18865_/B _18584_/B VPWR VGND sg13g2_and2_1
XFILLER_20_1868 VPWR VGND sg13g2_fill_2
X_15796_ _15796_/Y _15796_/A _15796_/B _15796_/C _15796_/D VPWR VGND sg13g2_nand4_1
XFILLER_45_782 VPWR VGND sg13g2_decap_8
X_14747_ _14747_/Y _15826_/B2 _22828_/Q _14206_/A _14746_/Y VPWR VGND sg13g2_a22oi_1
XFILLER_33_966 VPWR VGND sg13g2_fill_2
X_14678_ _14678_/Y _14295_/A _14714_/A2 _14677_/Y VPWR VGND sg13g2_a21oi_1
XFILLER_33_977 VPWR VGND sg13g2_fill_2
X_17466_ _22850_/D _17866_/A _17475_/B _17465_/Y VPWR VGND sg13g2_o21ai_1
XFILLER_60_774 VPWR VGND sg13g2_fill_2
XFILLER_18_1742 VPWR VGND sg13g2_decap_8
X_16417_ _16417_/Y _22576_/Q _16417_/B VPWR VGND sg13g2_nand2_1
X_17397_ _17397_/Y _15133_/B _16029_/B _17929_/B2 _17382_/A _17395_/S VPWR VGND sg13g2_a221oi_1
XFILLER_105_1734 VPWR VGND sg13g2_decap_8
Xplace3904 _18363_/B _18451_/C VPWR VGND sg13g2_buf_1
XFILLER_18_1797 VPWR VGND sg13g2_decap_4
Xplace3915 _18425_/A _18517_/A VPWR VGND sg13g2_buf_1
X_16348_ _16349_/B _22684_/Q _15307_/B _16681_/B _22620_/Q VPWR VGND sg13g2_a22oi_1
XFILLER_34_1076 VPWR VGND sg13g2_decap_8
Xplace3926 _13165_/A1 _11384_/Y VPWR VGND sg13g2_buf_1
XFILLER_34_1087 VPWR VGND sg13g2_fill_1
Xplace3937 _13186_/B _11929_/B VPWR VGND sg13g2_buf_1
Xplace3948 _19996_/B2 _20130_/B VPWR VGND sg13g2_buf_1
XFILLER_9_683 VPWR VGND sg13g2_decap_8
XFILLER_9_694 VPWR VGND sg13g2_fill_2
Xplace3959 _17809_/A1 _17823_/A1 VPWR VGND sg13g2_buf_1
X_19067_ _23070_/D _23070_/Q _19066_/X _19078_/S VPWR VGND sg13g2_mux2_1
XFILLER_51_1390 VPWR VGND sg13g2_decap_8
XFILLER_8_193 VPWR VGND sg13g2_decap_8
XFILLER_59_0 VPWR VGND sg13g2_fill_1
XFILLER_114_732 VPWR VGND sg13g2_decap_8
Xhold4639 _18129_/A _22958_/Q VPWR VGND sg13g2_dlygate4sd3_1
XFILLER_82_1317 VPWR VGND sg13g2_fill_1
XFILLER_113_231 VPWR VGND sg13g2_decap_8
XFILLER_29_1860 VPWR VGND sg13g2_decap_8
XFILLER_25_1702 VPWR VGND sg13g2_fill_2
X_19969_ _19970_/A _20278_/A1 _23207_/Q _23215_/Q _20278_/A2 _19514_/A _19505_/A VPWR
+ VGND sg13g2_mux4_1
XFILLER_25_1713 VPWR VGND sg13g2_decap_4
X_22980_ _22980_/Q clkload16/A _22980_/D fanout2920/X VPWR VGND sg13g2_dfrbpq_2
XFILLER_67_340 VPWR VGND sg13g2_decap_8
XFILLER_25_1768 VPWR VGND sg13g2_decap_8
XFILLER_28_727 VPWR VGND sg13g2_fill_1
X_21931_ _21931_/Y _23961_/Q _21942_/B VPWR VGND sg13g2_nand2_1
XFILLER_103_14 VPWR VGND sg13g2_decap_8
XFILLER_94_170 VPWR VGND sg13g2_decap_8
XFILLER_82_343 VPWR VGND sg13g2_decap_4
X_21862_ _23927_/D _21928_/A1 _21899_/S _21861_/Y VPWR VGND sg13g2_o21ai_1
X_23601_ _23601_/Q _24113_/CLK _23601_/D fanout2683/X VPWR VGND sg13g2_dfrbpq_1
XFILLER_3_1597 VPWR VGND sg13g2_decap_8
XFILLER_110_1484 VPWR VGND sg13g2_fill_2
X_20813_ _23455_/D _21317_/A1 _20818_/B _20812_/Y VPWR VGND sg13g2_o21ai_1
XFILLER_36_782 VPWR VGND sg13g2_decap_8
XFILLER_70_527 VPWR VGND sg13g2_decap_4
X_21793_ _23894_/D _22260_/A1 _21804_/B _21792_/Y VPWR VGND sg13g2_o21ai_1
XFILLER_35_270 VPWR VGND sg13g2_decap_4
XFILLER_51_730 VPWR VGND sg13g2_decap_8
XFILLER_93_1457 VPWR VGND sg13g2_decap_8
X_23532_ _23532_/Q _24170_/CLK _23532_/D fanout2640/X VPWR VGND sg13g2_dfrbpq_1
XFILLER_51_752 VPWR VGND sg13g2_decap_8
XFILLER_54_1419 VPWR VGND sg13g2_fill_2
XFILLER_11_627 VPWR VGND sg13g2_decap_8
X_23463_ _23463_/Q _24170_/CLK _23463_/D fanout2697/X VPWR VGND sg13g2_dfrbpq_1
XFILLER_104_1200 VPWR VGND sg13g2_decap_8
XFILLER_32_1706 VPWR VGND sg13g2_decap_8
XFILLER_17_1274 VPWR VGND sg13g2_decap_8
X_22414_ _24192_/D _22414_/A1 _22417_/B _22413_/Y VPWR VGND sg13g2_o21ai_1
X_23394_ _23394_/Q _23682_/CLK _23394_/D fanout2728/X VPWR VGND sg13g2_dfrbpq_1
XFILLER_109_559 VPWR VGND sg13g2_decap_8
X_22345_ _24159_/D _22412_/A1 _22350_/B _22344_/Y VPWR VGND sg13g2_o21ai_1
Xoutput4470 data_addr_o[12] _24257_/X VPWR VGND sg13g2_buf_1
Xoutput4481 data_addr_o[23] _24268_/X VPWR VGND sg13g2_buf_1
XFILLER_12_88 VPWR VGND sg13g2_decap_8
Xoutput4492 data_addr_o[4] _24249_/X VPWR VGND sg13g2_buf_1
X_22276_ _22276_/Y _24126_/Q _22276_/B VPWR VGND sg13g2_nand2_1
XFILLER_105_732 VPWR VGND sg13g2_fill_2
X_24015_ _24015_/Q clkload47/A _24015_/D fanout2661/X VPWR VGND sg13g2_dfrbpq_1
XFILLER_78_605 VPWR VGND sg13g2_decap_4
XFILLER_65_1559 VPWR VGND sg13g2_decap_8
XFILLER_104_264 VPWR VGND sg13g2_fill_2
XFILLER_43_1824 VPWR VGND sg13g2_decap_4
XFILLER_8_1453 VPWR VGND sg13g2_fill_1
XFILLER_59_852 VPWR VGND sg13g2_fill_2
X_13980_ _13980_/X _23604_/Q _23636_/Q _23668_/Q _23700_/Q _13983_/S0 _11390_/A VPWR
+ VGND sg13g2_mux4_1
XFILLER_4_1306 VPWR VGND sg13g2_decap_8
X_21089_ _21138_/B _22363_/B _21201_/B VPWR VGND sg13g2_or2_1
XFILLER_74_800 VPWR VGND sg13g2_decap_8
Xclkbuf_leaf_42_clk_i clkload56/A clkbuf_leaf_42_clk_i/A VPWR VGND sg13g2_buf_16
X_12931_ _15669_/A _13989_/A1 _12822_/X _12824_/Y VPWR VGND sg13g2_a21o_1
XFILLER_19_738 VPWR VGND sg13g2_decap_8
XFILLER_46_524 VPWR VGND sg13g2_fill_2
XFILLER_46_568 VPWR VGND sg13g2_decap_4
X_15650_ _15651_/B _20063_/A _15996_/A _15650_/C VPWR VGND sg13g2_nand3_1
X_11813_ _11813_/X _23545_/Q _23993_/Q _13398_/S VPWR VGND sg13g2_mux2_1
X_14601_ _14602_/D _24217_/Q _14601_/B VPWR VGND sg13g2_nand2_1
X_15581_ _15584_/B _15580_/Y _16681_/C VPWR VGND sg13g2_nand2b_1
XFILLER_27_782 VPWR VGND sg13g2_fill_1
X_12793_ _12793_/X _23428_/Q _23492_/Q _23588_/Q _23652_/Q _13260_/A1 _12498_/S VPWR
+ VGND sg13g2_mux4_1
Xclkbuf_leaf_57_clk_i clkload34/A clkbuf_4_8__f_clk_i/X VPWR VGND sg13g2_buf_16
XFILLER_42_730 VPWR VGND sg13g2_fill_2
XFILLER_57_1043 VPWR VGND sg13g2_decap_8
X_17320_ _22788_/D _16067_/A _17324_/B _17319_/Y VPWR VGND sg13g2_o21ai_1
X_14532_ _14532_/Y _14575_/A _14575_/B _14532_/C VPWR VGND sg13g2_nand3_1
X_11744_ _11744_/Y _23512_/Q _11749_/S VPWR VGND sg13g2_nand2b_1
XFILLER_57_1076 VPWR VGND sg13g2_decap_8
XFILLER_53_73 VPWR VGND sg13g2_decap_8
XFILLER_53_84 VPWR VGND sg13g2_fill_2
X_17251_ _22756_/D _16067_/A _17262_/B _17250_/Y VPWR VGND sg13g2_o21ai_1
X_14463_ _14463_/Y _19235_/C _14463_/B VPWR VGND sg13g2_nor2_1
X_11675_ _11675_/Y _14026_/A _11662_/B _11983_/A VPWR VGND sg13g2_o21ai_1
XFILLER_41_284 VPWR VGND sg13g2_fill_1
XFILLER_74_1390 VPWR VGND sg13g2_decap_8
X_13414_ _13414_/X _13579_/A _13414_/B VPWR VGND sg13g2_or2_1
XFILLER_70_1254 VPWR VGND sg13g2_fill_2
XFILLER_15_1948 VPWR VGND sg13g2_decap_8
X_17182_ _17182_/Y _17182_/A _17182_/B VPWR VGND sg13g2_nor2_1
X_14394_ _14394_/Y _15268_/B _17391_/A VPWR VGND sg13g2_nand2b_1
X_16133_ _22499_/D _16199_/B _16131_/Y _16132_/Y VPWR VGND sg13g2_o21ai_1
X_13345_ _13345_/Y _13345_/A VPWR VGND sg13g2_inv_1
XFILLER_13_1661 VPWR VGND sg13g2_decap_8
X_16064_ _16064_/Y _22487_/Q _16071_/B _16063_/Y VPWR VGND sg13g2_a21oi_1
X_13276_ _13276_/Y _13276_/A VPWR VGND sg13g2_inv_1
XFILLER_52_7 VPWR VGND sg13g2_fill_2
XFILLER_5_174 VPWR VGND sg13g2_decap_8
X_15015_ _15016_/B _22472_/Q _15114_/A2 _14826_/X VPWR VGND sg13g2_a21oi_1
X_12227_ _12232_/B _12247_/A _12227_/B VPWR VGND sg13g2_nor2_1
XFILLER_48_1746 VPWR VGND sg13g2_fill_2
XFILLER_68_1183 VPWR VGND sg13g2_decap_8
XFILLER_68_1194 VPWR VGND sg13g2_fill_1
XFILLER_111_702 VPWR VGND sg13g2_decap_8
X_19823_ _19823_/Y _19757_/A _19635_/Y _19822_/X VPWR VGND sg13g2_a21oi_1
Xfanout2840 fanout2840/X fanout2845/X VPWR VGND sg13g2_buf_1
XFILLER_78_81 VPWR VGND sg13g2_fill_1
Xfanout2851 fanout2851/X fanout2854/X VPWR VGND sg13g2_buf_1
XFILLER_29_1189 VPWR VGND sg13g2_decap_8
Xfanout2862 fanout2862/X fanout2865/X VPWR VGND sg13g2_buf_1
XFILLER_81_1350 VPWR VGND sg13g2_fill_1
XFILLER_68_137 VPWR VGND sg13g2_decap_4
Xfanout2873 fanout2873/X fanout2878/X VPWR VGND sg13g2_buf_1
Xfanout2884 fanout2884/X fanout2886/X VPWR VGND sg13g2_buf_1
X_19754_ _23224_/D _20190_/S _22396_/A1 _19753_/Y VPWR VGND sg13g2_o21ai_1
XFILLER_111_779 VPWR VGND sg13g2_decap_8
X_12089_ _12090_/B _19803_/A _14304_/C _11998_/A _12965_/B _12959_/A VPWR VGND sg13g2_a221oi_1
Xfanout2895 fanout2895/X fanout2896/X VPWR VGND sg13g2_buf_1
X_16966_ _16967_/B _17004_/B _16966_/B VPWR VGND sg13g2_nor2_1
XFILLER_77_671 VPWR VGND sg13g2_decap_8
XFILLER_110_278 VPWR VGND sg13g2_fill_2
X_18705_ _18705_/Y _18713_/A _18704_/Y _23019_/Q VPWR VGND sg13g2_a21oi_1
XFILLER_42_1356 VPWR VGND sg13g2_fill_2
X_15917_ _15921_/A _22509_/Q _15767_/B _15359_/Y _22832_/Q VPWR VGND sg13g2_a22oi_1
XFILLER_42_1367 VPWR VGND sg13g2_fill_2
X_19685_ _19685_/Y _19682_/Y _19684_/Y _19501_/A VPWR VGND sg13g2_o21ai_1
XFILLER_42_1378 VPWR VGND sg13g2_decap_8
X_16897_ _16902_/B _16907_/C _16907_/D VPWR VGND sg13g2_and2_1
XFILLER_20_1610 VPWR VGND sg13g2_fill_1
XFILLER_49_395 VPWR VGND sg13g2_decap_8
XFILLER_4_1851 VPWR VGND sg13g2_decap_8
XFILLER_65_855 VPWR VGND sg13g2_decap_4
X_18636_ _18642_/B _18636_/A _18636_/B VPWR VGND sg13g2_or2_1
XFILLER_111_1760 VPWR VGND sg13g2_decap_8
XFILLER_94_91 VPWR VGND sg13g2_decap_8
XFILLER_80_803 VPWR VGND sg13g2_fill_2
X_15848_ _22474_/D _15936_/S _15843_/Y _15847_/Y VPWR VGND sg13g2_a21oi_1
XFILLER_94_1711 VPWR VGND sg13g2_decap_8
XFILLER_80_814 VPWR VGND sg13g2_decap_4
XFILLER_98_1891 VPWR VGND sg13g2_fill_2
XFILLER_80_836 VPWR VGND sg13g2_decap_8
XFILLER_94_1733 VPWR VGND sg13g2_fill_2
XFILLER_94_1744 VPWR VGND sg13g2_fill_1
X_18567_ _18766_/A _24232_/Q _18567_/B VPWR VGND sg13g2_nand2b_1
XFILLER_20_1698 VPWR VGND sg13g2_decap_8
X_15779_ _15779_/Y _23018_/Q VPWR VGND sg13g2_inv_1
X_17518_ _17518_/X _17518_/A _17518_/B VPWR VGND sg13g2_and2_1
X_18498_ _18498_/X _18498_/A _18498_/B _18498_/C VPWR VGND sg13g2_or3_1
XFILLER_32_262 VPWR VGND sg13g2_decap_8
X_17449_ _17449_/Y _17449_/A _17475_/B VPWR VGND sg13g2_nand2_1
XFILLER_21_958 VPWR VGND sg13g2_decap_8
Xrebuffer5414 _12002_/B rebuffer5424/X VPWR VGND sg13g2_buf_1
XFILLER_18_1583 VPWR VGND sg13g2_fill_2
Xplace3701 _19728_/A _19437_/A VPWR VGND sg13g2_buf_1
Xrebuffer5425 rebuffer5425/X _15030_/Y VPWR VGND sg13g2_buf_1
X_20460_ _20460_/Y _23292_/Q _20464_/B VPWR VGND sg13g2_nand2_1
Xplace3712 _20132_/A place3712/A VPWR VGND sg13g2_buf_1
Xrebuffer5436 _11418_/B _22983_/Q VPWR VGND sg13g2_buf_1
Xplace3723 _14304_/C _12104_/B VPWR VGND sg13g2_buf_1
XFILLER_105_1564 VPWR VGND sg13g2_fill_2
XFILLER_53_1496 VPWR VGND sg13g2_decap_8
Xplace3734 _20233_/A2 _20304_/B VPWR VGND sg13g2_buf_1
XFILLER_9_480 VPWR VGND sg13g2_decap_4
Xrebuffer5458 _13951_/A place3556/A VPWR VGND sg13g2_buf_1
Xplace3745 _19576_/B _19460_/B VPWR VGND sg13g2_buf_1
Xrebuffer5469 _12516_/C _12535_/D VPWR VGND sg13g2_buf_1
X_19119_ _23097_/D _23097_/Q _19119_/A1 _19124_/S VPWR VGND sg13g2_mux2_1
Xplace3756 _17390_/A _15165_/C VPWR VGND sg13g2_buf_1
X_20391_ _23260_/D _22405_/A1 _20395_/B _20390_/Y VPWR VGND sg13g2_o21ai_1
Xhold5104 _20596_/A _23353_/Q VPWR VGND sg13g2_dlygate4sd3_1
Xplace3767 _13861_/A _11646_/X VPWR VGND sg13g2_buf_2
Xplace3778 _14104_/A _11983_/A VPWR VGND sg13g2_buf_1
Xplace3789 _19582_/A _14034_/B VPWR VGND sg13g2_buf_1
Xhold5115 _20882_/A _23487_/Q VPWR VGND sg13g2_dlygate4sd3_1
X_22130_ _24056_/D _22264_/A1 _22129_/B _22129_/Y VPWR VGND sg13g2_o21ai_1
Xhold5126 _20879_/A _23486_/Q VPWR VGND sg13g2_dlygate4sd3_1
Xhold5137 _22324_/A _24150_/Q VPWR VGND sg13g2_dlygate4sd3_1
XFILLER_12_1171 VPWR VGND sg13g2_decap_8
Xhold5148 _20000_/A _23232_/Q VPWR VGND sg13g2_dlygate4sd3_1
Xhold5159 _20598_/A _23354_/Q VPWR VGND sg13g2_dlygate4sd3_1
XFILLER_66_1813 VPWR VGND sg13g2_fill_2
X_22061_ _24023_/D _22262_/A1 _22069_/B _22060_/Y VPWR VGND sg13g2_o21ai_1
XFILLER_47_1223 VPWR VGND sg13g2_fill_1
XFILLER_47_1234 VPWR VGND sg13g2_fill_2
XFILLER_102_702 VPWR VGND sg13g2_decap_4
XFILLER_59_104 VPWR VGND sg13g2_fill_2
XFILLER_87_435 VPWR VGND sg13g2_decap_8
XFILLER_87_446 VPWR VGND sg13g2_decap_8
XFILLER_9_1773 VPWR VGND sg13g2_decap_8
XFILLER_60_1423 VPWR VGND sg13g2_decap_4
XFILLER_75_608 VPWR VGND sg13g2_fill_1
XFILLER_87_479 VPWR VGND sg13g2_decap_8
XFILLER_114_35 VPWR VGND sg13g2_decap_8
XFILLER_101_289 VPWR VGND sg13g2_decap_8
XFILLER_96_991 VPWR VGND sg13g2_decap_4
XFILLER_5_1648 VPWR VGND sg13g2_fill_1
X_22963_ _22963_/Q _23187_/CLK _22963_/D fanout2918/X VPWR VGND sg13g2_dfrbpq_1
XFILLER_28_546 VPWR VGND sg13g2_decap_8
XFILLER_55_321 VPWR VGND sg13g2_decap_8
X_21914_ _23954_/D _22314_/A1 _21916_/B _21913_/Y VPWR VGND sg13g2_o21ai_1
XFILLER_56_877 VPWR VGND sg13g2_decap_8
XFILLER_28_579 VPWR VGND sg13g2_decap_8
X_22894_ _22894_/Q clkload10/A _22894_/D fanout2816/X VPWR VGND sg13g2_dfrbpq_1
XFILLER_71_814 VPWR VGND sg13g2_decap_8
X_21845_ _23921_/D _20312_/Y _23921_/Q _21848_/B VPWR VGND sg13g2_mux2_1
XFILLER_77_1953 VPWR VGND sg13g2_fill_2
XFILLER_70_324 VPWR VGND sg13g2_decap_8
XFILLER_110_1281 VPWR VGND sg13g2_decap_8
XFILLER_38_1915 VPWR VGND sg13g2_decap_8
XFILLER_82_195 VPWR VGND sg13g2_fill_2
XFILLER_36_590 VPWR VGND sg13g2_fill_1
XFILLER_73_1817 VPWR VGND sg13g2_decap_8
XFILLER_54_1205 VPWR VGND sg13g2_fill_1
XFILLER_73_1828 VPWR VGND sg13g2_fill_1
Xinput4357 _17882_/A1 boot_addr_i[15] VPWR VGND sg13g2_buf_1
X_21776_ _23888_/D _21977_/A1 _21783_/B _21775_/Y VPWR VGND sg13g2_o21ai_1
XFILLER_70_379 VPWR VGND sg13g2_decap_8
Xinput4368 _17914_/A1 boot_addr_i[26] VPWR VGND sg13g2_buf_1
XFILLER_90_49 VPWR VGND sg13g2_fill_1
Xinput4379 _20278_/A1 data_rdata_i[10] VPWR VGND sg13g2_buf_1
X_23515_ _23515_/Q clkload59/A _23515_/D fanout2787/X VPWR VGND sg13g2_dfrbpq_1
XFILLER_51_582 VPWR VGND sg13g2_fill_2
X_20727_ _20727_/Y _23415_/Q _20727_/B VPWR VGND sg13g2_nand2_1
XFILLER_11_435 VPWR VGND sg13g2_fill_1
XFILLER_8_929 VPWR VGND sg13g2_fill_1
X_23446_ _23446_/Q clkload54/A _23446_/D fanout2772/X VPWR VGND sg13g2_dfrbpq_1
X_11460_ _11460_/Y _12674_/C _11455_/Y _11459_/Y VPWR VGND sg13g2_o21ai_1
XFILLER_7_417 VPWR VGND sg13g2_fill_2
X_20658_ _20658_/Y _23383_/Q _20712_/S VPWR VGND sg13g2_nand2_1
XFILLER_11_479 VPWR VGND sg13g2_decap_8
XFILLER_99_14 VPWR VGND sg13g2_decap_8
X_23377_ _23377_/Q clkload47/A _23377_/D fanout2681/X VPWR VGND sg13g2_dfrbpq_1
X_11391_ _11391_/Y _13774_/A _11388_/Y _11390_/X VPWR VGND sg13g2_a21oi_1
X_20589_ _23349_/D _20927_/A1 _20646_/S _20588_/Y VPWR VGND sg13g2_o21ai_1
XFILLER_104_1096 VPWR VGND sg13g2_decap_8
XFILLER_10_1823 VPWR VGND sg13g2_decap_8
X_13130_ _13131_/C _24040_/Q _24072_/Q _24104_/Q _24136_/Q _13133_/A _13466_/A VPWR
+ VGND sg13g2_mux4_1
X_22328_ _22328_/Y _24152_/Q _22328_/B VPWR VGND sg13g2_nand2_1
XFILLER_87_1058 VPWR VGND sg13g2_decap_4
XFILLER_30_1271 VPWR VGND sg13g2_decap_8
X_13061_ _13072_/B _20132_/A _13070_/B VPWR VGND sg13g2_nand2_1
X_22259_ _22259_/Y _22259_/A _22263_/B VPWR VGND sg13g2_nand2_1
XFILLER_105_551 VPWR VGND sg13g2_decap_8
XFILLER_2_144 VPWR VGND sg13g2_fill_1
XFILLER_45_1908 VPWR VGND sg13g2_decap_8
X_12012_ _12017_/B _13210_/A _12012_/B VPWR VGND sg13g2_nor2_1
XFILLER_26_1307 VPWR VGND sg13g2_fill_2
Xhold4970 _21771_/A _23886_/Q VPWR VGND sg13g2_dlygate4sd3_1
XFILLER_26_1318 VPWR VGND sg13g2_fill_2
Xhold4981 _21000_/A _23542_/Q VPWR VGND sg13g2_dlygate4sd3_1
XFILLER_78_435 VPWR VGND sg13g2_decap_8
XFILLER_26_1329 VPWR VGND sg13g2_decap_8
XFILLER_61_1209 VPWR VGND sg13g2_decap_8
Xhold4992 _20987_/A _23538_/Q VPWR VGND sg13g2_dlygate4sd3_1
X_16820_ _16821_/B _22675_/Q _16828_/D VPWR VGND sg13g2_nand2_1
XFILLER_94_928 VPWR VGND sg13g2_decap_8
XFILLER_47_800 VPWR VGND sg13g2_decap_4
XFILLER_43_1665 VPWR VGND sg13g2_decap_8
XFILLER_65_118 VPWR VGND sg13g2_decap_8
X_16751_ _16751_/Y _16755_/A _16751_/B VPWR VGND sg13g2_nor2_1
XFILLER_19_524 VPWR VGND sg13g2_fill_1
XFILLER_4_1125 VPWR VGND sg13g2_fill_1
XFILLER_65_129 VPWR VGND sg13g2_fill_2
XFILLER_4_1136 VPWR VGND sg13g2_decap_8
XFILLER_46_310 VPWR VGND sg13g2_decap_8
X_13963_ _13963_/X _23860_/Q _23892_/Q _23956_/Q _23988_/Q _12577_/C _13964_/S1 VPWR
+ VGND sg13g2_mux4_1
XFILLER_86_490 VPWR VGND sg13g2_decap_8
XFILLER_0_14 VPWR VGND sg13g2_decap_8
XFILLER_4_1147 VPWR VGND sg13g2_fill_2
XFILLER_24_1075 VPWR VGND sg13g2_decap_8
XFILLER_47_844 VPWR VGND sg13g2_decap_8
XFILLER_74_630 VPWR VGND sg13g2_fill_2
X_15702_ _15704_/B _14218_/A _15804_/B1 _16004_/B1 _22822_/Q VPWR VGND sg13g2_a22oi_1
XFILLER_24_1097 VPWR VGND sg13g2_fill_1
X_19470_ _19471_/A _19400_/Y _20060_/A _19469_/Y VPWR VGND sg13g2_a21oi_1
XFILLER_78_1728 VPWR VGND sg13g2_decap_8
X_12914_ _12914_/X _24165_/Q _24197_/Q _23237_/Q _23269_/Q _12802_/B _12709_/A VPWR
+ VGND sg13g2_mux4_1
XFILLER_21_1952 VPWR VGND sg13g2_fill_2
XFILLER_47_877 VPWR VGND sg13g2_fill_1
X_16682_ _16683_/D _22584_/Q _22651_/Q VPWR VGND sg13g2_nand2b_1
X_13894_ _13894_/Y _23571_/Q VPWR VGND sg13g2_inv_1
XFILLER_46_365 VPWR VGND sg13g2_decap_8
XFILLER_62_814 VPWR VGND sg13g2_fill_1
X_18421_ _18426_/B _18421_/A _18421_/B VPWR VGND sg13g2_nand2_1
X_15633_ _16111_/A _23011_/Q _22561_/Q _15633_/S VPWR VGND sg13g2_mux2_1
X_12845_ _12845_/Y _20066_/A _12845_/B VPWR VGND sg13g2_nand2_1
XFILLER_61_335 VPWR VGND sg13g2_decap_4
XFILLER_15_741 VPWR VGND sg13g2_decap_8
X_18352_ _18352_/Y _18071_/A _18064_/C _18301_/B _18350_/Y _18544_/A VPWR VGND sg13g2_a221oi_1
XFILLER_37_1425 VPWR VGND sg13g2_fill_2
X_15564_ _15564_/Y _15563_/Y _16090_/S VPWR VGND sg13g2_nand2b_1
X_12776_ _12777_/C _24196_/Q _23268_/Q _23332_/Q _23396_/Q _13259_/B _13019_/A VPWR
+ VGND sg13g2_mux4_1
XFILLER_14_251 VPWR VGND sg13g2_decap_8
XFILLER_42_560 VPWR VGND sg13g2_decap_8
XFILLER_30_711 VPWR VGND sg13g2_fill_2
X_17303_ _17321_/B _17303_/A _17399_/A VPWR VGND sg13g2_nand2_1
X_11727_ _11727_/Y _23896_/Q _11276_/Y _11726_/X _13701_/S0 VPWR VGND sg13g2_a22oi_1
X_14515_ _14518_/B _22609_/Q _23020_/Q VPWR VGND sg13g2_xnor2_1
XFILLER_37_1469 VPWR VGND sg13g2_decap_4
XFILLER_72_1349 VPWR VGND sg13g2_fill_1
X_15495_ _17092_/A _17523_/A VPWR VGND sg13g2_inv_1
XFILLER_14_284 VPWR VGND sg13g2_decap_8
X_18283_ _18284_/B _18485_/A _18395_/A _18541_/A1 VPWR VGND sg13g2_a21oi_1
XFILLER_19_1870 VPWR VGND sg13g2_decap_8
XFILLER_30_744 VPWR VGND sg13g2_decap_4
XFILLER_9_78 VPWR VGND sg13g2_decap_8
X_17234_ _17246_/B _17234_/A _17399_/A VPWR VGND sg13g2_nand2_1
XFILLER_15_1734 VPWR VGND sg13g2_fill_1
Xplace3008 _22377_/B _22383_/B VPWR VGND sg13g2_buf_1
X_11658_ _11658_/Y _14028_/B _11656_/Y _11657_/X _19346_/A _14026_/A VPWR VGND sg13g2_a221oi_1
XFILLER_80_71 VPWR VGND sg13g2_decap_8
X_14446_ _14758_/C _17042_/B _14446_/B VPWR VGND sg13g2_and2_1
Xplace3019 _22203_/B _22249_/S VPWR VGND sg13g2_buf_1
XFILLER_15_1756 VPWR VGND sg13g2_decap_8
XFILLER_106_1895 VPWR VGND sg13g2_decap_8
X_14377_ _14378_/D _17034_/B _14377_/B _14377_/C _14377_/D VPWR VGND sg13g2_and4_1
X_17165_ _22736_/D _17209_/B _17163_/Y _17164_/Y VPWR VGND sg13g2_a21oi_1
X_11589_ _11589_/X _14083_/A _11589_/B VPWR VGND sg13g2_and2_1
XFILLER_6_461 VPWR VGND sg13g2_decap_8
X_16116_ _16116_/Y _22496_/Q _16203_/B _16115_/Y VPWR VGND sg13g2_a21oi_1
X_13328_ _20208_/A _13989_/A1 _13322_/Y _13327_/Y VPWR VGND sg13g2_a21o_2
XFILLER_115_315 VPWR VGND sg13g2_decap_8
XFILLER_7_995 VPWR VGND sg13g2_fill_1
X_17096_ _17097_/B _17122_/B _17110_/B VPWR VGND sg13g2_nor2_1
XFILLER_83_1412 VPWR VGND sg13g2_decap_4
X_13259_ _13259_/Y _23530_/Q _13259_/B VPWR VGND sg13g2_nand2b_1
X_16047_ _22483_/D _16060_/B _16044_/Y _16046_/Y VPWR VGND sg13g2_o21ai_1
XFILLER_100_1483 VPWR VGND sg13g2_fill_2
XFILLER_97_700 VPWR VGND sg13g2_decap_4
XFILLER_83_1445 VPWR VGND sg13g2_fill_1
XFILLER_48_1576 VPWR VGND sg13g2_decap_8
XFILLER_69_424 VPWR VGND sg13g2_decap_8
XFILLER_83_1478 VPWR VGND sg13g2_decap_4
X_19806_ _19806_/Y _15435_/Y _19806_/B VPWR VGND sg13g2_nand2b_1
XFILLER_26_1841 VPWR VGND sg13g2_decap_4
XFILLER_96_243 VPWR VGND sg13g2_decap_8
XFILLER_69_468 VPWR VGND sg13g2_decap_8
Xfanout2670 fanout2670/X fanout2673/X VPWR VGND sg13g2_buf_1
Xfanout2681 fanout2681/X fanout2692/X VPWR VGND sg13g2_buf_1
XFILLER_6_1924 VPWR VGND sg13g2_decap_8
Xfanout2692 fanout2692/X fanout2693/X VPWR VGND sg13g2_buf_1
X_17998_ _17999_/B _18155_/A _18498_/B VPWR VGND sg13g2_nand2_1
XFILLER_61_1743 VPWR VGND sg13g2_decap_4
XFILLER_113_1822 VPWR VGND sg13g2_decap_8
XFILLER_111_576 VPWR VGND sg13g2_decap_8
XFILLER_85_939 VPWR VGND sg13g2_decap_8
XFILLER_56_107 VPWR VGND sg13g2_decap_4
XFILLER_56_118 VPWR VGND sg13g2_decap_8
X_19737_ _19737_/Y _19737_/A VPWR VGND sg13g2_inv_1
X_16949_ _16949_/Y _17141_/A _17026_/B VPWR VGND sg13g2_nand2_1
X_19668_ _19668_/Y _19978_/B _19673_/B VPWR VGND sg13g2_nor2b_1
XFILLER_65_663 VPWR VGND sg13g2_fill_2
XFILLER_113_1899 VPWR VGND sg13g2_decap_8
XFILLER_96_1839 VPWR VGND sg13g2_fill_2
XFILLER_25_505 VPWR VGND sg13g2_fill_1
XFILLER_92_482 VPWR VGND sg13g2_decap_4
XFILLER_80_622 VPWR VGND sg13g2_decap_8
XFILLER_20_1462 VPWR VGND sg13g2_decap_8
X_18619_ _18619_/Y _18619_/A _18666_/A VPWR VGND sg13g2_nand2_1
XFILLER_65_696 VPWR VGND sg13g2_fill_1
XFILLER_94_1552 VPWR VGND sg13g2_decap_8
X_21630_ _23829_/D _22258_/A1 _21635_/B _21629_/Y VPWR VGND sg13g2_o21ai_1
XFILLER_80_666 VPWR VGND sg13g2_fill_2
XFILLER_80_688 VPWR VGND sg13g2_fill_1
XFILLER_40_519 VPWR VGND sg13g2_fill_2
XFILLER_107_1626 VPWR VGND sg13g2_decap_8
XFILLER_21_722 VPWR VGND sg13g2_decap_4
XFILLER_107_1637 VPWR VGND sg13g2_fill_1
XFILLER_21_744 VPWR VGND sg13g2_decap_8
XFILLER_21_755 VPWR VGND sg13g2_fill_2
XFILLER_33_1812 VPWR VGND sg13g2_decap_8
Xplace4210 _13551_/S0 _13275_/S0 VPWR VGND sg13g2_buf_4
X_23300_ _23300_/Q _24196_/CLK _23300_/D fanout2702/X VPWR VGND sg13g2_dfrbpq_1
Xplace4221 _11861_/A _11352_/A VPWR VGND sg13g2_buf_1
X_20512_ _20512_/Y _23316_/Q _20512_/B VPWR VGND sg13g2_nand2_1
Xplace4232 _13689_/S1 _13582_/A VPWR VGND sg13g2_buf_1
Xplace4243 _13765_/S1 _13911_/B2 VPWR VGND sg13g2_buf_1
Xrebuffer5222 _12096_/A _19801_/A VPWR VGND sg13g2_buf_1
XFILLER_18_1380 VPWR VGND sg13g2_fill_1
XFILLER_21_788 VPWR VGND sg13g2_fill_2
Xrebuffer5233 _14701_/A _11732_/B VPWR VGND sg13g2_buf_1
Xplace4254 _13243_/S1 _12816_/A VPWR VGND sg13g2_buf_1
Xplace3520 _15872_/B1 _16004_/B1 VPWR VGND sg13g2_buf_1
Xrebuffer5244 _11662_/B _11497_/Y VPWR VGND sg13g2_buf_8
Xplace4265 _13680_/S1 _13981_/S1 VPWR VGND sg13g2_buf_8
Xrebuffer5255 _12460_/A _12039_/Y VPWR VGND sg13g2_buf_2
XFILLER_20_287 VPWR VGND sg13g2_decap_8
X_23231_ _23231_/Q _23682_/CLK _23231_/D fanout2725/X VPWR VGND sg13g2_dfrbpq_1
Xplace3531 _15900_/A2 _15970_/A2 VPWR VGND sg13g2_buf_1
Xplace4276 _13974_/S _13591_/B VPWR VGND sg13g2_buf_4
Xplace3542 _15804_/B1 _15969_/B VPWR VGND sg13g2_buf_1
XFILLER_14_1255 VPWR VGND sg13g2_decap_8
Xrebuffer5266 _14713_/A _13906_/A2 VPWR VGND sg13g2_buf_1
Xplace4287 _13173_/S _13621_/S VPWR VGND sg13g2_buf_2
XFILLER_107_805 VPWR VGND sg13g2_decap_4
Xplace4298 _12809_/A _12802_/B VPWR VGND sg13g2_buf_2
Xplace3553 _15552_/B _15289_/X VPWR VGND sg13g2_buf_1
Xrebuffer5277 place3946/A _11227_/Y VPWR VGND sg13g2_buf_2
XFILLER_109_35 VPWR VGND sg13g2_decap_8
Xrebuffer5288 _12428_/A_N _12340_/C VPWR VGND sg13g2_buf_1
XFILLER_10_1119 VPWR VGND sg13g2_decap_4
Xplace3564 _14728_/S _19611_/A VPWR VGND sg13g2_buf_1
Xplace3575 _19663_/A _19764_/A VPWR VGND sg13g2_buf_1
Xrebuffer5299 _14011_/A _14427_/A VPWR VGND sg13g2_buf_1
Xplace3586 _19932_/A _19874_/B VPWR VGND sg13g2_buf_1
X_23162_ _23162_/Q clkload15/A _23162_/D fanout2859/X VPWR VGND sg13g2_dfrbpq_1
XFILLER_101_1258 VPWR VGND sg13g2_decap_8
Xplace3597 _17926_/A2 _17855_/A VPWR VGND sg13g2_buf_1
Xrebuffer4576 _12838_/B _12725_/Y VPWR VGND sg13g2_buf_2
XFILLER_49_1318 VPWR VGND sg13g2_fill_1
Xrebuffer4587 _14670_/A _13278_/Y VPWR VGND sg13g2_buf_1
XFILLER_106_337 VPWR VGND sg13g2_decap_8
XFILLER_66_1610 VPWR VGND sg13g2_decap_4
X_22113_ _24049_/D _24049_/Q _22446_/A1 _22116_/S VPWR VGND sg13g2_mux2_1
Xrebuffer4598 _12623_/B _12536_/Y VPWR VGND sg13g2_buf_2
X_23093_ _23093_/Q _23215_/CLK _23093_/D fanout2924/X VPWR VGND sg13g2_dfrbpq_1
XFILLER_88_700 VPWR VGND sg13g2_decap_8
X_22044_ _24017_/D _20312_/Y _24017_/Q _22047_/S VPWR VGND sg13g2_mux2_1
XFILLER_47_1053 VPWR VGND sg13g2_fill_2
XFILLER_27_1638 VPWR VGND sg13g2_fill_2
XFILLER_62_1518 VPWR VGND sg13g2_fill_2
XFILLER_88_755 VPWR VGND sg13g2_fill_1
XFILLER_27_1649 VPWR VGND sg13g2_fill_1
XFILLER_114_1619 VPWR VGND sg13g2_fill_1
XFILLER_102_554 VPWR VGND sg13g2_decap_8
XFILLER_76_917 VPWR VGND sg13g2_decap_8
XFILLER_5_1401 VPWR VGND sg13g2_decap_4
XFILLER_9_1581 VPWR VGND sg13g2_decap_4
XFILLER_25_1340 VPWR VGND sg13g2_decap_8
XFILLER_5_1434 VPWR VGND sg13g2_fill_2
XFILLER_69_991 VPWR VGND sg13g2_fill_2
XFILLER_112_1321 VPWR VGND sg13g2_decap_8
XFILLER_18_21 VPWR VGND sg13g2_decap_8
XFILLER_25_1373 VPWR VGND sg13g2_decap_8
X_23995_ _23995_/Q clkload48/A _23995_/D fanout2755/X VPWR VGND sg13g2_dfrbpq_1
XFILLER_56_641 VPWR VGND sg13g2_decap_8
XFILLER_29_866 VPWR VGND sg13g2_fill_2
XFILLER_95_1305 VPWR VGND sg13g2_decap_8
X_22946_ _22946_/Q clkload17/A _22946_/D fanout2847/X VPWR VGND sg13g2_dfrbpq_1
XFILLER_90_419 VPWR VGND sg13g2_decap_8
XFILLER_55_140 VPWR VGND sg13g2_fill_1
XFILLER_99_1485 VPWR VGND sg13g2_decap_8
XFILLER_112_1398 VPWR VGND sg13g2_decap_8
XFILLER_95_1349 VPWR VGND sg13g2_fill_1
XFILLER_44_847 VPWR VGND sg13g2_decap_8
X_22877_ _22877_/Q clkload27/A _22877_/D fanout2897/X VPWR VGND sg13g2_dfrbpq_1
XFILLER_70_132 VPWR VGND sg13g2_decap_4
XFILLER_38_1723 VPWR VGND sg13g2_decap_4
X_12630_ _12630_/Y _12837_/A _19983_/A _12849_/B VPWR VGND sg13g2_nor3_1
X_21828_ _21828_/Y _23911_/Q _21843_/B VPWR VGND sg13g2_nand2_1
XFILLER_43_368 VPWR VGND sg13g2_decap_4
XFILLER_19_1122 VPWR VGND sg13g2_fill_1
XFILLER_43_379 VPWR VGND sg13g2_decap_8
XFILLER_19_1133 VPWR VGND sg13g2_decap_8
XFILLER_71_699 VPWR VGND sg13g2_decap_8
XFILLER_19_1144 VPWR VGND sg13g2_fill_2
XFILLER_12_722 VPWR VGND sg13g2_decap_8
XFILLER_52_891 VPWR VGND sg13g2_fill_1
X_12561_ _12582_/D _13028_/A _13028_/B _12561_/C VPWR VGND sg13g2_nor3_1
XFILLER_34_75 VPWR VGND sg13g2_fill_1
X_21759_ _23881_/D _23881_/Q _21965_/A0 _21781_/S VPWR VGND sg13g2_mux2_1
XFILLER_93_1095 VPWR VGND sg13g2_fill_1
XFILLER_11_210 VPWR VGND sg13g2_decap_8
XFILLER_51_1912 VPWR VGND sg13g2_decap_8
X_11512_ _11526_/A _13801_/A1 _11506_/X _11509_/X _11951_/A VPWR VGND sg13g2_a22oi_1
X_14300_ _14300_/Y _14286_/Y _14294_/Y _14359_/C VPWR VGND sg13g2_o21ai_1
X_15280_ _15280_/Y _22550_/Q _16023_/B VPWR VGND sg13g2_nand2_1
X_12492_ _12492_/Y _23904_/Q _12889_/C _12491_/X _11465_/A VPWR VGND sg13g2_a22oi_1
XFILLER_12_799 VPWR VGND sg13g2_decap_8
XFILLER_8_748 VPWR VGND sg13g2_decap_8
XFILLER_71_1382 VPWR VGND sg13g2_fill_2
XFILLER_12_1918 VPWR VGND sg13g2_decap_8
X_23429_ _23429_/Q _23682_/CLK _23429_/D fanout2719/X VPWR VGND sg13g2_dfrbpq_1
X_11443_ _11443_/Y _12414_/A _23157_/Q VPWR VGND sg13g2_nor2b_1
XFILLER_50_74 VPWR VGND sg13g2_fill_2
X_14162_ _24241_/D _19523_/B _14161_/Y VPWR VGND sg13g2_nor2b_1
XFILLER_109_175 VPWR VGND sg13g2_decap_8
X_11374_ _14028_/A _19361_/A _14019_/B VPWR VGND sg13g2_xnor2_1
XFILLER_67_1418 VPWR VGND sg13g2_fill_2
X_13113_ _13113_/X _23432_/Q _23464_/Q _23496_/Q _23528_/Q _13614_/S0 _13614_/S1 VPWR
+ VGND sg13g2_mux4_1
X_18970_ _18970_/Y _19003_/A _23086_/Q _19047_/C VPWR VGND sg13g2_nand3_1
XFILLER_3_442 VPWR VGND sg13g2_decap_8
X_14093_ _14094_/C _19494_/B _14093_/B VPWR VGND sg13g2_nor2_1
XFILLER_65_1120 VPWR VGND sg13g2_fill_2
XFILLER_65_1131 VPWR VGND sg13g2_decap_8
XFILLER_3_475 VPWR VGND sg13g2_decap_8
X_17921_ _17922_/B _22938_/Q _17930_/B VPWR VGND sg13g2_nand2_1
X_13044_ _13044_/X _23303_/Q _23335_/Q _23367_/Q _23399_/Q _13236_/S0 _13236_/S1 VPWR
+ VGND sg13g2_mux4_1
XFILLER_65_1142 VPWR VGND sg13g2_fill_2
XFILLER_59_61 VPWR VGND sg13g2_decap_8
XFILLER_84_1798 VPWR VGND sg13g2_fill_2
XFILLER_26_1126 VPWR VGND sg13g2_fill_1
XFILLER_65_1175 VPWR VGND sg13g2_decap_8
XFILLER_94_703 VPWR VGND sg13g2_decap_8
X_17852_ _22916_/D _16067_/A _17869_/B _17851_/Y VPWR VGND sg13g2_o21ai_1
XFILLER_43_1440 VPWR VGND sg13g2_decap_4
XFILLER_78_276 VPWR VGND sg13g2_fill_1
X_16803_ _16804_/B _22672_/Q _16803_/B VPWR VGND sg13g2_xor2_1
XFILLER_94_758 VPWR VGND sg13g2_decap_8
XFILLER_15_7 VPWR VGND sg13g2_fill_2
X_17783_ _22903_/D _17811_/B _17781_/Y _17782_/Y VPWR VGND sg13g2_a21oi_1
X_19522_ _19522_/Y _14068_/X _19320_/Y _19521_/Y VPWR VGND sg13g2_o21ai_1
X_16734_ _16735_/D _22657_/Q _22656_/Q _22655_/Q _16734_/D VPWR VGND sg13g2_nand4_1
X_13946_ _13951_/C _13946_/A _13946_/B _13946_/C VPWR VGND sg13g2_nand3_1
XFILLER_75_71 VPWR VGND sg13g2_decap_8
XFILLER_75_983 VPWR VGND sg13g2_decap_4
XFILLER_1_1832 VPWR VGND sg13g2_decap_8
X_19453_ _19468_/B _19702_/A _19756_/B VPWR VGND sg13g2_nand2_1
XFILLER_78_1558 VPWR VGND sg13g2_decap_4
X_16665_ _16665_/Y _22648_/Q _16665_/B VPWR VGND sg13g2_xnor2_1
XFILLER_21_1793 VPWR VGND sg13g2_decap_8
X_13877_ _13877_/Y _13877_/A _13877_/B _13877_/C _13938_/B VPWR VGND sg13g2_nand4_1
XFILLER_90_975 VPWR VGND sg13g2_fill_2
X_18404_ _18427_/B _18451_/B _18404_/B VPWR VGND sg13g2_nand2_1
X_15616_ _15617_/B _22763_/Q _15700_/B _16007_/B _22795_/Q VPWR VGND sg13g2_a22oi_1
X_19384_ _19384_/Y _20338_/A _19576_/B VPWR VGND sg13g2_nor2_1
XFILLER_37_1211 VPWR VGND sg13g2_fill_2
XFILLER_50_828 VPWR VGND sg13g2_decap_8
XFILLER_56_1834 VPWR VGND sg13g2_fill_1
X_12828_ _12861_/A _13723_/A _12863_/B VPWR VGND sg13g2_xnor2_1
XFILLER_61_165 VPWR VGND sg13g2_fill_2
XFILLER_17_1807 VPWR VGND sg13g2_fill_2
XFILLER_50_839 VPWR VGND sg13g2_fill_2
XFILLER_72_1113 VPWR VGND sg13g2_fill_1
X_18335_ _18336_/C _18238_/A _18330_/Y _18331_/Y _18334_/Y _18351_/B VPWR VGND sg13g2_a221oi_1
XFILLER_108_1946 VPWR VGND sg13g2_decap_8
XFILLER_15_593 VPWR VGND sg13g2_decap_4
X_15547_ _15548_/B _15545_/Y _15633_/S _15546_/Y VPWR VGND sg13g2_o21ai_1
XFILLER_37_1255 VPWR VGND sg13g2_fill_1
XFILLER_42_390 VPWR VGND sg13g2_decap_8
X_12759_ _12759_/Y _12759_/A _15629_/A VPWR VGND sg13g2_nor2_1
X_18266_ _18266_/Y _18504_/A _18485_/A VPWR VGND sg13g2_nor2_1
X_15478_ _15478_/Y _17390_/A _15478_/B _15478_/C _15478_/D VPWR VGND sg13g2_nor4_1
X_17217_ _17224_/A _22745_/Q _17217_/B VPWR VGND sg13g2_nand2_1
XFILLER_11_1406 VPWR VGND sg13g2_decap_8
X_14429_ _17041_/C _24276_/A _14429_/B VPWR VGND sg13g2_or2_1
XFILLER_11_1417 VPWR VGND sg13g2_fill_2
X_18197_ _18380_/A _18451_/A _18197_/B VPWR VGND sg13g2_nor2_1
XFILLER_89_1654 VPWR VGND sg13g2_fill_1
X_17148_ _22733_/D _17141_/B _17145_/Y _17147_/Y VPWR VGND sg13g2_a21oi_1
XFILLER_115_112 VPWR VGND sg13g2_decap_8
XFILLER_85_1529 VPWR VGND sg13g2_decap_8
X_17079_ _17079_/Y _22721_/Q _17079_/B VPWR VGND sg13g2_xnor2_1
XFILLER_41_0 VPWR VGND sg13g2_decap_8
XFILLER_115_189 VPWR VGND sg13g2_decap_8
XFILLER_69_210 VPWR VGND sg13g2_fill_2
X_20090_ _20090_/Y _20112_/A _20121_/B _20089_/Y VPWR VGND sg13g2_o21ai_1
XFILLER_97_541 VPWR VGND sg13g2_fill_2
XFILLER_115_1917 VPWR VGND sg13g2_decap_8
XFILLER_112_852 VPWR VGND sg13g2_decap_8
XFILLER_44_1248 VPWR VGND sg13g2_decap_4
XFILLER_111_351 VPWR VGND sg13g2_fill_1
XFILLER_6_1721 VPWR VGND sg13g2_decap_8
XFILLER_61_1562 VPWR VGND sg13g2_fill_1
XFILLER_69_298 VPWR VGND sg13g2_decap_8
XFILLER_84_235 VPWR VGND sg13g2_fill_1
X_22800_ _22800_/Q clkload10/A _22800_/D fanout2813/X VPWR VGND sg13g2_dfrbpq_1
XFILLER_6_1798 VPWR VGND sg13g2_decap_8
X_23780_ _23780_/Q clkload40/A _23780_/D fanout2731/X VPWR VGND sg13g2_dfrbpq_1
XFILLER_65_460 VPWR VGND sg13g2_fill_2
XFILLER_81_920 VPWR VGND sg13g2_decap_4
XFILLER_96_1647 VPWR VGND sg13g2_fill_1
XFILLER_65_471 VPWR VGND sg13g2_fill_1
X_22731_ _22731_/Q _22733_/CLK _22731_/D fanout2881/X VPWR VGND sg13g2_dfrbpq_1
XFILLER_96_1658 VPWR VGND sg13g2_decap_8
XFILLER_37_184 VPWR VGND sg13g2_fill_2
XFILLER_65_493 VPWR VGND sg13g2_decap_8
XFILLER_111_14 VPWR VGND sg13g2_decap_8
XFILLER_20_1270 VPWR VGND sg13g2_fill_1
XFILLER_53_655 VPWR VGND sg13g2_decap_8
X_22662_ _22662_/Q clkload23/A _22662_/D fanout2883/X VPWR VGND sg13g2_dfrbpq_1
XFILLER_74_1934 VPWR VGND sg13g2_decap_8
XFILLER_0_1397 VPWR VGND sg13g2_decap_4
XFILLER_52_187 VPWR VGND sg13g2_fill_1
X_21613_ _23822_/D _21974_/A1 _21621_/B _21612_/Y VPWR VGND sg13g2_o21ai_1
XFILLER_16_1306 VPWR VGND sg13g2_decap_8
XFILLER_35_1929 VPWR VGND sg13g2_decap_8
X_22593_ _22593_/Q clkload28/A _22593_/D fanout2872/X VPWR VGND sg13g2_dfrbpq_1
XFILLER_21_530 VPWR VGND sg13g2_fill_1
XFILLER_107_1445 VPWR VGND sg13g2_decap_4
XFILLER_107_1467 VPWR VGND sg13g2_decap_8
X_21544_ _23788_/D _21971_/A1 _21549_/B _21543_/Y VPWR VGND sg13g2_o21ai_1
Xplace4040 _14596_/A _24234_/Q VPWR VGND sg13g2_buf_1
Xplace4051 _19003_/A _19047_/A VPWR VGND sg13g2_buf_1
Xplace4062 _17987_/B _24225_/Q VPWR VGND sg13g2_buf_1
XFILLER_21_596 VPWR VGND sg13g2_decap_8
X_24263_ _24263_/X _24263_/A VPWR VGND sg13g2_buf_1
XFILLER_14_1041 VPWR VGND sg13g2_decap_4
Xplace4073 _18899_/A _24225_/Q VPWR VGND sg13g2_buf_1
X_21475_ _21475_/Y _23755_/Q _21483_/B VPWR VGND sg13g2_nand2_1
Xplace4084 _20316_/S0 _20222_/B VPWR VGND sg13g2_buf_1
Xplace3350 _21314_/A1 _22211_/A1 VPWR VGND sg13g2_buf_1
Xplace4095 _19263_/A _23192_/Q VPWR VGND sg13g2_buf_1
Xplace3361 _22270_/A1 _19854_/Y VPWR VGND sg13g2_buf_1
X_23214_ _23214_/Q clkload33/A _23214_/D fanout2930/X VPWR VGND sg13g2_dfrbpq_1
X_20426_ _20426_/Y _20426_/A _20426_/B VPWR VGND sg13g2_nand2_1
Xplace3372 _17929_/B2 _17228_/B VPWR VGND sg13g2_buf_1
Xplace3383 _16050_/A _16048_/X VPWR VGND sg13g2_buf_1
X_24194_ _24194_/Q _24196_/CLK _24194_/D fanout2703/X VPWR VGND sg13g2_dfrbpq_1
XFILLER_107_646 VPWR VGND sg13g2_decap_8
XFILLER_106_112 VPWR VGND sg13g2_decap_8
XFILLER_11_1951 VPWR VGND sg13g2_decap_4
XFILLER_20_33 VPWR VGND sg13g2_fill_2
Xplace3394 _17498_/B _17503_/B VPWR VGND sg13g2_buf_1
X_23145_ _23145_/Q clkload14/A _23145_/D fanout2840/X VPWR VGND sg13g2_dfrbpq_1
X_20357_ _20357_/Y _20356_/A _20287_/B _20356_/Y VPWR VGND sg13g2_o21ai_1
XFILLER_101_1099 VPWR VGND sg13g2_decap_8
XFILLER_84_1039 VPWR VGND sg13g2_decap_8
XFILLER_106_189 VPWR VGND sg13g2_decap_4
XFILLER_66_1451 VPWR VGND sg13g2_fill_2
X_23076_ _23076_/Q _23114_/CLK _23076_/D fanout2906/X VPWR VGND sg13g2_dfrbpq_1
X_20288_ _20289_/B _20355_/A _20290_/B _20287_/Y VPWR VGND sg13g2_a21oi_1
XFILLER_66_1473 VPWR VGND sg13g2_fill_1
XFILLER_81_1949 VPWR VGND sg13g2_decap_4
XFILLER_103_863 VPWR VGND sg13g2_decap_8
X_22027_ _22027_/Y _24007_/Q _22039_/B VPWR VGND sg13g2_nand2_1
XFILLER_88_563 VPWR VGND sg13g2_decap_8
XFILLER_48_405 VPWR VGND sg13g2_fill_1
XFILLER_88_585 VPWR VGND sg13g2_decap_8
XFILLER_29_42 VPWR VGND sg13g2_decap_8
XFILLER_29_53 VPWR VGND sg13g2_fill_1
XFILLER_75_213 VPWR VGND sg13g2_fill_2
XFILLER_5_1242 VPWR VGND sg13g2_fill_2
XFILLER_91_706 VPWR VGND sg13g2_decap_8
X_13800_ _13800_/Y _13141_/B _13794_/X _13796_/Y _13799_/Y _13966_/B VPWR VGND sg13g2_a221oi_1
XFILLER_25_1192 VPWR VGND sg13g2_decap_8
XFILLER_40_1646 VPWR VGND sg13g2_decap_8
XFILLER_79_1823 VPWR VGND sg13g2_decap_8
XFILLER_21_1034 VPWR VGND sg13g2_decap_8
X_11992_ _11992_/Y _22552_/Q _11736_/Y _11862_/Y VPWR VGND sg13g2_a21oi_1
X_14780_ _17527_/A _14780_/A _14792_/B VPWR VGND sg13g2_nor2_1
XFILLER_63_419 VPWR VGND sg13g2_decap_8
XFILLER_99_1271 VPWR VGND sg13g2_decap_8
XFILLER_1_1117 VPWR VGND sg13g2_fill_2
X_23978_ _23978_/Q _24131_/CLK _23978_/D fanout2711/X VPWR VGND sg13g2_dfrbpq_1
XFILLER_84_791 VPWR VGND sg13g2_decap_4
XFILLER_28_173 VPWR VGND sg13g2_decap_8
XFILLER_45_30 VPWR VGND sg13g2_fill_1
X_13731_ _13731_/Y _20229_/B _13733_/B VPWR VGND sg13g2_nor2_1
XFILLER_17_858 VPWR VGND sg13g2_decap_4
X_22929_ _22929_/Q _22941_/CLK _22929_/D fanout2801/X VPWR VGND sg13g2_dfrbpq_1
XFILLER_79_1889 VPWR VGND sg13g2_fill_2
XFILLER_43_132 VPWR VGND sg13g2_fill_1
XFILLER_32_806 VPWR VGND sg13g2_decap_4
XFILLER_16_368 VPWR VGND sg13g2_fill_1
X_16450_ _22589_/D _16050_/A _16517_/S _16449_/Y VPWR VGND sg13g2_o21ai_1
XFILLER_72_986 VPWR VGND sg13g2_decap_8
X_13662_ _13662_/Y _13657_/A _13657_/B _13661_/Y VPWR VGND sg13g2_o21ai_1
XFILLER_31_338 VPWR VGND sg13g2_fill_2
X_12613_ _14055_/A _13520_/A _12853_/A VPWR VGND sg13g2_xnor2_1
X_13593_ _13593_/X _24046_/Q _24078_/Q _13974_/S VPWR VGND sg13g2_mux2_1
X_16381_ _22553_/D _23003_/Q _22553_/Q _16388_/B VPWR VGND sg13g2_mux2_1
XFILLER_101_91 VPWR VGND sg13g2_decap_8
X_18120_ _18120_/Y _18297_/B VPWR VGND sg13g2_inv_1
XFILLER_38_1597 VPWR VGND sg13g2_fill_2
X_15332_ _15333_/B _15332_/A _15332_/B _15332_/C _15332_/D VPWR VGND sg13g2_nand4_1
X_12544_ _14051_/B _12544_/A _12544_/B _12544_/C VPWR VGND sg13g2_nand3_1
XFILLER_61_62 VPWR VGND sg13g2_decap_8
XFILLER_12_1704 VPWR VGND sg13g2_decap_4
XFILLER_51_1753 VPWR VGND sg13g2_fill_2
X_15263_ _16787_/B _17390_/B _14394_/Y _17390_/A VPWR VGND sg13g2_a21o_1
XFILLER_16_1884 VPWR VGND sg13g2_decap_8
XFILLER_8_556 VPWR VGND sg13g2_decap_8
X_12475_ _12480_/B _12475_/A _12475_/B VPWR VGND sg13g2_nor2_1
XFILLER_103_1854 VPWR VGND sg13g2_decap_8
X_17002_ _22709_/D _17007_/A1 _17000_/Y _17001_/Y VPWR VGND sg13g2_o21ai_1
X_11426_ _11433_/B _12247_/A _11426_/B VPWR VGND sg13g2_nor2_1
X_15194_ _15194_/Y _15482_/B _15194_/B VPWR VGND sg13g2_nor2_1
XANTENNA_6 _14614_/Y VPWR VGND sg13g2_antennanp
XFILLER_67_1204 VPWR VGND sg13g2_fill_1
XFILLER_6_79 VPWR VGND sg13g2_fill_2
X_14145_ _14435_/B _14436_/C _14145_/B VPWR VGND sg13g2_nor2_1
X_11357_ _11357_/X _23831_/Q _23863_/Q _23927_/Q _23959_/Q _11768_/S0 _11768_/S1 VPWR
+ VGND sg13g2_mux4_1
XFILLER_99_839 VPWR VGND sg13g2_decap_8
XFILLER_98_316 VPWR VGND sg13g2_fill_1
XFILLER_49_1660 VPWR VGND sg13g2_decap_8
XFILLER_113_638 VPWR VGND sg13g2_decap_8
XFILLER_10_1494 VPWR VGND sg13g2_decap_8
XFILLER_45_1502 VPWR VGND sg13g2_decap_8
X_18953_ _18953_/Y _18953_/A _18953_/B _18953_/C VPWR VGND sg13g2_nand3_1
X_14076_ _19320_/C _19721_/A VPWR VGND sg13g2_inv_1
XFILLER_112_126 VPWR VGND sg13g2_decap_8
X_11288_ _11288_/Y _12126_/A _11285_/X _11287_/X VPWR VGND sg13g2_a21oi_1
XFILLER_3_294 VPWR VGND sg13g2_decap_8
X_17904_ _22932_/D _17904_/A _17904_/B VPWR VGND sg13g2_nand2_1
X_13027_ _13028_/C _23431_/Q _23495_/Q _23591_/Q _23655_/Q _13270_/S1 _13019_/A VPWR
+ VGND sg13g2_mux4_1
X_18884_ _18886_/B _18884_/A _18884_/B VPWR VGND sg13g2_nand2_1
XFILLER_94_500 VPWR VGND sg13g2_decap_4
XFILLER_79_574 VPWR VGND sg13g2_fill_2
XFILLER_6_1028 VPWR VGND sg13g2_fill_2
X_17835_ _17853_/C _17835_/A _17835_/B VPWR VGND sg13g2_nand2_1
XFILLER_86_92 VPWR VGND sg13g2_decap_8
XFILLER_13_4 VPWR VGND sg13g2_fill_1
XFILLER_62_1893 VPWR VGND sg13g2_decap_8
XFILLER_110_1803 VPWR VGND sg13g2_decap_8
XFILLER_19_140 VPWR VGND sg13g2_fill_2
X_17766_ _17766_/Y _17182_/A _17810_/A2 _17810_/B1 _17765_/Y VPWR VGND sg13g2_a22oi_1
XFILLER_82_739 VPWR VGND sg13g2_decap_8
XFILLER_35_611 VPWR VGND sg13g2_decap_8
XFILLER_47_471 VPWR VGND sg13g2_fill_1
X_19505_ _19505_/Y _19505_/A _19514_/A VPWR VGND sg13g2_nor2b_1
X_16717_ _16726_/C _22658_/Q _22657_/Q _16717_/C VPWR VGND sg13g2_and3_1
XFILLER_93_1809 VPWR VGND sg13g2_decap_8
XFILLER_78_1355 VPWR VGND sg13g2_decap_8
XFILLER_34_110 VPWR VGND sg13g2_decap_8
XFILLER_39_1306 VPWR VGND sg13g2_fill_1
X_13929_ _13930_/B _13929_/A _13937_/B VPWR VGND sg13g2_nand2_1
X_17697_ _17697_/Y _17697_/A _22963_/Q VPWR VGND sg13g2_nand2_1
XFILLER_63_953 VPWR VGND sg13g2_fill_2
XFILLER_63_964 VPWR VGND sg13g2_fill_2
XFILLER_23_806 VPWR VGND sg13g2_decap_8
X_19436_ _19436_/Y _20058_/A _19896_/B VPWR VGND sg13g2_nand2_1
XFILLER_34_143 VPWR VGND sg13g2_decap_8
XFILLER_62_452 VPWR VGND sg13g2_decap_8
X_16648_ _16658_/C _22644_/Q _22643_/Q _16648_/C VPWR VGND sg13g2_and3_1
XFILLER_63_997 VPWR VGND sg13g2_fill_2
XFILLER_50_625 VPWR VGND sg13g2_fill_2
X_19367_ _19367_/Y _19777_/B _19367_/B VPWR VGND sg13g2_nand2b_1
X_16579_ _16676_/A _16654_/B VPWR VGND sg13g2_inv_1
XFILLER_17_1637 VPWR VGND sg13g2_decap_8
X_18318_ _18318_/Y _18318_/A _18318_/B VPWR VGND sg13g2_nand2_1
XFILLER_89_0 VPWR VGND sg13g2_decap_8
XFILLER_37_1085 VPWR VGND sg13g2_decap_8
XFILLER_104_1618 VPWR VGND sg13g2_decap_4
X_19298_ _23215_/D _23215_/Q _20278_/A0 _19298_/S VPWR VGND sg13g2_mux2_1
X_18249_ _18249_/Y _18290_/C _18239_/Y _18248_/Y VPWR VGND sg13g2_a21oi_1
XFILLER_102_1331 VPWR VGND sg13g2_decap_8
X_21260_ _21260_/Y _23652_/Q _21271_/B VPWR VGND sg13g2_nand2_1
XFILLER_102_1375 VPWR VGND sg13g2_fill_2
XFILLER_102_1386 VPWR VGND sg13g2_decap_4
X_20211_ _20214_/A _20304_/B _20208_/Y _20209_/Y _20210_/Y _19956_/A VPWR VGND sg13g2_a221oi_1
X_21191_ _21191_/Y _23619_/Q _21197_/B VPWR VGND sg13g2_nand2_1
XFILLER_104_638 VPWR VGND sg13g2_decap_8
XFILLER_89_349 VPWR VGND sg13g2_fill_1
XFILLER_106_14 VPWR VGND sg13g2_decap_8
XFILLER_115_1714 VPWR VGND sg13g2_decap_8
XFILLER_100_800 VPWR VGND sg13g2_fill_2
X_20073_ _20073_/Y _20073_/A VPWR VGND sg13g2_inv_1
XFILLER_98_883 VPWR VGND sg13g2_decap_8
XFILLER_97_360 VPWR VGND sg13g2_fill_1
XFILLER_85_522 VPWR VGND sg13g2_fill_1
XFILLER_57_213 VPWR VGND sg13g2_fill_2
XFILLER_58_736 VPWR VGND sg13g2_fill_1
X_23901_ _23901_/Q clkload44/A _23901_/D fanout2745/X VPWR VGND sg13g2_dfrbpq_1
XFILLER_58_769 VPWR VGND sg13g2_decap_4
XFILLER_100_877 VPWR VGND sg13g2_fill_2
X_23832_ _23832_/Q _24113_/CLK _23832_/D fanout2688/X VPWR VGND sg13g2_dfrbpq_1
XFILLER_85_577 VPWR VGND sg13g2_decap_8
XFILLER_39_994 VPWR VGND sg13g2_decap_8
X_23763_ _23763_/Q clkload51/A _23763_/D fanout2664/X VPWR VGND sg13g2_dfrbpq_1
XFILLER_2_1459 VPWR VGND sg13g2_fill_2
X_20975_ _20975_/Y _23532_/Q _20983_/B VPWR VGND sg13g2_nand2_1
XFILLER_65_290 VPWR VGND sg13g2_fill_1
XFILLER_92_1319 VPWR VGND sg13g2_decap_8
X_22714_ _22714_/Q _22733_/CLK _22714_/D fanout2884/X VPWR VGND sg13g2_dfrbpq_1
XFILLER_81_772 VPWR VGND sg13g2_decap_8
XFILLER_26_688 VPWR VGND sg13g2_decap_8
X_23694_ _23694_/Q clkload36/A _23694_/D fanout2641/X VPWR VGND sg13g2_dfrbpq_1
XFILLER_14_839 VPWR VGND sg13g2_decap_4
XFILLER_25_198 VPWR VGND sg13g2_decap_8
X_22645_ _22645_/Q clkload19/A _22645_/D fanout2862/X VPWR VGND sg13g2_dfrbpq_1
XFILLER_41_658 VPWR VGND sg13g2_decap_8
XFILLER_74_1764 VPWR VGND sg13g2_decap_8
XFILLER_107_1231 VPWR VGND sg13g2_decap_4
XFILLER_16_1114 VPWR VGND sg13g2_decap_8
XFILLER_90_1054 VPWR VGND sg13g2_fill_1
XFILLER_16_1125 VPWR VGND sg13g2_fill_1
X_22576_ _22576_/Q clkload11/A _22576_/D fanout2837/X VPWR VGND sg13g2_dfrbpq_1
XFILLER_40_179 VPWR VGND sg13g2_decap_4
XFILLER_107_1264 VPWR VGND sg13g2_decap_8
X_21527_ _23779_/D _21954_/A1 _21534_/B _21526_/Y VPWR VGND sg13g2_o21ai_1
XFILLER_31_32 VPWR VGND sg13g2_fill_1
X_12260_ _12260_/Y _12341_/B _12341_/A _12264_/C _12628_/A1 _12259_/Y VPWR VGND sg13g2_a221oi_1
XFILLER_68_1513 VPWR VGND sg13g2_fill_1
Xplace3180 _20565_/B _20572_/B VPWR VGND sg13g2_buf_1
Xplace3191 _20395_/B _20388_/B VPWR VGND sg13g2_buf_1
X_20409_ _23268_/D _21261_/A1 _20412_/B _20408_/Y VPWR VGND sg13g2_o21ai_1
XFILLER_68_1546 VPWR VGND sg13g2_fill_2
X_24177_ _24177_/Q clkload50/A _24177_/D fanout2662/X VPWR VGND sg13g2_dfrbpq_1
X_12191_ _12192_/B _23741_/Q _23805_/Q _12191_/S VPWR VGND sg13g2_mux2_1
X_21389_ _21389_/Y _21389_/A _21389_/B VPWR VGND sg13g2_nand2_1
XFILLER_68_1557 VPWR VGND sg13g2_decap_4
X_23128_ _23128_/Q clkload5/A _23128_/D fanout2835/X VPWR VGND sg13g2_dfrbpq_1
XFILLER_81_1702 VPWR VGND sg13g2_decap_8
XFILLER_62_1101 VPWR VGND sg13g2_decap_4
X_23059_ _23059_/Q clkload12/A _23059_/D fanout2913/X VPWR VGND sg13g2_dfrbpq_1
X_15950_ _15950_/X _20304_/C _15950_/B _15950_/C VPWR VGND sg13g2_or3_1
XFILLER_88_360 VPWR VGND sg13g2_decap_8
XFILLER_88_371 VPWR VGND sg13g2_fill_1
XFILLER_48_202 VPWR VGND sg13g2_decap_4
XFILLER_114_1224 VPWR VGND sg13g2_decap_4
X_14901_ _14901_/Y _14953_/A _23133_/Q VPWR VGND sg13g2_nand2_1
XFILLER_48_224 VPWR VGND sg13g2_fill_1
XFILLER_48_235 VPWR VGND sg13g2_decap_8
X_15881_ _15882_/D _22775_/Q _15700_/B _15880_/Y VPWR VGND sg13g2_a21oi_1
XFILLER_114_1257 VPWR VGND sg13g2_fill_2
XFILLER_48_246 VPWR VGND sg13g2_fill_1
XFILLER_62_1189 VPWR VGND sg13g2_fill_2
X_17620_ _22885_/D _17661_/B _17618_/Y _17619_/Y VPWR VGND sg13g2_a21oi_1
XFILLER_97_1219 VPWR VGND sg13g2_fill_2
XFILLER_91_503 VPWR VGND sg13g2_decap_8
X_14832_ _14832_/Y _14861_/A _14228_/A VPWR VGND sg13g2_nor2b_1
XFILLER_79_1631 VPWR VGND sg13g2_fill_1
XFILLER_63_216 VPWR VGND sg13g2_decap_4
XFILLER_5_1083 VPWR VGND sg13g2_decap_8
XFILLER_45_931 VPWR VGND sg13g2_fill_1
X_14763_ _14763_/Y _14872_/A _14763_/B VPWR VGND sg13g2_nand2_1
X_11975_ _11975_/Y _12266_/A _11975_/B VPWR VGND sg13g2_nor2_1
X_16502_ _16502_/Y _22612_/Q _16508_/B VPWR VGND sg13g2_nand2_1
XFILLER_16_154 VPWR VGND sg13g2_decap_4
X_17482_ _17482_/Y _17482_/A _17503_/B VPWR VGND sg13g2_nand2_1
XFILLER_16_165 VPWR VGND sg13g2_decap_4
X_14694_ _14694_/Y _14694_/A _14694_/B VPWR VGND sg13g2_nand2_1
XFILLER_16_176 VPWR VGND sg13g2_fill_1
X_19221_ _23176_/D _24265_/A _23176_/Q _19221_/S VPWR VGND sg13g2_mux2_1
X_16433_ _17034_/D _16684_/A1 _16681_/A VPWR VGND sg13g2_nand2b_1
XFILLER_16_198 VPWR VGND sg13g2_fill_2
XFILLER_38_1350 VPWR VGND sg13g2_fill_2
X_13645_ _13645_/X _13645_/A _23919_/Q VPWR VGND sg13g2_and2_1
XFILLER_32_658 VPWR VGND sg13g2_decap_8
XFILLER_53_1815 VPWR VGND sg13g2_fill_2
XFILLER_18_1946 VPWR VGND sg13g2_decap_8
XFILLER_105_1905 VPWR VGND sg13g2_decap_8
XFILLER_13_861 VPWR VGND sg13g2_decap_8
XFILLER_34_1214 VPWR VGND sg13g2_decap_8
X_16364_ _16367_/A _22546_/Q _16364_/B VPWR VGND sg13g2_nor2_1
X_13576_ _13597_/A _13576_/A1 _13573_/X _13575_/X VPWR VGND sg13g2_o21ai_1
X_18103_ _18103_/Y _18194_/A _18103_/B VPWR VGND sg13g2_nor2_1
XFILLER_34_1269 VPWR VGND sg13g2_fill_1
X_12527_ _12623_/A _12524_/X _19430_/A _12526_/Y VPWR VGND sg13g2_a21oi_2
X_19083_ _19083_/X _18871_/A _23110_/Q _19098_/S VPWR VGND sg13g2_mux2_1
X_16295_ _16296_/B _16295_/A _16295_/B VPWR VGND sg13g2_nor2_1
X_15246_ _15538_/A _16776_/C _15246_/B VPWR VGND sg13g2_nand2_1
XFILLER_86_1602 VPWR VGND sg13g2_decap_8
X_12458_ _12461_/D _12458_/A _12458_/B VPWR VGND sg13g2_or2_1
XFILLER_86_1635 VPWR VGND sg13g2_decap_8
X_11409_ _11409_/Y _23510_/Q _11749_/S VPWR VGND sg13g2_nand2b_1
XFILLER_86_1646 VPWR VGND sg13g2_fill_1
X_15177_ _15197_/B _15177_/A _15577_/A VPWR VGND sg13g2_or2_1
XFILLER_47_1608 VPWR VGND sg13g2_fill_2
XFILLER_86_1668 VPWR VGND sg13g2_decap_8
XFILLER_98_113 VPWR VGND sg13g2_fill_1
X_14128_ _14290_/B _14116_/X _14117_/Y _14127_/Y VPWR VGND sg13g2_a21oi_1
XFILLER_113_435 VPWR VGND sg13g2_decap_8
X_19985_ _19985_/Y _20033_/A1 _19764_/B _19663_/X VPWR VGND sg13g2_a21oi_1
XFILLER_98_146 VPWR VGND sg13g2_fill_1
XFILLER_25_1906 VPWR VGND sg13g2_fill_1
X_18936_ _18936_/Y _18955_/A _18936_/B _18936_/C VPWR VGND sg13g2_nand3b_1
X_14059_ _14064_/B _14059_/A _14059_/B _14059_/C _14059_/D VPWR VGND sg13g2_and4_1
XFILLER_100_107 VPWR VGND sg13g2_fill_2
XFILLER_60_1808 VPWR VGND sg13g2_fill_1
XFILLER_95_842 VPWR VGND sg13g2_decap_8
XFILLER_67_533 VPWR VGND sg13g2_decap_8
X_18867_ _18867_/Y _18016_/S _23045_/Q _18856_/B _17982_/B VPWR VGND sg13g2_a22oi_1
XFILLER_95_853 VPWR VGND sg13g2_decap_8
XFILLER_95_864 VPWR VGND sg13g2_fill_2
XFILLER_23_1630 VPWR VGND sg13g2_fill_1
X_17818_ _17818_/Y _22908_/Q _17825_/B VPWR VGND sg13g2_nor2_1
X_18798_ _18798_/Y _17965_/A _23034_/Q _18823_/B1 _19120_/A1 VPWR VGND sg13g2_a22oi_1
XFILLER_94_385 VPWR VGND sg13g2_fill_1
XFILLER_82_525 VPWR VGND sg13g2_decap_8
XFILLER_23_1674 VPWR VGND sg13g2_decap_4
XFILLER_3_1757 VPWR VGND sg13g2_decap_8
XFILLER_97_1753 VPWR VGND sg13g2_decap_8
X_17749_ _17749_/Y _17823_/A1 _17747_/X _17748_/Y VPWR VGND sg13g2_o21ai_1
XFILLER_78_1141 VPWR VGND sg13g2_decap_8
X_20760_ _20760_/Y _23430_/Q _20772_/B VPWR VGND sg13g2_nand2_1
XFILLER_36_997 VPWR VGND sg13g2_decap_8
XFILLER_90_580 VPWR VGND sg13g2_fill_1
XFILLER_50_411 VPWR VGND sg13g2_decap_8
XFILLER_23_636 VPWR VGND sg13g2_fill_1
XFILLER_50_422 VPWR VGND sg13g2_fill_1
X_19419_ _19874_/B _19671_/A _19419_/B VPWR VGND sg13g2_xnor2_1
XFILLER_39_1169 VPWR VGND sg13g2_decap_8
XFILLER_71_1904 VPWR VGND sg13g2_decap_8
X_20691_ _23398_/D _22427_/A1 _20690_/B _20690_/Y VPWR VGND sg13g2_o21ai_1
XFILLER_50_455 VPWR VGND sg13g2_fill_1
X_22430_ _22449_/S _22430_/A _22430_/B VPWR VGND sg13g2_nor2_1
XFILLER_22_179 VPWR VGND sg13g2_decap_8
XFILLER_52_1358 VPWR VGND sg13g2_decap_8
X_22361_ _22361_/Y _22361_/A _22374_/B VPWR VGND sg13g2_nand2_1
XFILLER_52_1369 VPWR VGND sg13g2_fill_1
X_24100_ _24100_/Q clkload45/A _24100_/D fanout2715/X VPWR VGND sg13g2_dfrbpq_1
X_21312_ _23677_/D _21312_/A1 _21313_/B _21311_/Y VPWR VGND sg13g2_o21ai_1
XFILLER_15_1191 VPWR VGND sg13g2_decap_4
X_22292_ _24133_/D _22292_/A1 _22291_/B _22291_/Y VPWR VGND sg13g2_o21ai_1
XFILLER_102_1172 VPWR VGND sg13g2_decap_8
XFILLER_30_1678 VPWR VGND sg13g2_decap_8
X_24031_ _24031_/Q _24131_/CLK _24031_/D fanout2750/X VPWR VGND sg13g2_dfrbpq_1
X_21243_ _23644_/D _22272_/A1 _21242_/B _21242_/Y VPWR VGND sg13g2_o21ai_1
X_21174_ _23611_/D _21307_/A1 _21179_/B _21173_/Y VPWR VGND sg13g2_o21ai_1
XFILLER_85_1178 VPWR VGND sg13g2_fill_2
XFILLER_77_17 VPWR VGND sg13g2_decap_8
XFILLER_89_146 VPWR VGND sg13g2_decap_8
XFILLER_104_468 VPWR VGND sg13g2_fill_2
XFILLER_115_1511 VPWR VGND sg13g2_decap_8
XFILLER_63_1454 VPWR VGND sg13g2_decap_4
XFILLER_86_831 VPWR VGND sg13g2_decap_4
XFILLER_98_691 VPWR VGND sg13g2_decap_4
X_20056_ _20138_/B _19663_/A _19569_/Y _19543_/Y VPWR VGND sg13g2_o21ai_1
XFILLER_97_190 VPWR VGND sg13g2_decap_8
XFILLER_115_1588 VPWR VGND sg13g2_decap_8
XFILLER_115_1599 VPWR VGND sg13g2_decap_8
XFILLER_45_205 VPWR VGND sg13g2_fill_1
XFILLER_100_685 VPWR VGND sg13g2_decap_8
XFILLER_58_599 VPWR VGND sg13g2_fill_1
XFILLER_93_38 VPWR VGND sg13g2_decap_8
XFILLER_85_396 VPWR VGND sg13g2_decap_8
XFILLER_73_536 VPWR VGND sg13g2_decap_8
XFILLER_2_1245 VPWR VGND sg13g2_decap_4
X_23815_ _23815_/Q clkload37/A _23815_/D fanout2707/X VPWR VGND sg13g2_dfrbpq_1
XFILLER_42_901 VPWR VGND sg13g2_fill_2
X_11760_ _11760_/Y _13674_/A _11760_/B VPWR VGND sg13g2_nor2_1
XFILLER_26_65 VPWR VGND sg13g2_fill_2
X_20958_ _20958_/Y _23524_/Q _20971_/B VPWR VGND sg13g2_nand2_1
X_23746_ _23746_/Q clkload43/A _23746_/D fanout2740/X VPWR VGND sg13g2_dfrbpq_1
XFILLER_109_1326 VPWR VGND sg13g2_fill_2
XFILLER_26_496 VPWR VGND sg13g2_decap_4
XFILLER_53_282 VPWR VGND sg13g2_decap_8
XFILLER_57_1269 VPWR VGND sg13g2_decap_8
X_11691_ _11692_/B _24152_/Q _23288_/Q _11699_/S VPWR VGND sg13g2_mux2_1
XFILLER_39_1670 VPWR VGND sg13g2_decap_8
XFILLER_74_1550 VPWR VGND sg13g2_fill_1
X_23677_ _23677_/Q clkload53/A _23677_/D fanout2778/X VPWR VGND sg13g2_dfrbpq_1
X_20889_ _23490_/D _21323_/A1 _20888_/B _20888_/Y VPWR VGND sg13g2_o21ai_1
X_13430_ _13430_/Y _23179_/Q _13924_/A2 _13924_/B1 _13429_/X VPWR VGND sg13g2_a22oi_1
X_22628_ _22628_/Q clkload23/A _22628_/D fanout2887/X VPWR VGND sg13g2_dfrbpq_1
XFILLER_9_128 VPWR VGND sg13g2_decap_4
XFILLER_107_1050 VPWR VGND sg13g2_decap_8
XFILLER_107_1061 VPWR VGND sg13g2_fill_1
XFILLER_10_820 VPWR VGND sg13g2_decap_8
X_13361_ _13361_/Y _14032_/A _13360_/Y _20178_/B VPWR VGND sg13g2_o21ai_1
X_22559_ _22559_/Q clkload26/A _22559_/D fanout2853/X VPWR VGND sg13g2_dfrbpq_1
XFILLER_13_1843 VPWR VGND sg13g2_decap_8
X_12312_ _12324_/A _12488_/B1 _12308_/X _12311_/X _11951_/A VPWR VGND sg13g2_a22oi_1
X_16080_ _16080_/Y _19430_/A _15335_/B _15540_/Y VPWR VGND sg13g2_a21oi_1
X_13292_ _20181_/A _13292_/A _20179_/B VPWR VGND sg13g2_nor2_1
XFILLER_6_868 VPWR VGND sg13g2_decap_8
XFILLER_68_1321 VPWR VGND sg13g2_fill_2
X_12243_ _12250_/A _12243_/A _12243_/B VPWR VGND sg13g2_nor2_1
XFILLER_6_879 VPWR VGND sg13g2_fill_2
X_24229_ _24229_/Q clkload11/A _24229_/D fanout2841/X VPWR VGND sg13g2_dfrbpq_1
XFILLER_107_273 VPWR VGND sg13g2_fill_2
XFILLER_68_1365 VPWR VGND sg13g2_fill_2
X_12174_ _12174_/X _12170_/X _12171_/X _12172_/X _12173_/X _11926_/S _11418_/A VPWR
+ VGND sg13g2_mux4_1
XFILLER_3_14 VPWR VGND sg13g2_decap_8
X_19770_ _19778_/B _20307_/A _20294_/B _19769_/Y VPWR VGND sg13g2_o21ai_1
XFILLER_49_500 VPWR VGND sg13g2_decap_8
X_16982_ _16983_/B _17004_/B _16993_/C VPWR VGND sg13g2_nor2_1
XFILLER_96_639 VPWR VGND sg13g2_fill_2
XFILLER_42_1505 VPWR VGND sg13g2_fill_2
X_18721_ _18721_/Y _18721_/A VPWR VGND sg13g2_inv_1
XFILLER_7_1134 VPWR VGND sg13g2_decap_8
XFILLER_77_853 VPWR VGND sg13g2_decap_4
XFILLER_88_190 VPWR VGND sg13g2_decap_8
XFILLER_77_875 VPWR VGND sg13g2_decap_8
XFILLER_7_1178 VPWR VGND sg13g2_fill_1
XFILLER_49_566 VPWR VGND sg13g2_decap_8
X_18652_ _18652_/Y _15545_/Y _18661_/B _18648_/Y VPWR VGND sg13g2_o21ai_1
XFILLER_111_1920 VPWR VGND sg13g2_decap_8
X_15864_ _15865_/C _15864_/A _15864_/B _15864_/C _15864_/D VPWR VGND sg13g2_and4_1
XFILLER_92_834 VPWR VGND sg13g2_decap_8
X_17603_ _17603_/Y _17687_/A _22954_/Q VPWR VGND sg13g2_nand2_1
XFILLER_92_856 VPWR VGND sg13g2_decap_8
X_14815_ _14815_/Y _22913_/Q _14872_/A VPWR VGND sg13g2_nor2_1
X_18583_ _18584_/B _22996_/Q _18771_/B VPWR VGND sg13g2_nor2_1
X_15795_ _15796_/D _22608_/Q _15964_/A2 _15347_/Y _22872_/Q VPWR VGND sg13g2_a22oi_1
XFILLER_18_975 VPWR VGND sg13g2_fill_2
XFILLER_79_1483 VPWR VGND sg13g2_decap_8
X_17534_ _17706_/B _24238_/Q _17586_/A VPWR VGND sg13g2_and2_1
X_14746_ _14746_/Y _14202_/X _14745_/Y _14206_/B VPWR VGND sg13g2_o21ai_1
XFILLER_51_219 VPWR VGND sg13g2_fill_1
X_11958_ _11963_/B _11954_/Y _11956_/X _11957_/X _13266_/A1 VPWR VGND sg13g2_a22oi_1
XFILLER_83_82 VPWR VGND sg13g2_decap_8
XFILLER_60_720 VPWR VGND sg13g2_decap_8
XFILLER_44_282 VPWR VGND sg13g2_decap_8
X_17465_ _17465_/Y _17465_/A _17475_/B VPWR VGND sg13g2_nand2_1
XFILLER_75_1369 VPWR VGND sg13g2_decap_8
X_14677_ _14677_/Y _14713_/A _19195_/B VPWR VGND sg13g2_nor2_1
XFILLER_32_444 VPWR VGND sg13g2_fill_2
XFILLER_53_1601 VPWR VGND sg13g2_decap_8
X_11889_ _24249_/A _11889_/A VPWR VGND sg13g2_inv_1
XFILLER_32_455 VPWR VGND sg13g2_fill_1
XFILLER_34_1000 VPWR VGND sg13g2_decap_4
X_19204_ _23162_/D _24251_/A _23162_/Q _19209_/S VPWR VGND sg13g2_mux2_1
X_16416_ _22575_/D _23025_/Q _22575_/Q _16421_/S VPWR VGND sg13g2_mux2_1
X_13628_ _13734_/A _13925_/A1 _13625_/X _13627_/Y VPWR VGND sg13g2_a21o_2
XFILLER_34_1022 VPWR VGND sg13g2_decap_8
X_17396_ _17396_/Y _17396_/A VPWR VGND sg13g2_inv_1
XFILLER_14_1607 VPWR VGND sg13g2_decap_4
XFILLER_13_691 VPWR VGND sg13g2_decap_4
X_19135_ _23112_/D _23112_/Q _18895_/B _19141_/S VPWR VGND sg13g2_mux2_1
Xplace3905 _18553_/A1 _18425_/B VPWR VGND sg13g2_buf_1
X_16347_ _16350_/A _17034_/B _16347_/B VPWR VGND sg13g2_nor2_1
Xplace3916 _18406_/A _17977_/A VPWR VGND sg13g2_buf_1
XFILLER_9_662 VPWR VGND sg13g2_decap_8
X_13559_ _13559_/X _23438_/Q _23502_/Q _23598_/Q _23662_/Q _13251_/B _13559_/S1 VPWR
+ VGND sg13g2_mux4_1
Xplace3927 _13675_/A1 _11379_/Y VPWR VGND sg13g2_buf_1
Xplace3938 _18498_/C _18332_/A VPWR VGND sg13g2_buf_1
XFILLER_8_150 VPWR VGND sg13g2_decap_8
Xplace3949 _20130_/B _20317_/B VPWR VGND sg13g2_buf_1
X_19066_ _19066_/X _19124_/A1 _23102_/Q _19077_/S VPWR VGND sg13g2_mux2_1
X_16278_ _16321_/C _16278_/A _16278_/B _16278_/C VPWR VGND sg13g2_or3_1
XFILLER_12_1353 VPWR VGND sg13g2_fill_2
X_18017_ _18479_/C _18015_/X _18016_/X _18491_/A VPWR VGND sg13g2_mux2_1
X_15229_ _15229_/Y _14359_/C _15226_/Y _16776_/B _15228_/X _14316_/Y VPWR VGND sg13g2_a221oi_1
XFILLER_114_711 VPWR VGND sg13g2_decap_8
XFILLER_113_210 VPWR VGND sg13g2_decap_8
XFILLER_114_788 VPWR VGND sg13g2_decap_8
XFILLER_80_1020 VPWR VGND sg13g2_fill_2
X_19968_ _19968_/Y _20071_/A _19968_/B VPWR VGND sg13g2_nand2_1
XFILLER_45_1162 VPWR VGND sg13g2_decap_8
X_18919_ _18920_/C _18926_/A _23082_/Q VPWR VGND sg13g2_nand2_1
XFILLER_25_1747 VPWR VGND sg13g2_decap_8
XFILLER_5_1819 VPWR VGND sg13g2_decap_8
X_19899_ _19899_/Y _20092_/A2 _19865_/Y _19898_/Y VPWR VGND sg13g2_o21ai_1
XFILLER_68_864 VPWR VGND sg13g2_decap_4
XFILLER_112_1728 VPWR VGND sg13g2_decap_8
XFILLER_110_972 VPWR VGND sg13g2_decap_8
XFILLER_95_672 VPWR VGND sg13g2_decap_4
XFILLER_83_812 VPWR VGND sg13g2_decap_4
XFILLER_67_363 VPWR VGND sg13g2_decap_8
X_21930_ _23960_/D _21930_/A1 _21965_/S _21929_/Y VPWR VGND sg13g2_o21ai_1
XFILLER_110_983 VPWR VGND sg13g2_fill_1
XFILLER_41_1048 VPWR VGND sg13g2_fill_2
XFILLER_83_834 VPWR VGND sg13g2_fill_2
XFILLER_7_1690 VPWR VGND sg13g2_decap_8
XFILLER_3_1532 VPWR VGND sg13g2_decap_8
X_21861_ _21861_/Y _23927_/Q _21869_/B VPWR VGND sg13g2_nand2_1
XFILLER_24_901 VPWR VGND sg13g2_fill_1
XFILLER_36_761 VPWR VGND sg13g2_decap_8
X_20812_ _20812_/Y _23455_/Q _20818_/B VPWR VGND sg13g2_nand2_1
XFILLER_70_517 VPWR VGND sg13g2_fill_1
X_23600_ _23600_/Q clkload56/A _23600_/D fanout2672/X VPWR VGND sg13g2_dfrbpq_1
X_21792_ _21792_/Y _23894_/Q _21804_/B VPWR VGND sg13g2_nand2_1
XFILLER_24_923 VPWR VGND sg13g2_fill_1
XFILLER_58_1545 VPWR VGND sg13g2_decap_8
XFILLER_19_1507 VPWR VGND sg13g2_decap_4
XFILLER_58_1556 VPWR VGND sg13g2_fill_1
XFILLER_63_580 VPWR VGND sg13g2_fill_2
XFILLER_58_1567 VPWR VGND sg13g2_fill_2
XFILLER_54_1409 VPWR VGND sg13g2_fill_1
X_20743_ _23422_/D _21314_/A1 _20742_/B _20742_/Y VPWR VGND sg13g2_o21ai_1
XFILLER_23_433 VPWR VGND sg13g2_decap_8
X_23531_ _23531_/Q clkload38/A _23531_/D fanout2638/X VPWR VGND sg13g2_dfrbpq_1
XFILLER_24_978 VPWR VGND sg13g2_decap_8
XFILLER_23_466 VPWR VGND sg13g2_decap_4
XFILLER_24_989 VPWR VGND sg13g2_fill_2
XFILLER_51_775 VPWR VGND sg13g2_fill_1
XFILLER_17_1220 VPWR VGND sg13g2_decap_8
X_23462_ _23462_/Q clkload42/A _23462_/D fanout2720/X VPWR VGND sg13g2_dfrbpq_1
XFILLER_23_488 VPWR VGND sg13g2_fill_1
X_20674_ _23390_/D _22409_/A1 _20673_/B _20673_/Y VPWR VGND sg13g2_o21ai_1
X_22413_ _22413_/Y _22413_/A _22417_/B VPWR VGND sg13g2_nand2_1
XFILLER_13_1117 VPWR VGND sg13g2_decap_4
X_23393_ _23393_/Q _23682_/CLK _23393_/D fanout2725/X VPWR VGND sg13g2_dfrbpq_1
XFILLER_52_1166 VPWR VGND sg13g2_decap_8
XFILLER_6_109 VPWR VGND sg13g2_decap_8
XFILLER_109_538 VPWR VGND sg13g2_decap_8
XFILLER_13_1139 VPWR VGND sg13g2_fill_1
X_22344_ _22344_/Y _24159_/Q _22350_/B VPWR VGND sg13g2_nand2_1
XFILLER_12_67 VPWR VGND sg13g2_decap_4
Xoutput4471 data_addr_o[13] _24258_/X VPWR VGND sg13g2_buf_1
Xoutput4482 data_addr_o[24] _24269_/X VPWR VGND sg13g2_buf_1
Xoutput4493 data_addr_o[5] _24250_/X VPWR VGND sg13g2_buf_1
XFILLER_30_1475 VPWR VGND sg13g2_decap_8
X_22275_ _24125_/D _19921_/Y _22276_/B _22274_/Y VPWR VGND sg13g2_o21ai_1
XFILLER_105_711 VPWR VGND sg13g2_decap_8
X_24014_ _24014_/Q clkload36/A _24014_/D fanout2638/X VPWR VGND sg13g2_dfrbpq_1
XFILLER_65_1538 VPWR VGND sg13g2_fill_1
XFILLER_105_788 VPWR VGND sg13g2_decap_8
XFILLER_8_1432 VPWR VGND sg13g2_decap_4
XFILLER_28_1382 VPWR VGND sg13g2_decap_8
X_21088_ _21201_/B _21918_/D _21289_/C VPWR VGND sg13g2_nand2_1
XFILLER_98_1303 VPWR VGND sg13g2_decap_4
XFILLER_19_717 VPWR VGND sg13g2_decap_8
XFILLER_59_886 VPWR VGND sg13g2_decap_8
X_12930_ _13077_/B _12949_/A _15690_/A VPWR VGND sg13g2_xnor2_1
X_20039_ _20040_/C _20039_/A _20117_/C VPWR VGND sg13g2_nor2_1
XFILLER_85_193 VPWR VGND sg13g2_decap_8
X_12861_ _14956_/A _12861_/A _13748_/A _13748_/B VPWR VGND sg13g2_nand3_1
XFILLER_74_867 VPWR VGND sg13g2_decap_4
XFILLER_2_1042 VPWR VGND sg13g2_fill_2
XFILLER_37_97 VPWR VGND sg13g2_fill_2
XFILLER_76_1612 VPWR VGND sg13g2_decap_4
X_14600_ _24223_/D _24223_/Q _14254_/Y hold4636/X VPWR VGND sg13g2_a21o_1
X_11812_ _11818_/D _11812_/A _11812_/B _11812_/C _11812_/D VPWR VGND sg13g2_nor4_1
XFILLER_57_1011 VPWR VGND sg13g2_decap_4
X_15580_ _15580_/Y _22695_/Q _15662_/A2 _15662_/B1 _22631_/Q VPWR VGND sg13g2_a22oi_1
XFILLER_27_794 VPWR VGND sg13g2_fill_1
X_12792_ _12792_/Y _12788_/A _12786_/Y _12791_/Y VPWR VGND sg13g2_o21ai_1
XFILLER_96_1082 VPWR VGND sg13g2_decap_4
XFILLER_37_1629 VPWR VGND sg13g2_fill_2
X_14531_ _14532_/C _24276_/A _14574_/B _14458_/X _24222_/Q _14530_/Y VPWR VGND sg13g2_a221oi_1
X_23729_ _23729_/Q _24113_/CLK _23729_/D fanout2683/X VPWR VGND sg13g2_dfrbpq_1
X_11743_ _11743_/Y _13158_/S _11739_/X _13776_/A1 VPWR VGND sg13g2_o21ai_1
XFILLER_18_1017 VPWR VGND sg13g2_fill_2
XFILLER_14_455 VPWR VGND sg13g2_decap_8
XFILLER_41_241 VPWR VGND sg13g2_decap_8
XFILLER_53_63 VPWR VGND sg13g2_decap_4
XFILLER_14_466 VPWR VGND sg13g2_fill_1
X_17250_ _17250_/Y _22756_/Q _17262_/B VPWR VGND sg13g2_nand2_1
XFILLER_57_1099 VPWR VGND sg13g2_fill_1
XFILLER_54_1954 VPWR VGND sg13g2_fill_1
X_11674_ _11674_/Y _19361_/A _11674_/B VPWR VGND sg13g2_nor2_1
XFILLER_14_499 VPWR VGND sg13g2_fill_2
XFILLER_30_948 VPWR VGND sg13g2_fill_2
XFILLER_15_1927 VPWR VGND sg13g2_decap_8
XFILLER_41_296 VPWR VGND sg13g2_decap_8
X_16201_ _16203_/A _20338_/A _15996_/X _15997_/Y VPWR VGND sg13g2_a21oi_1
X_13413_ _13414_/B _23244_/Q _23276_/Q _23372_/Q _23404_/Q _13578_/S0 _13578_/S1 VPWR
+ VGND sg13g2_mux4_1
X_17181_ _17181_/Y _22739_/Q _17181_/B VPWR VGND sg13g2_xnor2_1
X_14393_ _15268_/B _14591_/A _15216_/B _14434_/B VPWR VGND sg13g2_a21oi_1
XFILLER_70_1277 VPWR VGND sg13g2_fill_2
XFILLER_102_1919 VPWR VGND sg13g2_decap_8
XFILLER_6_610 VPWR VGND sg13g2_fill_1
X_16132_ _16132_/Y _16132_/A _16132_/B VPWR VGND sg13g2_nand2_1
X_13344_ _13344_/Y _13337_/X _13966_/B _13343_/Y VPWR VGND sg13g2_o21ai_1
XFILLER_87_1741 VPWR VGND sg13g2_decap_8
X_16063_ _16063_/Y _16063_/A _16071_/B VPWR VGND sg13g2_nor2_1
XFILLER_5_153 VPWR VGND sg13g2_decap_8
X_13275_ _13275_/X _23722_/Q _23754_/Q _23786_/Q _23818_/Q _13275_/S0 _12570_/S VPWR
+ VGND sg13g2_mux4_1
X_15014_ _15016_/A _22503_/Q _14998_/B _15075_/B1 _22931_/Q VPWR VGND sg13g2_a22oi_1
XFILLER_87_1785 VPWR VGND sg13g2_decap_8
XFILLER_83_1616 VPWR VGND sg13g2_decap_4
X_12226_ _12227_/B _23293_/Q _23325_/Q _12248_/S VPWR VGND sg13g2_mux2_1
XFILLER_83_1627 VPWR VGND sg13g2_decap_8
XFILLER_64_1004 VPWR VGND sg13g2_decap_8
X_19822_ _19822_/X _19932_/A _19822_/B VPWR VGND sg13g2_and2_1
X_12157_ _12157_/X _24156_/Q _24188_/Q _23228_/Q _23260_/Q _11904_/B _11427_/B VPWR
+ VGND sg13g2_mux4_1
XFILLER_78_60 VPWR VGND sg13g2_fill_1
Xfanout2830 fanout2830/X fanout2831/X VPWR VGND sg13g2_buf_1
Xfanout2841 fanout2841/X fanout2845/X VPWR VGND sg13g2_buf_1
XFILLER_96_425 VPWR VGND sg13g2_decap_8
Xfanout2852 fanout2852/X fanout2854/X VPWR VGND sg13g2_buf_1
XFILLER_68_127 VPWR VGND sg13g2_decap_4
XFILLER_110_224 VPWR VGND sg13g2_decap_8
Xfanout2863 fanout2863/X fanout2865/X VPWR VGND sg13g2_buf_1
XFILLER_111_758 VPWR VGND sg13g2_decap_8
Xfanout2874 fanout2874/X fanout2877/X VPWR VGND sg13g2_buf_1
XFILLER_110_235 VPWR VGND sg13g2_fill_2
Xfanout2885 fanout2885/X fanout2886/X VPWR VGND sg13g2_buf_1
X_12088_ _19803_/A _12088_/A VPWR VGND sg13g2_inv_1
X_19753_ _19753_/Y _19753_/A _19857_/B VPWR VGND sg13g2_nand2_1
X_16965_ _16966_/B _22702_/Q _16975_/A VPWR VGND sg13g2_nand2_1
XFILLER_84_609 VPWR VGND sg13g2_fill_2
Xfanout2896 fanout2896/X fanout2897/X VPWR VGND sg13g2_buf_1
XFILLER_42_1335 VPWR VGND sg13g2_decap_8
XFILLER_77_650 VPWR VGND sg13g2_decap_8
XFILLER_49_352 VPWR VGND sg13g2_fill_1
X_18704_ _18704_/Y _15779_/Y _18700_/A _15022_/A VPWR VGND sg13g2_o21ai_1
X_15916_ _16189_/A _23025_/Q _22575_/Q _15982_/S VPWR VGND sg13g2_mux2_1
X_19684_ _19684_/Y _19850_/A _19684_/B VPWR VGND sg13g2_nor2_1
X_16896_ _16907_/D _22689_/Q _22688_/Q _22687_/Q VPWR VGND sg13g2_and3_1
XFILLER_4_1830 VPWR VGND sg13g2_decap_8
XFILLER_92_620 VPWR VGND sg13g2_decap_8
XFILLER_49_385 VPWR VGND sg13g2_decap_4
XFILLER_64_311 VPWR VGND sg13g2_decap_8
XFILLER_76_182 VPWR VGND sg13g2_decap_4
X_18635_ _18636_/B _24253_/A _18635_/A2 _14888_/Y VPWR VGND sg13g2_a21oi_1
XFILLER_37_547 VPWR VGND sg13g2_decap_8
XFILLER_76_193 VPWR VGND sg13g2_decap_8
XFILLER_20_1633 VPWR VGND sg13g2_decap_8
X_15847_ _15847_/Y _15936_/S _16171_/A VPWR VGND sg13g2_nor2_1
XFILLER_64_344 VPWR VGND sg13g2_decap_8
XFILLER_59_1832 VPWR VGND sg13g2_decap_8
XFILLER_91_163 VPWR VGND sg13g2_fill_2
XFILLER_111_1794 VPWR VGND sg13g2_decap_8
XFILLER_0_1749 VPWR VGND sg13g2_decap_4
X_18566_ _22995_/D _18565_/B _18564_/Y _18565_/Y VPWR VGND sg13g2_o21ai_1
XFILLER_52_528 VPWR VGND sg13g2_decap_8
X_15778_ _15778_/Y _15935_/S _17164_/A _15777_/Y VPWR VGND sg13g2_o21ai_1
XFILLER_91_185 VPWR VGND sg13g2_fill_2
XFILLER_80_859 VPWR VGND sg13g2_decap_8
XFILLER_18_794 VPWR VGND sg13g2_decap_8
XFILLER_33_731 VPWR VGND sg13g2_decap_8
X_17517_ _17518_/B _17835_/B _17517_/B _17517_/C _17517_/D VPWR VGND sg13g2_nand4_1
X_14729_ _14729_/X _14673_/Y _14671_/Y _14729_/S VPWR VGND sg13g2_mux2_1
X_18497_ _18497_/Y _18531_/A _18497_/B _18497_/C VPWR VGND sg13g2_nand3_1
XFILLER_36_1128 VPWR VGND sg13g2_fill_1
XFILLER_18_1540 VPWR VGND sg13g2_decap_8
X_17448_ _22842_/D _16050_/A _17467_/B _17447_/Y VPWR VGND sg13g2_o21ai_1
XFILLER_92_1491 VPWR VGND sg13g2_decap_4
XFILLER_53_1442 VPWR VGND sg13g2_decap_8
Xrebuffer5415 _14043_/A2 rebuffer5424/X VPWR VGND sg13g2_buf_1
Xplace3702 _19773_/A _15319_/A VPWR VGND sg13g2_buf_1
XFILLER_20_458 VPWR VGND sg13g2_fill_1
Xrebuffer5426 _11750_/A _11854_/A VPWR VGND sg13g2_buf_1
X_17379_ _17379_/Y _17388_/B _17379_/B VPWR VGND sg13g2_nand2_1
Xrebuffer5437 _12746_/A2 _13035_/A2 VPWR VGND sg13g2_buf_1
Xplace3713 _20085_/A _15669_/A VPWR VGND sg13g2_buf_1
Xplace3724 _12088_/A _19801_/A VPWR VGND sg13g2_buf_2
Xrebuffer5448 _13345_/A _13344_/Y VPWR VGND sg13g2_buf_2
XFILLER_71_0 VPWR VGND sg13g2_decap_8
Xplace3735 _20335_/A _20294_/A VPWR VGND sg13g2_buf_1
X_19118_ _23096_/D _23096_/Q _19118_/A1 _19130_/S VPWR VGND sg13g2_mux2_1
Xrebuffer5459 _13145_/A place3976/A VPWR VGND sg13g2_buf_1
Xplace3746 _19460_/B _19463_/S VPWR VGND sg13g2_buf_1
Xplace3757 _15165_/C _15140_/A VPWR VGND sg13g2_buf_1
X_20390_ _20390_/Y _23260_/Q _20395_/B VPWR VGND sg13g2_nand2_1
Xplace3768 _12429_/A _12340_/A VPWR VGND sg13g2_buf_1
Xhold5105 _22111_/A _24048_/Q VPWR VGND sg13g2_dlygate4sd3_1
Xhold5116 _21566_/A _23799_/Q VPWR VGND sg13g2_dlygate4sd3_1
XFILLER_88_1549 VPWR VGND sg13g2_fill_1
Xplace3779 _12759_/A _12852_/A VPWR VGND sg13g2_buf_1
Xhold5127 _19691_/A _23223_/Q VPWR VGND sg13g2_dlygate4sd3_1
X_19049_ _23061_/D _19043_/Y _19046_/Y _19047_/Y _19048_/Y VPWR VGND sg13g2_a22oi_1
Xhold5138 _22105_/A _24044_/Q VPWR VGND sg13g2_dlygate4sd3_1
XFILLER_86_1240 VPWR VGND sg13g2_decap_8
Xhold5149 _21982_/A _23988_/Q VPWR VGND sg13g2_dlygate4sd3_1
XFILLER_12_1194 VPWR VGND sg13g2_fill_1
X_22060_ _22060_/Y _22060_/A _22069_/B VPWR VGND sg13g2_nand2_1
XFILLER_47_1213 VPWR VGND sg13g2_decap_4
XFILLER_66_1836 VPWR VGND sg13g2_fill_1
XFILLER_82_1104 VPWR VGND sg13g2_decap_8
X_21011_ _23545_/D _22266_/A1 _21019_/B _21010_/Y VPWR VGND sg13g2_o21ai_1
XFILLER_0_819 VPWR VGND sg13g2_fill_1
XFILLER_114_585 VPWR VGND sg13g2_decap_8
XFILLER_99_274 VPWR VGND sg13g2_fill_2
XFILLER_47_1268 VPWR VGND sg13g2_fill_2
XFILLER_82_1159 VPWR VGND sg13g2_decap_8
XFILLER_59_127 VPWR VGND sg13g2_decap_8
XFILLER_29_1691 VPWR VGND sg13g2_decap_8
XFILLER_114_14 VPWR VGND sg13g2_decap_8
XFILLER_5_1627 VPWR VGND sg13g2_decap_8
XFILLER_56_801 VPWR VGND sg13g2_fill_2
XFILLER_112_1514 VPWR VGND sg13g2_fill_2
XFILLER_5_1638 VPWR VGND sg13g2_fill_1
X_22962_ _22962_/Q _23187_/CLK _22962_/D fanout2916/X VPWR VGND sg13g2_dfrbpq_1
XFILLER_110_780 VPWR VGND sg13g2_decap_8
XFILLER_25_1588 VPWR VGND sg13g2_decap_8
XFILLER_74_29 VPWR VGND sg13g2_decap_8
X_21913_ _21913_/Y _23954_/Q _21916_/B VPWR VGND sg13g2_nand2_1
XFILLER_77_1910 VPWR VGND sg13g2_decap_8
X_22893_ _22893_/Q _22893_/CLK _22893_/D fanout2820/X VPWR VGND sg13g2_dfrbpq_1
XFILLER_71_804 VPWR VGND sg13g2_fill_1
XFILLER_77_1921 VPWR VGND sg13g2_decap_8
XFILLER_83_686 VPWR VGND sg13g2_fill_2
XFILLER_15_219 VPWR VGND sg13g2_decap_8
XFILLER_82_174 VPWR VGND sg13g2_decap_8
X_21844_ _23920_/D _22311_/A1 _21843_/B _21843_/Y VPWR VGND sg13g2_o21ai_1
XFILLER_58_1331 VPWR VGND sg13g2_decap_8
XFILLER_70_314 VPWR VGND sg13g2_fill_1
XFILLER_71_848 VPWR VGND sg13g2_decap_8
XFILLER_97_1391 VPWR VGND sg13g2_fill_2
XFILLER_24_742 VPWR VGND sg13g2_decap_8
X_21775_ _21775_/Y _21775_/A _21783_/B VPWR VGND sg13g2_nand2_1
XFILLER_93_1266 VPWR VGND sg13g2_decap_8
Xinput4358 _14966_/A boot_addr_i[16] VPWR VGND sg13g2_buf_1
XFILLER_19_1348 VPWR VGND sg13g2_decap_8
Xinput4369 _17918_/A1 boot_addr_i[27] VPWR VGND sg13g2_buf_1
X_20726_ _23414_/D _20929_/A1 _20727_/B _20725_/Y VPWR VGND sg13g2_o21ai_1
X_23514_ _23514_/Q clkload55/A _23514_/D fanout2780/X VPWR VGND sg13g2_dfrbpq_1
XFILLER_23_263 VPWR VGND sg13g2_fill_2
XFILLER_51_572 VPWR VGND sg13g2_decap_4
XFILLER_93_1299 VPWR VGND sg13g2_fill_1
XFILLER_71_1520 VPWR VGND sg13g2_fill_2
X_23445_ _23445_/Q clkload57/A _23445_/D fanout2762/X VPWR VGND sg13g2_dfrbpq_1
X_20657_ _23382_/D _20929_/A1 _20666_/B _20656_/Y VPWR VGND sg13g2_o21ai_1
XFILLER_109_335 VPWR VGND sg13g2_decap_8
X_11390_ _11390_/X _11390_/A _11390_/B VPWR VGND sg13g2_or2_1
X_23376_ _23376_/Q _24214_/CLK _23376_/D fanout2626/X VPWR VGND sg13g2_dfrbpq_1
X_20588_ _20588_/Y _20588_/A _20646_/S VPWR VGND sg13g2_nand2_1
XFILLER_10_1802 VPWR VGND sg13g2_decap_8
XFILLER_87_1037 VPWR VGND sg13g2_decap_8
X_22327_ _24151_/D _19688_/Y _22335_/B _22326_/Y VPWR VGND sg13g2_o21ai_1
XFILLER_84_1925 VPWR VGND sg13g2_decap_8
X_13060_ _13067_/B _20132_/A _15714_/A VPWR VGND sg13g2_nand2_1
XFILLER_105_530 VPWR VGND sg13g2_decap_8
X_22258_ _24117_/D _22258_/A1 _22263_/B _22257_/Y VPWR VGND sg13g2_o21ai_1
XFILLER_10_1879 VPWR VGND sg13g2_decap_8
X_12011_ _12012_/B _24187_/Q _23323_/Q _12015_/S VPWR VGND sg13g2_mux2_1
XFILLER_79_926 VPWR VGND sg13g2_fill_1
X_21209_ _21209_/Y _21209_/A _21209_/B VPWR VGND sg13g2_nand2_1
XFILLER_79_937 VPWR VGND sg13g2_decap_8
Xhold4960 _22034_/A _24011_/Q VPWR VGND sg13g2_dlygate4sd3_1
Xhold4971 _21010_/A _23545_/Q VPWR VGND sg13g2_dlygate4sd3_1
Xhold4982 _22369_/A _24171_/Q VPWR VGND sg13g2_dlygate4sd3_1
XFILLER_2_189 VPWR VGND sg13g2_decap_8
Xhold4993 _21881_/A _23936_/Q VPWR VGND sg13g2_dlygate4sd3_1
XFILLER_47_1791 VPWR VGND sg13g2_fill_1
XFILLER_24_1021 VPWR VGND sg13g2_decap_4
X_16750_ _16751_/B _22665_/Q _16750_/B VPWR VGND sg13g2_xnor2_1
X_13962_ _13962_/X _23444_/Q _23476_/Q _23508_/Q _23540_/Q _13962_/S0 _13964_/S1 VPWR
+ VGND sg13g2_mux4_1
XFILLER_58_171 VPWR VGND sg13g2_fill_1
X_12913_ _12913_/X _23301_/Q _23333_/Q _23365_/Q _23397_/Q _12802_/B _12709_/A VPWR
+ VGND sg13g2_mux4_1
XFILLER_21_1931 VPWR VGND sg13g2_decap_8
X_16681_ _16681_/Y _16681_/A _16681_/B _16681_/C VPWR VGND sg13g2_nand3_1
X_13893_ _13896_/A _13887_/X _13890_/Y _13891_/X _13892_/X _13794_/S _13141_/B VPWR
+ VGND sg13g2_mux4_1
XFILLER_46_355 VPWR VGND sg13g2_decap_4
XFILLER_73_141 VPWR VGND sg13g2_fill_2
XFILLER_74_675 VPWR VGND sg13g2_decap_8
X_18420_ _18420_/Y _18425_/A _18404_/B _18421_/B _18451_/C VPWR VGND sg13g2_a22oi_1
XFILLER_104_91 VPWR VGND sg13g2_decap_8
X_15632_ _15632_/Y _16000_/S _17124_/A _15631_/Y VPWR VGND sg13g2_o21ai_1
XFILLER_59_1139 VPWR VGND sg13g2_decap_8
XFILLER_73_163 VPWR VGND sg13g2_decap_4
X_12844_ _12847_/B _12830_/Y _12832_/Y _12843_/Y VPWR VGND sg13g2_a21oi_1
XFILLER_73_174 VPWR VGND sg13g2_decap_8
XFILLER_15_720 VPWR VGND sg13g2_decap_8
XFILLER_46_399 VPWR VGND sg13g2_decap_8
XFILLER_27_580 VPWR VGND sg13g2_decap_8
XFILLER_27_591 VPWR VGND sg13g2_fill_1
X_18351_ _18544_/A _18351_/A _18351_/B VPWR VGND sg13g2_nand2_1
X_15563_ _15563_/Y _15562_/Y _15996_/A VPWR VGND sg13g2_nand2b_1
X_12775_ _12778_/B _12771_/X _12772_/Y _12773_/X _12774_/Y VPWR VGND sg13g2_a22oi_1
XFILLER_15_775 VPWR VGND sg13g2_decap_4
XFILLER_9_24 VPWR VGND sg13g2_fill_2
X_17302_ _22781_/D _17929_/B2 _22781_/Q _17302_/S VPWR VGND sg13g2_mux2_1
XFILLER_72_1328 VPWR VGND sg13g2_fill_1
X_14514_ _14518_/A _22616_/Q _23027_/Q VPWR VGND sg13g2_xnor2_1
X_11726_ _11726_/X _23544_/Q _23992_/Q _11726_/S VPWR VGND sg13g2_mux2_1
X_18282_ _18282_/Y _18361_/B _18494_/A _18280_/Y _18553_/A1 _18281_/Y VPWR VGND sg13g2_a221oi_1
XFILLER_9_57 VPWR VGND sg13g2_decap_8
X_17233_ _22749_/D _15204_/Y _14882_/B _17527_/A _15599_/Y _17232_/Y VPWR VGND sg13g2_a221oi_1
X_14445_ _14446_/B _24238_/Q _14445_/B _16856_/B VPWR VGND sg13g2_nor3_1
X_11657_ _11657_/X _15165_/B _14021_/B _14028_/B VPWR VGND sg13g2_a21o_1
XFILLER_30_778 VPWR VGND sg13g2_fill_2
Xplace3009 _22315_/S _22263_/B VPWR VGND sg13g2_buf_1
XFILLER_35_1172 VPWR VGND sg13g2_decap_8
XFILLER_106_1874 VPWR VGND sg13g2_decap_8
XFILLER_102_1705 VPWR VGND sg13g2_decap_8
XFILLER_11_981 VPWR VGND sg13g2_fill_2
X_17164_ _17164_/Y _17164_/A _17182_/B VPWR VGND sg13g2_nor2_1
X_14376_ _14377_/D _16776_/B _15191_/B _16439_/A VPWR VGND sg13g2_nand3_1
XFILLER_102_1738 VPWR VGND sg13g2_fill_1
X_11588_ _11589_/B _14434_/A _11571_/B _15216_/A VPWR VGND sg13g2_a21oi_1
XFILLER_89_1858 VPWR VGND sg13g2_fill_1
XFILLER_31_1069 VPWR VGND sg13g2_decap_8
X_16115_ _16115_/Y _17878_/A _16203_/B VPWR VGND sg13g2_nor2_1
X_13327_ _13327_/Y _23178_/Q _13988_/A2 _13988_/B1 _13326_/Y VPWR VGND sg13g2_a22oi_1
X_17095_ _17110_/B _22723_/Q _17095_/B VPWR VGND sg13g2_nand2_1
XFILLER_6_484 VPWR VGND sg13g2_fill_1
XFILLER_100_1451 VPWR VGND sg13g2_decap_8
X_16046_ _16046_/Y _16046_/A _16060_/B VPWR VGND sg13g2_nand2_1
X_13258_ _13258_/Y _13259_/B _23434_/Q _13257_/Y VPWR VGND sg13g2_o21ai_1
X_12209_ _12219_/A _12209_/A _12209_/B _12209_/C _12209_/D VPWR VGND sg13g2_nor4_1
XFILLER_96_200 VPWR VGND sg13g2_fill_1
XFILLER_69_414 VPWR VGND sg13g2_fill_2
XFILLER_97_734 VPWR VGND sg13g2_decap_8
X_13189_ _13189_/Y _23913_/Q _13798_/A2 _13188_/X _13961_/S0 VPWR VGND sg13g2_a22oi_1
XFILLER_44_1419 VPWR VGND sg13g2_fill_2
Xfanout2660 fanout2660/X fanout2668/X VPWR VGND sg13g2_buf_1
X_19805_ _19806_/B _12104_/B _19801_/Y _19802_/Y _19803_/Y _19804_/Y VPWR VGND sg13g2_a221oi_1
XFILLER_6_1903 VPWR VGND sg13g2_decap_8
Xfanout2671 fanout2671/X fanout2672/X VPWR VGND sg13g2_buf_1
XFILLER_113_1801 VPWR VGND sg13g2_decap_8
XFILLER_111_555 VPWR VGND sg13g2_decap_8
Xfanout2682 fanout2682/X fanout2685/X VPWR VGND sg13g2_buf_1
Xfanout2693 fanout2693/X fanout2792/X VPWR VGND sg13g2_buf_1
X_16948_ _16948_/Y _22700_/Q _16948_/B VPWR VGND sg13g2_xnor2_1
X_19736_ _19737_/A _20005_/A _19734_/Y _19735_/Y VPWR VGND sg13g2_o21ai_1
XFILLER_26_1897 VPWR VGND sg13g2_fill_1
XFILLER_42_1165 VPWR VGND sg13g2_decap_8
XFILLER_61_1788 VPWR VGND sg13g2_decap_4
XFILLER_42_1176 VPWR VGND sg13g2_fill_2
XFILLER_113_1878 VPWR VGND sg13g2_decap_8
XFILLER_93_962 VPWR VGND sg13g2_decap_8
X_16879_ _16879_/Y _16879_/A _17032_/B VPWR VGND sg13g2_nand2_1
XFILLER_38_878 VPWR VGND sg13g2_decap_8
XFILLER_64_130 VPWR VGND sg13g2_decap_4
XFILLER_77_1217 VPWR VGND sg13g2_fill_1
XFILLER_92_461 VPWR VGND sg13g2_decap_8
XFILLER_25_517 VPWR VGND sg13g2_decap_4
X_18618_ _18618_/Y _18623_/A _18626_/A _14828_/A VPWR VGND sg13g2_o21ai_1
XFILLER_52_325 VPWR VGND sg13g2_decap_4
X_18549_ _18549_/X _17992_/X _18860_/B _18549_/S VPWR VGND sg13g2_mux2_1
XFILLER_59_1684 VPWR VGND sg13g2_fill_2
XFILLER_90_1428 VPWR VGND sg13g2_decap_8
XFILLER_100_49 VPWR VGND sg13g2_decap_8
Xplace4200 _13028_/A _13274_/S0 VPWR VGND sg13g2_buf_2
Xplace4211 _12978_/S0 _13275_/S0 VPWR VGND sg13g2_buf_2
X_20511_ _23315_/D _23315_/Q _22449_/A1 _20511_/S VPWR VGND sg13g2_mux2_1
XFILLER_21_767 VPWR VGND sg13g2_decap_8
XFILLER_72_1873 VPWR VGND sg13g2_decap_8
Xplace4222 _12175_/B _13008_/B VPWR VGND sg13g2_buf_2
Xrebuffer5212 _19953_/B _19955_/B VPWR VGND sg13g2_buf_4
Xplace4233 _13582_/A _12443_/A VPWR VGND sg13g2_buf_1
X_21491_ _21555_/B _22186_/A _21557_/B VPWR VGND sg13g2_nand2_1
Xrebuffer5223 _15436_/A _19801_/A VPWR VGND sg13g2_buf_1
Xplace4244 _13911_/B2 _13111_/A VPWR VGND sg13g2_buf_1
XFILLER_14_1223 VPWR VGND sg13g2_decap_8
Xrebuffer5234 _11732_/B _11731_/Y VPWR VGND sg13g2_buf_2
XFILLER_18_1392 VPWR VGND sg13g2_decap_8
Xplace4255 _12816_/A _13983_/S1 VPWR VGND sg13g2_buf_2
Xplace3510 _24253_/A _14890_/B2 VPWR VGND sg13g2_buf_2
Xplace4266 _12171_/S1 _11538_/S1 VPWR VGND sg13g2_buf_1
Xplace3521 _16004_/B1 _15359_/Y VPWR VGND sg13g2_buf_1
X_23230_ _23230_/Q _24190_/CLK _23230_/D fanout2773/X VPWR VGND sg13g2_dfrbpq_1
XFILLER_33_1868 VPWR VGND sg13g2_fill_1
Xrebuffer5245 _14399_/C _16036_/A VPWR VGND sg13g2_buf_1
Xrebuffer5256 _13576_/A1 _12039_/Y VPWR VGND sg13g2_buf_1
Xplace3532 _15970_/A2 _15945_/A2 VPWR VGND sg13g2_buf_1
Xplace4277 _13589_/B _13591_/B VPWR VGND sg13g2_buf_2
Xclkbuf_leaf_41_clk_i clkload44/A clkload2/A VPWR VGND sg13g2_buf_16
XFILLER_109_14 VPWR VGND sg13g2_decap_8
Xrebuffer5267 _13906_/A2 _13903_/Y VPWR VGND sg13g2_buf_2
Xplace4288 _13610_/S0 _13606_/S0 VPWR VGND sg13g2_buf_4
Xplace3543 _15986_/C1 _15319_/Y VPWR VGND sg13g2_buf_1
Xplace3554 _15897_/A2 _15924_/B VPWR VGND sg13g2_buf_1
Xplace4299 _12802_/B _13243_/S0 VPWR VGND sg13g2_buf_2
Xrebuffer5278 _12298_/A place3978/A VPWR VGND sg13g2_buf_1
Xplace3565 _12531_/B _12968_/B VPWR VGND sg13g2_buf_1
Xrebuffer5289 _19902_/A1 _12340_/C VPWR VGND sg13g2_buf_1
XFILLER_14_1278 VPWR VGND sg13g2_decap_8
Xplace3576 _17056_/C _15325_/Y VPWR VGND sg13g2_buf_1
XFILLER_14_1289 VPWR VGND sg13g2_decap_8
X_23161_ _23161_/Q clkload17/A _23161_/D fanout2857/X VPWR VGND sg13g2_dfrbpq_1
XFILLER_31_1570 VPWR VGND sg13g2_fill_1
Xplace3587 _19869_/A _19760_/A VPWR VGND sg13g2_buf_1
Xplace3598 _17810_/B1 _17824_/B1 VPWR VGND sg13g2_buf_1
Xrebuffer4577 _14691_/A _11497_/B2 VPWR VGND sg13g2_buf_1
X_22112_ _24048_/D _22311_/A1 _22117_/B _22111_/Y VPWR VGND sg13g2_o21ai_1
Xrebuffer4588 _13086_/B _13526_/B VPWR VGND sg13g2_buf_1
Xrebuffer4599 _14711_/A1 _12694_/B VPWR VGND sg13g2_buf_1
X_23092_ _23092_/Q _23215_/CLK _23092_/D fanout2924/X VPWR VGND sg13g2_dfrbpq_1
Xclkbuf_leaf_56_clk_i clkload33/A clkbuf_4_8__f_clk_i/X VPWR VGND sg13g2_buf_16
XFILLER_47_1032 VPWR VGND sg13g2_decap_8
X_22043_ _24016_/D _22311_/A1 _22048_/B _22042_/Y VPWR VGND sg13g2_o21ai_1
XFILLER_47_1043 VPWR VGND sg13g2_fill_2
XFILLER_115_894 VPWR VGND sg13g2_decap_8
XFILLER_27_1628 VPWR VGND sg13g2_fill_2
XFILLER_87_222 VPWR VGND sg13g2_decap_8
XFILLER_102_533 VPWR VGND sg13g2_decap_8
XFILLER_76_907 VPWR VGND sg13g2_fill_1
XFILLER_112_1300 VPWR VGND sg13g2_decap_8
XFILLER_85_39 VPWR VGND sg13g2_decap_4
XFILLER_47_108 VPWR VGND sg13g2_decap_8
XFILLER_99_1420 VPWR VGND sg13g2_decap_8
X_23994_ _23994_/Q clkload48/A _23994_/D fanout2686/X VPWR VGND sg13g2_dfrbpq_1
XFILLER_28_311 VPWR VGND sg13g2_decap_8
XFILLER_56_620 VPWR VGND sg13g2_decap_8
X_22945_ _22945_/Q clkload17/A _22945_/D fanout2846/X VPWR VGND sg13g2_dfrbpq_1
XFILLER_28_344 VPWR VGND sg13g2_decap_8
XFILLER_56_675 VPWR VGND sg13g2_decap_4
XFILLER_16_517 VPWR VGND sg13g2_decap_8
XFILLER_43_314 VPWR VGND sg13g2_decap_4
XFILLER_77_1740 VPWR VGND sg13g2_fill_2
XFILLER_55_185 VPWR VGND sg13g2_fill_2
X_22876_ _22876_/Q clkload28/A _22876_/D fanout2897/X VPWR VGND sg13g2_dfrbpq_1
XFILLER_55_196 VPWR VGND sg13g2_decap_4
XFILLER_38_1713 VPWR VGND sg13g2_decap_4
XFILLER_43_358 VPWR VGND sg13g2_fill_2
X_21827_ _23910_/D _22294_/A1 _21826_/B _21826_/Y VPWR VGND sg13g2_o21ai_1
XFILLER_70_155 VPWR VGND sg13g2_fill_2
XFILLER_52_870 VPWR VGND sg13g2_fill_2
XFILLER_12_712 VPWR VGND sg13g2_decap_4
XFILLER_24_583 VPWR VGND sg13g2_decap_8
X_12560_ _12561_/C _23425_/Q _23489_/Q _23585_/Q _23649_/Q _12478_/S _12377_/S VPWR
+ VGND sg13g2_mux4_1
X_21758_ _23880_/D _23880_/Q _21898_/A0 _21781_/S VPWR VGND sg13g2_mux2_1
XFILLER_106_1115 VPWR VGND sg13g2_decap_4
XFILLER_19_1178 VPWR VGND sg13g2_decap_8
XFILLER_19_1189 VPWR VGND sg13g2_fill_2
X_20709_ _23409_/D _22246_/A0 _23409_/Q _20712_/S VPWR VGND sg13g2_mux2_1
XFILLER_12_767 VPWR VGND sg13g2_fill_1
XFILLER_7_204 VPWR VGND sg13g2_fill_2
X_12491_ _12491_/X _23552_/Q _24000_/Q _22985_/Q VPWR VGND sg13g2_mux2_1
X_21689_ _23859_/D _23859_/Q _21781_/A1 _21689_/S VPWR VGND sg13g2_mux2_1
XFILLER_32_1323 VPWR VGND sg13g2_decap_4
XFILLER_71_1372 VPWR VGND sg13g2_decap_4
XFILLER_11_277 VPWR VGND sg13g2_decap_8
X_14230_ _14861_/A _22877_/Q _16438_/B _24224_/Q VPWR VGND sg13g2_nand3_1
X_23428_ _23428_/Q _24196_/CLK _23428_/D fanout2702/X VPWR VGND sg13g2_dfrbpq_1
X_11442_ _13987_/B _11442_/A _11736_/A VPWR VGND sg13g2_nand2_1
XFILLER_50_53 VPWR VGND sg13g2_fill_1
XFILLER_109_154 VPWR VGND sg13g2_decap_8
XFILLER_10_1610 VPWR VGND sg13g2_fill_2
Xclkbuf_3_7_0_clk_i clkbuf_3_7_0_clk_i/X clkbuf_0_clk_i/X VPWR VGND sg13g2_buf_16
XFILLER_32_1389 VPWR VGND sg13g2_decap_8
X_14161_ _14161_/Y _19545_/A _14068_/X _17039_/B VPWR VGND sg13g2_a21oi_1
X_23359_ _23359_/Q _23682_/CLK _23359_/D fanout2725/X VPWR VGND sg13g2_dfrbpq_1
XFILLER_4_944 VPWR VGND sg13g2_decap_8
X_13112_ _13112_/Y _13120_/A _13109_/X _13111_/X VPWR VGND sg13g2_a21oi_1
XFILLER_101_1771 VPWR VGND sg13g2_fill_1
X_14092_ _14093_/B _14594_/A _11594_/B _14107_/A VPWR VGND sg13g2_a21oi_1
XFILLER_106_850 VPWR VGND sg13g2_fill_1
XFILLER_1_0 VPWR VGND sg13g2_decap_8
XFILLER_112_319 VPWR VGND sg13g2_decap_8
X_17920_ _17922_/A _17920_/A1 _17929_/A2 _17920_/B1 _17920_/B2 VPWR VGND sg13g2_a22oi_1
X_13043_ _13043_/Y _13042_/A _13040_/Y _13042_/Y VPWR VGND sg13g2_o21ai_1
XFILLER_61_1018 VPWR VGND sg13g2_fill_2
XFILLER_65_1187 VPWR VGND sg13g2_decap_8
X_17851_ _17851_/Y _22916_/Q _17853_/B _17869_/B VPWR VGND sg13g2_nand3_1
Xhold4790 _22142_/A _24062_/Q VPWR VGND sg13g2_dlygate4sd3_1
XFILLER_79_778 VPWR VGND sg13g2_decap_8
XFILLER_79_789 VPWR VGND sg13g2_fill_2
X_16802_ _16803_/B _16802_/A _16833_/A VPWR VGND sg13g2_nor2_1
X_17782_ _17782_/Y _22903_/Q _17811_/B VPWR VGND sg13g2_nor2_1
XFILLER_93_225 VPWR VGND sg13g2_decap_8
XFILLER_93_236 VPWR VGND sg13g2_fill_1
XFILLER_75_940 VPWR VGND sg13g2_decap_8
X_16733_ _16734_/D _22661_/Q _22660_/Q _22659_/Q _22658_/Q VPWR VGND sg13g2_and4_1
X_19521_ _19521_/Y _19471_/Y _19474_/X _19520_/Y VPWR VGND sg13g2_a21oi_1
XFILLER_46_130 VPWR VGND sg13g2_decap_8
X_13945_ _13952_/A _13937_/Y _13939_/Y _13944_/Y VPWR VGND sg13g2_a21oi_1
XFILLER_93_269 VPWR VGND sg13g2_fill_2
XFILLER_47_664 VPWR VGND sg13g2_fill_1
XFILLER_1_1811 VPWR VGND sg13g2_decap_8
XFILLER_47_675 VPWR VGND sg13g2_fill_2
XFILLER_75_83 VPWR VGND sg13g2_decap_4
X_19452_ _19756_/B _19703_/A _19644_/B _19451_/Y VPWR VGND sg13g2_a21oi_1
X_16664_ _16665_/B _22647_/Q _16671_/D VPWR VGND sg13g2_nand2_1
XFILLER_19_388 VPWR VGND sg13g2_decap_4
XFILLER_19_399 VPWR VGND sg13g2_fill_1
X_13876_ _13938_/B _13876_/A _13876_/B VPWR VGND sg13g2_and2_1
XFILLER_74_494 VPWR VGND sg13g2_fill_1
XFILLER_35_859 VPWR VGND sg13g2_decap_8
XFILLER_61_111 VPWR VGND sg13g2_decap_8
X_18403_ _18403_/Y _18403_/A _18403_/B VPWR VGND sg13g2_nand2_1
X_15615_ _15617_/A _22853_/Q _16005_/B _15684_/B _22891_/Q VPWR VGND sg13g2_a22oi_1
XFILLER_1_1888 VPWR VGND sg13g2_decap_8
X_12827_ _12863_/B _12934_/A _20087_/B VPWR VGND sg13g2_xnor2_1
XFILLER_76_1250 VPWR VGND sg13g2_fill_1
X_16595_ _16604_/C _16654_/B _16638_/B VPWR VGND sg13g2_and2_1
XFILLER_50_818 VPWR VGND sg13g2_fill_2
XFILLER_90_998 VPWR VGND sg13g2_decap_8
XFILLER_56_1846 VPWR VGND sg13g2_fill_1
XFILLER_108_1925 VPWR VGND sg13g2_decap_8
XFILLER_91_60 VPWR VGND sg13g2_decap_8
X_18334_ _18334_/Y _18334_/A _18334_/B _18334_/C VPWR VGND sg13g2_nor3_1
XFILLER_76_1283 VPWR VGND sg13g2_fill_1
XFILLER_91_1748 VPWR VGND sg13g2_decap_8
XFILLER_15_583 VPWR VGND sg13g2_decap_8
X_15546_ _15546_/Y _22557_/Q _15633_/S VPWR VGND sg13g2_nand2_1
XFILLER_61_199 VPWR VGND sg13g2_decap_4
X_12758_ _12761_/B _12756_/Y _12757_/Y _12766_/A VPWR VGND sg13g2_o21ai_1
XFILLER_30_553 VPWR VGND sg13g2_fill_2
X_18265_ _18265_/Y _18253_/B _18290_/A _18264_/Y VPWR VGND sg13g2_o21ai_1
X_15477_ _15481_/B _22547_/Q _16334_/A VPWR VGND sg13g2_nand2_1
X_12689_ _12690_/B _23298_/Q _23330_/Q _23362_/Q _23394_/Q _13274_/S0 _13260_/A1 VPWR
+ VGND sg13g2_mux4_1
XFILLER_54_1581 VPWR VGND sg13g2_fill_2
XFILLER_50_1434 VPWR VGND sg13g2_fill_2
X_17216_ _22745_/D _17226_/A _17214_/Y _17215_/Y VPWR VGND sg13g2_a21oi_1
X_14428_ _14429_/B _14428_/A _19545_/A _14585_/B VPWR VGND sg13g2_nand3_1
X_18196_ _18197_/B _18196_/A _18274_/B VPWR VGND sg13g2_nor2_1
X_17147_ _17147_/Y _17147_/A _17220_/B VPWR VGND sg13g2_nor2_1
X_14359_ _15187_/C _17034_/A _17391_/A _14359_/C _14372_/C VPWR VGND sg13g2_nand4_1
XFILLER_89_1677 VPWR VGND sg13g2_decap_4
X_17078_ _17079_/B _17090_/A _17083_/B _17083_/C VPWR VGND sg13g2_nor3_1
XFILLER_115_168 VPWR VGND sg13g2_decap_8
X_16029_ _16029_/Y _16029_/A _16029_/B VPWR VGND sg13g2_nand2_1
XFILLER_112_831 VPWR VGND sg13g2_decap_8
XFILLER_34_0 VPWR VGND sg13g2_decap_8
XFILLER_97_564 VPWR VGND sg13g2_decap_4
XFILLER_6_1700 VPWR VGND sg13g2_decap_8
XFILLER_22_1503 VPWR VGND sg13g2_fill_2
XFILLER_22_1514 VPWR VGND sg13g2_decap_8
XFILLER_6_1777 VPWR VGND sg13g2_decap_8
X_19719_ _19719_/Y _19719_/A _19719_/B VPWR VGND sg13g2_nor2_1
XFILLER_22_1547 VPWR VGND sg13g2_fill_2
X_20991_ _23540_/D _21983_/A1 _20990_/B _20990_/Y VPWR VGND sg13g2_o21ai_1
XFILLER_37_141 VPWR VGND sg13g2_decap_4
XFILLER_37_152 VPWR VGND sg13g2_fill_1
X_22730_ _22730_/Q _22733_/CLK _22730_/D fanout2881/X VPWR VGND sg13g2_dfrbpq_1
XFILLER_80_420 VPWR VGND sg13g2_decap_8
XFILLER_52_122 VPWR VGND sg13g2_decap_8
XFILLER_20_1282 VPWR VGND sg13g2_fill_2
X_22661_ _22661_/Q clkload24/A _22661_/D fanout2888/X VPWR VGND sg13g2_dfrbpq_1
XFILLER_0_1365 VPWR VGND sg13g2_decap_4
XFILLER_80_464 VPWR VGND sg13g2_decap_8
XFILLER_41_829 VPWR VGND sg13g2_fill_2
XFILLER_59_1481 VPWR VGND sg13g2_decap_8
XFILLER_94_1383 VPWR VGND sg13g2_fill_2
X_21612_ _21612_/Y _21612_/A _21612_/B VPWR VGND sg13g2_nand2_1
XFILLER_40_339 VPWR VGND sg13g2_decap_8
X_22592_ _22592_/Q clkload22/A _22592_/D fanout2896/X VPWR VGND sg13g2_dfrbpq_1
XFILLER_55_1378 VPWR VGND sg13g2_decap_4
X_21543_ _21543_/Y _21543_/A _21549_/B VPWR VGND sg13g2_nand2_1
Xplace4030 _13798_/A2 _11276_/Y VPWR VGND sg13g2_buf_1
XFILLER_21_575 VPWR VGND sg13g2_decap_8
Xplace4041 _14953_/A _15073_/A VPWR VGND sg13g2_buf_1
Xplace4052 _19047_/A _19045_/B VPWR VGND sg13g2_buf_1
Xplace4063 _18016_/S _18048_/S VPWR VGND sg13g2_buf_1
X_24262_ _24262_/X _24262_/A VPWR VGND sg13g2_buf_1
X_21474_ _23754_/D _21606_/A1 _21473_/B _21473_/Y VPWR VGND sg13g2_o21ai_1
Xplace4074 _14885_/A _24222_/Q VPWR VGND sg13g2_buf_1
Xplace4085 _20222_/B _23196_/Q VPWR VGND sg13g2_buf_1
Xplace3340 _21954_/A1 _22288_/A1 VPWR VGND sg13g2_buf_1
XFILLER_101_1012 VPWR VGND sg13g2_decap_4
Xplace3351 _22211_/A1 _19947_/Y VPWR VGND sg13g2_buf_1
X_23213_ _23213_/Q clkload35/A _23213_/D fanout2933/X VPWR VGND sg13g2_dfrbpq_1
Xplace4096 _19265_/A _23191_/Q VPWR VGND sg13g2_buf_1
X_20425_ _23277_/D _20251_/Y _23277_/Q _20435_/B VPWR VGND sg13g2_mux2_1
XFILLER_112_7 VPWR VGND sg13g2_decap_8
Xplace3362 _22403_/A1 _19854_/Y VPWR VGND sg13g2_buf_1
XFILLER_11_1930 VPWR VGND sg13g2_decap_8
XFILLER_107_625 VPWR VGND sg13g2_decap_8
X_24193_ _24193_/Q _24196_/CLK _24193_/D fanout2723/X VPWR VGND sg13g2_dfrbpq_1
Xplace3373 _17920_/B2 _17209_/A VPWR VGND sg13g2_buf_1
XFILLER_101_1045 VPWR VGND sg13g2_fill_2
Xplace3384 _17917_/A _15934_/A VPWR VGND sg13g2_buf_1
Xplace3395 _17503_/B _17502_/S VPWR VGND sg13g2_buf_1
XFILLER_88_1176 VPWR VGND sg13g2_decap_8
X_23144_ _23144_/Q clkload5/A _23144_/D fanout2840/X VPWR VGND sg13g2_dfrbpq_1
X_20356_ _20356_/Y _20356_/A _20356_/B VPWR VGND sg13g2_nand2_1
XFILLER_49_1149 VPWR VGND sg13g2_decap_8
XFILLER_106_168 VPWR VGND sg13g2_decap_8
X_23075_ _23075_/Q _23114_/CLK _23075_/D fanout2904/X VPWR VGND sg13g2_dfrbpq_1
XFILLER_0_413 VPWR VGND sg13g2_decap_4
X_20287_ _20287_/Y _20290_/B _20287_/B VPWR VGND sg13g2_nor2_1
XFILLER_115_691 VPWR VGND sg13g2_decap_8
XFILLER_103_842 VPWR VGND sg13g2_decap_4
XFILLER_96_49 VPWR VGND sg13g2_decap_8
XFILLER_88_542 VPWR VGND sg13g2_decap_8
X_22026_ _24006_/D _22294_/A1 _22025_/B _22025_/Y VPWR VGND sg13g2_o21ai_1
XFILLER_102_330 VPWR VGND sg13g2_decap_4
XFILLER_66_1496 VPWR VGND sg13g2_decap_8
XFILLER_29_21 VPWR VGND sg13g2_decap_8
XFILLER_49_918 VPWR VGND sg13g2_decap_8
XFILLER_5_1210 VPWR VGND sg13g2_fill_1
XFILLER_40_1603 VPWR VGND sg13g2_fill_2
XFILLER_29_620 VPWR VGND sg13g2_decap_8
XFILLER_40_1625 VPWR VGND sg13g2_decap_8
XFILLER_75_247 VPWR VGND sg13g2_decap_8
XFILLER_75_258 VPWR VGND sg13g2_decap_8
X_23977_ _23977_/Q _24113_/CLK _23977_/D fanout2684/X VPWR VGND sg13g2_dfrbpq_1
XFILLER_91_729 VPWR VGND sg13g2_fill_1
XFILLER_90_228 VPWR VGND sg13g2_decap_8
XFILLER_28_163 VPWR VGND sg13g2_fill_1
X_13730_ _13856_/B _13729_/Y _20260_/A VPWR VGND sg13g2_nand2b_1
XFILLER_79_1868 VPWR VGND sg13g2_decap_8
X_22928_ _22928_/Q _22941_/CLK _22928_/D fanout2801/X VPWR VGND sg13g2_dfrbpq_1
XFILLER_83_280 VPWR VGND sg13g2_fill_2
XFILLER_16_325 VPWR VGND sg13g2_decap_4
XFILLER_21_1079 VPWR VGND sg13g2_decap_8
XFILLER_45_42 VPWR VGND sg13g2_decap_8
X_13661_ _13661_/Y _20258_/A _15884_/A VPWR VGND sg13g2_nand2_1
X_22859_ _22859_/Q _22869_/CLK _22859_/D fanout2793/X VPWR VGND sg13g2_dfrbpq_1
XFILLER_44_689 VPWR VGND sg13g2_decap_8
XFILLER_31_317 VPWR VGND sg13g2_decap_4
X_12612_ _12853_/A _12831_/B _20013_/B VPWR VGND sg13g2_xnor2_1
X_16380_ _22552_/D _23002_/Q _22552_/Q _16388_/B VPWR VGND sg13g2_mux2_1
XFILLER_71_497 VPWR VGND sg13g2_decap_8
X_13592_ _13592_/Y _13589_/B _24110_/Q _13591_/Y VPWR VGND sg13g2_o21ai_1
XFILLER_101_70 VPWR VGND sg13g2_decap_8
XFILLER_38_1587 VPWR VGND sg13g2_fill_2
X_15331_ _15332_/D _15331_/A _15331_/B VPWR VGND sg13g2_nor2_1
XFILLER_73_1478 VPWR VGND sg13g2_fill_1
X_12543_ _12544_/C _12541_/Y _12542_/Y _12543_/S VPWR VGND sg13g2_mux2_1
XFILLER_40_873 VPWR VGND sg13g2_decap_4
XFILLER_8_524 VPWR VGND sg13g2_decap_8
XFILLER_16_1863 VPWR VGND sg13g2_decap_8
X_18050_ _18366_/A _18473_/S _18047_/Y _18049_/Y VPWR VGND sg13g2_o21ai_1
XFILLER_8_535 VPWR VGND sg13g2_decap_8
XFILLER_40_895 VPWR VGND sg13g2_decap_4
X_15262_ _16787_/A _15262_/A _15262_/B _15300_/B _17034_/A VPWR VGND sg13g2_nand4_1
XFILLER_12_597 VPWR VGND sg13g2_decap_8
X_12474_ _12475_/B _23456_/Q _23520_/Q _12474_/S VPWR VGND sg13g2_mux2_1
XFILLER_103_1833 VPWR VGND sg13g2_decap_8
XFILLER_6_14 VPWR VGND sg13g2_decap_8
X_17001_ _17001_/Y _17192_/A _17021_/B VPWR VGND sg13g2_nand2_1
X_14213_ _14213_/Y _14213_/A _14213_/B _14213_/C _14213_/D VPWR VGND sg13g2_nand4_1
XFILLER_32_1164 VPWR VGND sg13g2_fill_2
X_11425_ _11426_/B _23286_/Q _23318_/Q _11762_/B VPWR VGND sg13g2_mux2_1
XFILLER_32_1175 VPWR VGND sg13g2_fill_2
X_15193_ _15194_/B _15289_/A _19728_/A _15193_/C VPWR VGND sg13g2_nand3_1
XFILLER_4_730 VPWR VGND sg13g2_decap_4
X_14144_ _14145_/B _14436_/A _22994_/Q _14144_/C VPWR VGND sg13g2_nand3b_1
XFILLER_99_818 VPWR VGND sg13g2_decap_8
XFILLER_113_617 VPWR VGND sg13g2_decap_8
XFILLER_67_1249 VPWR VGND sg13g2_decap_8
XFILLER_3_251 VPWR VGND sg13g2_decap_8
XFILLER_112_105 VPWR VGND sg13g2_decap_8
X_18952_ _18953_/C _18959_/A _23085_/Q VPWR VGND sg13g2_nand2_1
X_14075_ _19721_/A _14090_/A _14090_/B _19489_/B VPWR VGND sg13g2_nor3_1
XFILLER_106_680 VPWR VGND sg13g2_decap_4
X_11287_ _11287_/X _11477_/A _11287_/B VPWR VGND sg13g2_and2_1
XFILLER_3_273 VPWR VGND sg13g2_decap_8
X_17903_ _17904_/B _22932_/Q _17930_/B VPWR VGND sg13g2_nand2_1
X_13026_ _13026_/X _23463_/Q _23527_/Q _23623_/Q _23687_/Q _13270_/S1 _13019_/A VPWR
+ VGND sg13g2_mux4_1
XFILLER_45_1547 VPWR VGND sg13g2_fill_2
X_18883_ _23046_/D _18875_/Y _18879_/Y _18880_/Y _18882_/Y VPWR VGND sg13g2_a22oi_1
XFILLER_39_428 VPWR VGND sg13g2_decap_4
X_17834_ _22910_/D _16357_/C _17855_/B _17833_/Y VPWR VGND sg13g2_a21oi_1
XFILLER_23_1823 VPWR VGND sg13g2_fill_1
XFILLER_114_1951 VPWR VGND sg13g2_decap_4
XFILLER_86_82 VPWR VGND sg13g2_fill_1
X_14977_ _16282_/A _14977_/A1 _18679_/A2 _14976_/Y VPWR VGND sg13g2_a21oi_1
XFILLER_3_1939 VPWR VGND sg13g2_decap_8
X_17765_ _17765_/Y _17809_/A1 _17763_/Y _17764_/Y VPWR VGND sg13g2_o21ai_1
XFILLER_47_450 VPWR VGND sg13g2_decap_8
XFILLER_48_984 VPWR VGND sg13g2_decap_8
XFILLER_48_995 VPWR VGND sg13g2_fill_1
XFILLER_97_1946 VPWR VGND sg13g2_decap_8
X_19504_ _19504_/Y _20249_/A3 _19501_/Y _19503_/Y _19501_/A VPWR VGND sg13g2_a22oi_1
XFILLER_75_781 VPWR VGND sg13g2_fill_2
X_16716_ _22658_/D _16067_/A _16728_/A _16715_/Y VPWR VGND sg13g2_a21oi_1
X_13928_ _13930_/A _13937_/B _13940_/A VPWR VGND sg13g2_nand2b_1
XFILLER_110_1859 VPWR VGND sg13g2_decap_8
X_17696_ _17696_/Y _22563_/Q _17715_/C VPWR VGND sg13g2_xnor2_1
XFILLER_90_740 VPWR VGND sg13g2_decap_8
XFILLER_74_291 VPWR VGND sg13g2_fill_1
XFILLER_78_1378 VPWR VGND sg13g2_decap_4
X_19435_ _19896_/B _19872_/A _19418_/Y _19434_/X VPWR VGND sg13g2_a21oi_1
X_16647_ _22644_/D _16175_/A _16656_/A _16646_/Y VPWR VGND sg13g2_a21oi_1
XFILLER_90_773 VPWR VGND sg13g2_decap_4
XFILLER_23_818 VPWR VGND sg13g2_decap_4
X_13859_ _13860_/D _13717_/B _13717_/C _14342_/A VPWR VGND sg13g2_a21oi_1
XFILLER_1_1685 VPWR VGND sg13g2_decap_8
XFILLER_16_881 VPWR VGND sg13g2_fill_1
XFILLER_76_1080 VPWR VGND sg13g2_decap_4
X_16578_ _22630_/D _17866_/A _16591_/A _16577_/Y VPWR VGND sg13g2_a21oi_1
X_19366_ _19366_/Y _13734_/A _19367_/B _19365_/Y VPWR VGND sg13g2_o21ai_1
XFILLER_34_199 VPWR VGND sg13g2_decap_8
XFILLER_15_380 VPWR VGND sg13g2_decap_8
XFILLER_56_1665 VPWR VGND sg13g2_decap_4
XFILLER_37_1064 VPWR VGND sg13g2_decap_8
XFILLER_52_1518 VPWR VGND sg13g2_decap_4
X_15529_ _16014_/A _16790_/A _15625_/B VPWR VGND sg13g2_nand2b_1
X_18317_ _18318_/B _18288_/A _18290_/A _18316_/Y VPWR VGND sg13g2_a21oi_1
X_19297_ _23214_/D _23214_/Q _20255_/A0 _19299_/S VPWR VGND sg13g2_mux2_1
X_18248_ _18248_/Y _18427_/A _18243_/Y _18247_/Y VPWR VGND sg13g2_a21oi_1
XFILLER_102_1321 VPWR VGND sg13g2_decap_4
XFILLER_89_1441 VPWR VGND sg13g2_fill_2
X_20210_ _20210_/Y _20208_/A _20208_/B _20354_/B VPWR VGND sg13g2_a21oi_1
XFILLER_89_1485 VPWR VGND sg13g2_fill_1
XFILLER_104_617 VPWR VGND sg13g2_decap_8
XFILLER_89_317 VPWR VGND sg13g2_decap_8
X_20141_ _20141_/Y _20266_/A1 _20130_/Y _20140_/Y _20266_/B2 VPWR VGND sg13g2_a22oi_1
X_20072_ _20073_/A _20343_/A1 _23211_/Q _23219_/Q _20343_/A2 _20343_/S1 _20072_/S1
+ VPWR VGND sg13g2_mux4_1
XFILLER_8_1839 VPWR VGND sg13g2_decap_8
XFILLER_48_1193 VPWR VGND sg13g2_fill_2
XFILLER_44_1035 VPWR VGND sg13g2_fill_2
X_23900_ _23900_/Q clkload56/A _23900_/D fanout2677/X VPWR VGND sg13g2_dfrbpq_1
XFILLER_41_1912 VPWR VGND sg13g2_decap_8
XFILLER_100_834 VPWR VGND sg13g2_fill_1
XFILLER_111_182 VPWR VGND sg13g2_decap_8
XFILLER_44_1079 VPWR VGND sg13g2_decap_8
XFILLER_6_1552 VPWR VGND sg13g2_fill_2
XFILLER_85_556 VPWR VGND sg13g2_fill_2
XFILLER_26_1491 VPWR VGND sg13g2_fill_2
X_23831_ _23831_/Q clkload52/A _23831_/D fanout2689/X VPWR VGND sg13g2_dfrbpq_1
XFILLER_39_973 VPWR VGND sg13g2_decap_8
XFILLER_57_269 VPWR VGND sg13g2_fill_2
XFILLER_113_1472 VPWR VGND sg13g2_fill_1
XFILLER_66_781 VPWR VGND sg13g2_decap_8
X_23762_ _23762_/Q clkload32/A _23762_/D fanout2652/X VPWR VGND sg13g2_dfrbpq_1
X_20974_ _23531_/D _21969_/A1 _20990_/B _20973_/Y VPWR VGND sg13g2_o21ai_1
XFILLER_81_740 VPWR VGND sg13g2_fill_2
XFILLER_82_29 VPWR VGND sg13g2_decap_4
XFILLER_26_656 VPWR VGND sg13g2_decap_4
X_22713_ _22713_/Q clkload20/A _22713_/D fanout2865/X VPWR VGND sg13g2_dfrbpq_1
X_23693_ _23693_/Q clkload51/A _23693_/D fanout2659/X VPWR VGND sg13g2_dfrbpq_1
XFILLER_39_1830 VPWR VGND sg13g2_decap_8
XFILLER_54_998 VPWR VGND sg13g2_fill_1
XFILLER_15_23 VPWR VGND sg13g2_fill_2
XFILLER_41_615 VPWR VGND sg13g2_decap_8
XFILLER_74_1721 VPWR VGND sg13g2_fill_1
XFILLER_94_1180 VPWR VGND sg13g2_fill_2
X_22644_ _22644_/Q clkload19/A _22644_/D fanout2862/X VPWR VGND sg13g2_dfrbpq_1
XFILLER_80_294 VPWR VGND sg13g2_decap_4
XFILLER_15_67 VPWR VGND sg13g2_decap_8
XFILLER_15_89 VPWR VGND sg13g2_fill_2
XFILLER_21_350 VPWR VGND sg13g2_fill_1
X_22575_ _22575_/Q _23029_/CLK _22575_/D fanout2825/X VPWR VGND sg13g2_dfrbpq_1
XFILLER_51_1017 VPWR VGND sg13g2_decap_8
XFILLER_55_1186 VPWR VGND sg13g2_fill_2
XFILLER_22_884 VPWR VGND sg13g2_fill_2
XFILLER_51_1028 VPWR VGND sg13g2_fill_1
XFILLER_22_895 VPWR VGND sg13g2_fill_2
XFILLER_21_372 VPWR VGND sg13g2_fill_1
X_21526_ _21526_/Y _21526_/A _21534_/B VPWR VGND sg13g2_nand2_1
XFILLER_21_394 VPWR VGND sg13g2_fill_2
XFILLER_5_527 VPWR VGND sg13g2_fill_1
X_21457_ _23746_/D _21952_/A1 _21456_/B _21456_/Y VPWR VGND sg13g2_o21ai_1
Xplace3170 _20624_/B _20638_/B VPWR VGND sg13g2_buf_1
XFILLER_5_538 VPWR VGND sg13g2_decap_8
XFILLER_5_549 VPWR VGND sg13g2_fill_2
Xplace3181 _20548_/B _20572_/B VPWR VGND sg13g2_buf_1
X_11210_ _14614_/B _11311_/A _11311_/B VPWR VGND sg13g2_or2_1
X_12190_ _12195_/B _12788_/B _12190_/B VPWR VGND sg13g2_nor2_1
Xplace3192 _20388_/B _20380_/B VPWR VGND sg13g2_buf_1
X_20408_ _20408_/Y _20408_/A _20412_/B VPWR VGND sg13g2_nand2_1
XFILLER_11_1760 VPWR VGND sg13g2_decap_4
X_24176_ _24176_/Q _24214_/CLK _24176_/D fanout2629/X VPWR VGND sg13g2_dfrbpq_1
X_21388_ _23713_/D _21950_/A1 _21389_/B _21387_/Y VPWR VGND sg13g2_o21ai_1
X_23127_ _23127_/Q clkload6/A _23127_/D fanout2833/X VPWR VGND sg13g2_dfrbpq_1
XFILLER_107_499 VPWR VGND sg13g2_decap_8
X_20339_ _20339_/Y _20338_/A _20337_/Y _20338_/Y VPWR VGND sg13g2_o21ai_1
XFILLER_46_1823 VPWR VGND sg13g2_fill_1
X_23058_ _23058_/Q _23215_/CLK _23058_/D fanout2927/X VPWR VGND sg13g2_dfrbpq_1
XFILLER_7_1305 VPWR VGND sg13g2_decap_8
XFILLER_62_1124 VPWR VGND sg13g2_fill_2
XFILLER_81_1758 VPWR VGND sg13g2_fill_2
XFILLER_27_1255 VPWR VGND sg13g2_fill_2
XFILLER_76_501 VPWR VGND sg13g2_fill_2
X_22009_ _23998_/D _22211_/A1 _22008_/B _22008_/Y VPWR VGND sg13g2_o21ai_1
XFILLER_103_694 VPWR VGND sg13g2_fill_1
XFILLER_88_383 VPWR VGND sg13g2_decap_4
X_15880_ _15880_/Y _15947_/A1 _15879_/Y _15947_/B1 VPWR VGND sg13g2_o21ai_1
XFILLER_88_394 VPWR VGND sg13g2_decap_4
XFILLER_49_759 VPWR VGND sg13g2_decap_8
XFILLER_76_545 VPWR VGND sg13g2_decap_8
XFILLER_40_1411 VPWR VGND sg13g2_decap_8
XFILLER_76_556 VPWR VGND sg13g2_fill_1
XFILLER_44_1591 VPWR VGND sg13g2_fill_2
X_14831_ _14831_/Y _14831_/A _14831_/B _14831_/C VPWR VGND sg13g2_nand3_1
XFILLER_40_1433 VPWR VGND sg13g2_decap_8
XFILLER_79_1610 VPWR VGND sg13g2_fill_2
XFILLER_17_601 VPWR VGND sg13g2_decap_4
XFILLER_5_1062 VPWR VGND sg13g2_fill_2
XFILLER_56_63 VPWR VGND sg13g2_fill_1
XFILLER_17_623 VPWR VGND sg13g2_fill_1
X_14762_ _14763_/B _14760_/Y _14762_/B VPWR VGND sg13g2_nand2b_1
XFILLER_45_943 VPWR VGND sg13g2_fill_2
XFILLER_16_133 VPWR VGND sg13g2_decap_8
X_13713_ _13713_/Y _13713_/A1 _13699_/Y _13703_/Y _13267_/A _13712_/Y VPWR VGND sg13g2_a221oi_1
XFILLER_72_751 VPWR VGND sg13g2_fill_2
X_14693_ _14693_/X _14690_/Y _14692_/Y _14737_/S VPWR VGND sg13g2_mux2_1
XFILLER_57_1930 VPWR VGND sg13g2_decap_8
XFILLER_32_615 VPWR VGND sg13g2_decap_8
XFILLER_45_998 VPWR VGND sg13g2_decap_8
XFILLER_71_261 VPWR VGND sg13g2_fill_2
XFILLER_72_795 VPWR VGND sg13g2_decap_4
XFILLER_112_91 VPWR VGND sg13g2_decap_8
XFILLER_92_1832 VPWR VGND sg13g2_decap_4
XFILLER_31_103 VPWR VGND sg13g2_fill_1
X_19220_ _23175_/D _24264_/A _23175_/Q _19229_/S VPWR VGND sg13g2_mux2_1
XFILLER_60_946 VPWR VGND sg13g2_fill_2
X_16432_ _22583_/D _17476_/A1 _16431_/B _16431_/Y VPWR VGND sg13g2_o21ai_1
X_13644_ _13644_/X _23567_/Q _24015_/Q _13645_/A VPWR VGND sg13g2_mux2_1
XFILLER_92_1854 VPWR VGND sg13g2_decap_8
XFILLER_18_1925 VPWR VGND sg13g2_decap_8
XFILLER_71_294 VPWR VGND sg13g2_decap_4
XFILLER_60_968 VPWR VGND sg13g2_decap_8
X_16363_ _22545_/D _16364_/B _16361_/Y _16362_/Y VPWR VGND sg13g2_o21ai_1
XFILLER_53_1849 VPWR VGND sg13g2_decap_8
X_13575_ _13575_/X _13607_/A _13575_/B VPWR VGND sg13g2_or2_1
XFILLER_13_895 VPWR VGND sg13g2_decap_8
X_15314_ _15561_/B _15482_/A _15353_/A VPWR VGND sg13g2_nor2_1
X_12526_ _12526_/Y _16090_/S _12526_/B VPWR VGND sg13g2_nor2_1
X_19082_ _23077_/D _23077_/Q _19081_/X _19086_/S VPWR VGND sg13g2_mux2_1
XFILLER_40_692 VPWR VGND sg13g2_decap_8
X_16294_ _22532_/D _16295_/A _16295_/B VPWR VGND sg13g2_xor2_1
XFILLER_16_1682 VPWR VGND sg13g2_decap_4
X_18033_ _18269_/A _18351_/A _18562_/A VPWR VGND sg13g2_nand2_1
X_15245_ _15246_/B _15245_/A _15447_/B _15447_/C _15245_/D VPWR VGND sg13g2_nor4_1
X_12457_ _12458_/B _23712_/Q _23744_/Q _23776_/Q _23808_/Q _12459_/S0 _12457_/S1 VPWR
+ VGND sg13g2_mux4_1
X_11408_ _11408_/Y _11408_/A _12039_/B VPWR VGND sg13g2_nor2b_1
X_12388_ _12418_/B _14438_/B _14296_/A2 _12387_/X VPWR VGND sg13g2_a21o_1
XFILLER_114_926 VPWR VGND sg13g2_fill_1
XFILLER_86_1658 VPWR VGND sg13g2_fill_1
XFILLER_4_560 VPWR VGND sg13g2_decap_8
XFILLER_113_414 VPWR VGND sg13g2_decap_8
X_14127_ _14127_/Y _14127_/A _14127_/B _14127_/C VPWR VGND sg13g2_nand3_1
XFILLER_28_1019 VPWR VGND sg13g2_fill_2
X_19984_ _19991_/B _19984_/A _19984_/B _19984_/C VPWR VGND sg13g2_nor3_1
XFILLER_84_1371 VPWR VGND sg13g2_fill_1
XFILLER_97_70 VPWR VGND sg13g2_decap_8
X_18935_ _18936_/C _23051_/Q _19023_/B _18956_/B VPWR VGND sg13g2_or3_1
X_14058_ _14059_/D _14956_/A _14053_/Y _14055_/X _12768_/S _14057_/Y VPWR VGND sg13g2_a221oi_1
XFILLER_80_1224 VPWR VGND sg13g2_decap_8
XFILLER_95_821 VPWR VGND sg13g2_fill_2
XFILLER_45_1355 VPWR VGND sg13g2_decap_8
XFILLER_67_512 VPWR VGND sg13g2_fill_2
X_13009_ _13009_/Y _13002_/X _13008_/B _13008_/Y VPWR VGND sg13g2_o21ai_1
XFILLER_45_1366 VPWR VGND sg13g2_fill_2
XFILLER_95_832 VPWR VGND sg13g2_fill_1
X_18866_ _18866_/Y _18866_/A _18866_/B VPWR VGND sg13g2_nand2_1
XFILLER_67_545 VPWR VGND sg13g2_decap_8
XFILLER_39_247 VPWR VGND sg13g2_decap_8
XFILLER_62_1680 VPWR VGND sg13g2_fill_1
XFILLER_7_1883 VPWR VGND sg13g2_decap_8
X_17817_ _17817_/Y _17220_/A _17824_/A2 _17824_/B1 _17816_/Y VPWR VGND sg13g2_a22oi_1
XFILLER_95_887 VPWR VGND sg13g2_fill_1
XFILLER_23_1653 VPWR VGND sg13g2_decap_8
XFILLER_110_1612 VPWR VGND sg13g2_fill_2
XFILLER_95_898 VPWR VGND sg13g2_decap_8
X_18797_ _18797_/Y _18822_/A _18797_/B VPWR VGND sg13g2_nand2_1
XFILLER_3_1736 VPWR VGND sg13g2_decap_8
XFILLER_48_770 VPWR VGND sg13g2_decap_8
X_17748_ _17748_/Y _23177_/Q _17822_/A2 _17815_/B1 _18432_/A VPWR VGND sg13g2_a22oi_1
XFILLER_63_740 VPWR VGND sg13g2_decap_8
XFILLER_93_1618 VPWR VGND sg13g2_decap_8
XFILLER_36_976 VPWR VGND sg13g2_decap_4
X_17679_ _17679_/Y _11583_/S _17687_/A _17678_/Y VPWR VGND sg13g2_o21ai_1
XFILLER_39_1148 VPWR VGND sg13g2_fill_2
XFILLER_63_795 VPWR VGND sg13g2_fill_1
X_19418_ _19418_/Y _19638_/S _19410_/Y _19417_/Y VPWR VGND sg13g2_a21oi_1
XFILLER_22_114 VPWR VGND sg13g2_decap_8
XFILLER_35_497 VPWR VGND sg13g2_fill_2
X_20690_ _20690_/Y _20690_/A _20690_/B VPWR VGND sg13g2_nand2_1
XFILLER_91_1331 VPWR VGND sg13g2_decap_8
XFILLER_17_1402 VPWR VGND sg13g2_fill_2
XFILLER_22_136 VPWR VGND sg13g2_fill_2
X_19349_ _19349_/X _19336_/X _19650_/B _19696_/B VPWR VGND sg13g2_mux2_1
XFILLER_22_169 VPWR VGND sg13g2_fill_1
XFILLER_56_1484 VPWR VGND sg13g2_fill_2
XFILLER_91_1375 VPWR VGND sg13g2_fill_1
X_22360_ _24166_/D _22427_/A1 _22359_/B _22359_/Y VPWR VGND sg13g2_o21ai_1
X_21311_ _21311_/Y _23677_/Q _21313_/B VPWR VGND sg13g2_nand2_1
XFILLER_11_1001 VPWR VGND sg13g2_fill_2
XFILLER_30_1624 VPWR VGND sg13g2_decap_4
XFILLER_34_1793 VPWR VGND sg13g2_decap_8
X_22291_ _22291_/Y _24133_/Q _22291_/B VPWR VGND sg13g2_nand2_1
X_21242_ _21242_/Y _21242_/A _21242_/B VPWR VGND sg13g2_nand2_1
XFILLER_89_1271 VPWR VGND sg13g2_decap_8
X_24030_ _24030_/Q clkload44/A _24030_/D fanout2744/X VPWR VGND sg13g2_dfrbpq_1
XFILLER_7_90 VPWR VGND sg13g2_decap_4
XFILLER_89_1293 VPWR VGND sg13g2_decap_4
XFILLER_105_937 VPWR VGND sg13g2_decap_8
XFILLER_85_1146 VPWR VGND sg13g2_fill_1
X_21173_ _21173_/Y _23611_/Q _21179_/B VPWR VGND sg13g2_nand2_1
XFILLER_63_1400 VPWR VGND sg13g2_fill_1
X_20124_ _20124_/Y _20266_/A1 _20111_/Y _20123_/Y _20266_/B2 VPWR VGND sg13g2_a22oi_1
XFILLER_63_1411 VPWR VGND sg13g2_decap_8
XFILLER_89_169 VPWR VGND sg13g2_fill_1
XFILLER_113_992 VPWR VGND sg13g2_decap_8
X_20055_ _20069_/A _24259_/A _20091_/B VPWR VGND sg13g2_nand2_1
XFILLER_115_1545 VPWR VGND sg13g2_fill_2
XFILLER_24_1428 VPWR VGND sg13g2_fill_1
XFILLER_58_545 VPWR VGND sg13g2_fill_1
XFILLER_63_1499 VPWR VGND sg13g2_decap_4
XFILLER_115_1567 VPWR VGND sg13g2_decap_8
XFILLER_98_1507 VPWR VGND sg13g2_decap_8
XFILLER_98_1518 VPWR VGND sg13g2_decap_8
XFILLER_85_353 VPWR VGND sg13g2_fill_2
XFILLER_100_664 VPWR VGND sg13g2_decap_8
XFILLER_18_409 VPWR VGND sg13g2_decap_8
XFILLER_22_1130 VPWR VGND sg13g2_decap_8
XFILLER_58_589 VPWR VGND sg13g2_fill_1
XFILLER_93_28 VPWR VGND sg13g2_decap_4
XFILLER_85_375 VPWR VGND sg13g2_decap_8
XFILLER_22_1141 VPWR VGND sg13g2_fill_1
XFILLER_45_217 VPWR VGND sg13g2_decap_4
X_23814_ _23814_/Q clkload40/A _23814_/D fanout2735/X VPWR VGND sg13g2_dfrbpq_1
XFILLER_22_1185 VPWR VGND sg13g2_fill_2
XFILLER_27_954 VPWR VGND sg13g2_decap_8
XFILLER_27_976 VPWR VGND sg13g2_fill_1
XFILLER_2_1279 VPWR VGND sg13g2_fill_1
XFILLER_26_55 VPWR VGND sg13g2_decap_4
XFILLER_60_209 VPWR VGND sg13g2_fill_2
X_23745_ _23745_/Q clkload43/A _23745_/D fanout2740/X VPWR VGND sg13g2_dfrbpq_1
X_20957_ _23523_/D _21325_/A1 _20962_/B _20956_/Y VPWR VGND sg13g2_o21ai_1
XFILLER_26_464 VPWR VGND sg13g2_decap_4
XFILLER_53_250 VPWR VGND sg13g2_fill_2
XFILLER_96_1297 VPWR VGND sg13g2_fill_1
XFILLER_42_935 VPWR VGND sg13g2_decap_8
XFILLER_42_946 VPWR VGND sg13g2_fill_2
X_23676_ _23676_/Q clkload59/A _23676_/D fanout2784/X VPWR VGND sg13g2_dfrbpq_1
X_20888_ _20888_/Y _20888_/A _20888_/B VPWR VGND sg13g2_nand2_1
XFILLER_13_147 VPWR VGND sg13g2_decap_8
X_22627_ _22627_/Q clkload24/A _22627_/D fanout2898/X VPWR VGND sg13g2_dfrbpq_1
XFILLER_35_1535 VPWR VGND sg13g2_decap_8
XFILLER_42_43 VPWR VGND sg13g2_decap_4
X_13360_ _13360_/Y _19423_/A _20179_/B VPWR VGND sg13g2_nor2_1
XFILLER_35_1579 VPWR VGND sg13g2_fill_1
X_22558_ _22558_/Q clkload26/A _22558_/D fanout2851/X VPWR VGND sg13g2_dfrbpq_1
XFILLER_13_1822 VPWR VGND sg13g2_decap_8
XFILLER_104_1950 VPWR VGND sg13g2_decap_4
XFILLER_10_876 VPWR VGND sg13g2_fill_2
X_12311_ _12311_/X _12309_/X _12310_/X _12557_/S VPWR VGND sg13g2_mux2_1
X_21509_ _23771_/D _21936_/A1 _21508_/B _21508_/Y VPWR VGND sg13g2_o21ai_1
XFILLER_6_847 VPWR VGND sg13g2_decap_8
XFILLER_33_1292 VPWR VGND sg13g2_decap_8
X_22489_ _22489_/Q _22917_/CLK _22489_/D fanout2892/X VPWR VGND sg13g2_dfrbpq_1
XFILLER_108_742 VPWR VGND sg13g2_fill_1
XFILLER_87_1923 VPWR VGND sg13g2_fill_2
X_15030_ _15030_/Y _16304_/A _16304_/B _16304_/C VPWR VGND sg13g2_nand3_1
X_12242_ _12243_/B _23421_/Q _23453_/Q _12246_/S VPWR VGND sg13g2_mux2_1
X_24228_ _24228_/Q clkload5/A _24228_/D fanout2841/X VPWR VGND sg13g2_dfrbpq_1
XFILLER_13_1899 VPWR VGND sg13g2_decap_8
XFILLER_68_1333 VPWR VGND sg13g2_decap_8
XFILLER_101_0 VPWR VGND sg13g2_decap_8
X_12173_ _12173_/X _23420_/Q _23452_/Q _23484_/Q _23516_/Q _11843_/S _12297_/S1 VPWR
+ VGND sg13g2_mux4_1
X_24159_ _24159_/Q clkload41/A _24159_/D fanout2727/X VPWR VGND sg13g2_dfrbpq_1
XFILLER_46_1631 VPWR VGND sg13g2_fill_2
XFILLER_7_1113 VPWR VGND sg13g2_decap_8
XFILLER_27_1052 VPWR VGND sg13g2_fill_1
XFILLER_107_91 VPWR VGND sg13g2_decap_8
X_18720_ _18720_/Y _18729_/A _18726_/B _15042_/B VPWR VGND sg13g2_o21ai_1
XFILLER_67_40 VPWR VGND sg13g2_fill_2
XFILLER_110_439 VPWR VGND sg13g2_decap_8
XFILLER_81_1566 VPWR VGND sg13g2_decap_4
X_15932_ _15934_/A _20290_/A _15930_/Y _15931_/Y VPWR VGND sg13g2_a21oi_1
XFILLER_49_545 VPWR VGND sg13g2_decap_8
XFILLER_67_62 VPWR VGND sg13g2_decap_8
XFILLER_24_1940 VPWR VGND sg13g2_decap_8
XFILLER_27_1096 VPWR VGND sg13g2_decap_4
XFILLER_67_73 VPWR VGND sg13g2_fill_1
X_18651_ _18651_/Y _18655_/B _18651_/B VPWR VGND sg13g2_nand2b_1
X_15863_ _15864_/D _22611_/Q _15964_/A2 _15862_/Y VPWR VGND sg13g2_a21oi_1
XFILLER_91_312 VPWR VGND sg13g2_decap_8
XFILLER_18_932 VPWR VGND sg13g2_fill_1
X_14814_ _14814_/Y _14762_/B _14808_/Y _14813_/Y _14220_/B VPWR VGND sg13g2_a22oi_1
X_17602_ _17608_/A _23162_/Q _17621_/B VPWR VGND sg13g2_nand2_1
XFILLER_76_397 VPWR VGND sg13g2_decap_8
XFILLER_91_323 VPWR VGND sg13g2_fill_1
X_18582_ _18585_/C _22997_/Q _18821_/B VPWR VGND sg13g2_nor2_1
X_15794_ _15796_/C _22472_/Q _15970_/A2 _15825_/B _22899_/Q VPWR VGND sg13g2_a22oi_1
XFILLER_64_559 VPWR VGND sg13g2_fill_2
XFILLER_91_356 VPWR VGND sg13g2_decap_8
XFILLER_83_50 VPWR VGND sg13g2_decap_4
XFILLER_17_453 VPWR VGND sg13g2_fill_2
X_14745_ _14745_/Y _15920_/A1 _22832_/Q _14210_/A _14744_/Y VPWR VGND sg13g2_a22oi_1
X_11957_ _11957_/X _23834_/Q _23930_/Q _11960_/S VPWR VGND sg13g2_mux2_1
XFILLER_94_1949 VPWR VGND sg13g2_decap_4
XFILLER_44_261 VPWR VGND sg13g2_decap_8
XFILLER_75_1348 VPWR VGND sg13g2_decap_8
XFILLER_60_732 VPWR VGND sg13g2_decap_8
X_14676_ _14676_/Y _14714_/A1 _14642_/B _14675_/Y VPWR VGND sg13g2_o21ai_1
X_11888_ _11889_/A _14041_/B _11888_/B VPWR VGND sg13g2_xor2_1
XFILLER_57_1760 VPWR VGND sg13g2_fill_2
XFILLER_57_1771 VPWR VGND sg13g2_fill_1
XFILLER_60_765 VPWR VGND sg13g2_decap_4
XFILLER_92_1662 VPWR VGND sg13g2_fill_2
X_16415_ _22574_/D _15911_/Y _18697_/A _16414_/Y VPWR VGND sg13g2_o21ai_1
X_19203_ _23161_/D _24250_/A _23161_/Q _19231_/S VPWR VGND sg13g2_mux2_1
X_13627_ _13627_/Y _23182_/Q _13924_/A2 _13924_/B1 _13626_/X VPWR VGND sg13g2_a22oi_1
XFILLER_53_1624 VPWR VGND sg13g2_decap_8
X_17395_ _22819_/D _17394_/Y _22819_/Q _17395_/S VPWR VGND sg13g2_mux2_1
XFILLER_92_1695 VPWR VGND sg13g2_decap_4
XFILLER_109_1883 VPWR VGND sg13g2_decap_8
XFILLER_18_1777 VPWR VGND sg13g2_fill_2
X_16346_ _16347_/B _22652_/Q _15323_/X _15325_/Y _22716_/Q VPWR VGND sg13g2_a22oi_1
X_19134_ _23111_/D _23111_/Q _18884_/A _19134_/S VPWR VGND sg13g2_mux2_1
Xplace3906 _18517_/B _18363_/A VPWR VGND sg13g2_buf_1
XFILLER_34_1056 VPWR VGND sg13g2_decap_8
X_13558_ _13558_/X _23470_/Q _23534_/Q _23630_/Q _23694_/Q _13251_/B _13559_/S1 VPWR
+ VGND sg13g2_mux4_1
Xplace3917 _18297_/B _17956_/B VPWR VGND sg13g2_buf_1
Xplace3928 _13595_/B2 _13234_/B2 VPWR VGND sg13g2_buf_1
Xplace3939 _18385_/B _18479_/C VPWR VGND sg13g2_buf_1
X_19065_ _23069_/D _23069_/Q _19064_/X _19078_/S VPWR VGND sg13g2_mux2_1
X_12509_ _12512_/B _12837_/A _19983_/B VPWR VGND sg13g2_xnor2_1
X_16277_ _22527_/D _16270_/Y _16277_/B VPWR VGND sg13g2_nand2b_1
X_13489_ _13489_/Y _13617_/B _24045_/Q _13488_/Y VPWR VGND sg13g2_o21ai_1
X_15228_ _15228_/X _14308_/Y _15227_/Y _16779_/A VPWR VGND sg13g2_a21o_1
X_18016_ _18016_/X _19128_/A1 _23041_/Q _18016_/S VPWR VGND sg13g2_mux2_1
XFILLER_12_1376 VPWR VGND sg13g2_fill_2
X_15159_ _16518_/C _15300_/A _15159_/B VPWR VGND sg13g2_and2_1
XFILLER_5_880 VPWR VGND sg13g2_decap_8
XFILLER_86_1477 VPWR VGND sg13g2_decap_8
XFILLER_114_767 VPWR VGND sg13g2_decap_8
XFILLER_102_907 VPWR VGND sg13g2_decap_8
XFILLER_59_309 VPWR VGND sg13g2_fill_1
XFILLER_9_1934 VPWR VGND sg13g2_decap_8
X_19967_ _19968_/B _20278_/A1 _20278_/A3 _20278_/A0 _20278_/A2 _19514_/A _19505_/A
+ VPWR VGND sg13g2_mux4_1
XFILLER_87_629 VPWR VGND sg13g2_fill_1
X_18918_ _18920_/B _18951_/A _18918_/B VPWR VGND sg13g2_nand2_1
XFILLER_41_1005 VPWR VGND sg13g2_fill_2
X_19898_ _19898_/Y _20031_/A _19898_/B VPWR VGND sg13g2_nand2_1
XFILLER_64_1797 VPWR VGND sg13g2_decap_8
XFILLER_112_1707 VPWR VGND sg13g2_fill_1
XFILLER_41_1027 VPWR VGND sg13g2_fill_1
X_18849_ _18850_/C _23074_/Q _18869_/B VPWR VGND sg13g2_nand2_1
XFILLER_99_1849 VPWR VGND sg13g2_fill_1
XFILLER_3_1511 VPWR VGND sg13g2_decap_8
XFILLER_110_995 VPWR VGND sg13g2_decap_8
XFILLER_23_1450 VPWR VGND sg13g2_fill_2
XFILLER_27_217 VPWR VGND sg13g2_fill_1
XFILLER_55_526 VPWR VGND sg13g2_decap_4
X_21860_ _23926_/D _21926_/A1 _21869_/B _21859_/Y VPWR VGND sg13g2_o21ai_1
XFILLER_94_194 VPWR VGND sg13g2_fill_1
XFILLER_103_49 VPWR VGND sg13g2_decap_8
XFILLER_23_1494 VPWR VGND sg13g2_fill_1
XFILLER_55_559 VPWR VGND sg13g2_decap_8
XFILLER_83_879 VPWR VGND sg13g2_fill_2
XFILLER_36_740 VPWR VGND sg13g2_decap_8
XFILLER_110_1453 VPWR VGND sg13g2_decap_8
XFILLER_110_1464 VPWR VGND sg13g2_decap_8
XFILLER_3_1588 VPWR VGND sg13g2_decap_4
XFILLER_110_1486 VPWR VGND sg13g2_fill_1
X_21791_ _23893_/D _19526_/Y _21848_/B _21790_/Y VPWR VGND sg13g2_o21ai_1
XFILLER_93_1437 VPWR VGND sg13g2_decap_8
XFILLER_23_412 VPWR VGND sg13g2_decap_8
XFILLER_51_721 VPWR VGND sg13g2_fill_1
XFILLER_19_1519 VPWR VGND sg13g2_fill_1
X_23530_ _23530_/Q _24196_/CLK _23530_/D fanout2704/X VPWR VGND sg13g2_dfrbpq_1
X_20742_ _20742_/Y _23422_/Q _20742_/B VPWR VGND sg13g2_nand2_1
XFILLER_50_231 VPWR VGND sg13g2_decap_8
XFILLER_23_456 VPWR VGND sg13g2_fill_1
XFILLER_36_1822 VPWR VGND sg13g2_decap_8
X_23461_ _23461_/Q clkload42/A _23461_/D fanout2718/X VPWR VGND sg13g2_dfrbpq_1
XFILLER_51_787 VPWR VGND sg13g2_decap_8
XFILLER_56_1270 VPWR VGND sg13g2_decap_8
XFILLER_51_798 VPWR VGND sg13g2_fill_1
X_20673_ _20673_/Y _20673_/A _20673_/B VPWR VGND sg13g2_nand2_1
XFILLER_17_1243 VPWR VGND sg13g2_decap_8
XFILLER_32_990 VPWR VGND sg13g2_fill_2
X_22412_ _24191_/D _22412_/A1 _22417_/B _22411_/Y VPWR VGND sg13g2_o21ai_1
XFILLER_91_1194 VPWR VGND sg13g2_decap_4
X_23392_ _23392_/Q _23682_/CLK _23392_/D fanout2722/X VPWR VGND sg13g2_dfrbpq_1
XFILLER_52_1156 VPWR VGND sg13g2_decap_4
XFILLER_109_517 VPWR VGND sg13g2_decap_8
XFILLER_12_35 VPWR VGND sg13g2_decap_8
XFILLER_104_1268 VPWR VGND sg13g2_fill_1
Xoutput4472 data_addr_o[14] _24259_/X VPWR VGND sg13g2_buf_1
Xoutput4483 data_addr_o[25] _24270_/X VPWR VGND sg13g2_buf_1
Xoutput4494 data_addr_o[6] _24251_/X VPWR VGND sg13g2_buf_1
X_22274_ _22274_/Y _22274_/A _22276_/B VPWR VGND sg13g2_nand2_1
XFILLER_69_1653 VPWR VGND sg13g2_decap_8
XFILLER_88_39 VPWR VGND sg13g2_fill_2
X_24013_ _24013_/Q _24205_/CLK _24013_/D fanout2651/X VPWR VGND sg13g2_dfrbpq_1
XFILLER_69_1686 VPWR VGND sg13g2_decap_8
XFILLER_105_745 VPWR VGND sg13g2_decap_8
XFILLER_5_7 VPWR VGND sg13g2_decap_8
XFILLER_105_767 VPWR VGND sg13g2_decap_8
XFILLER_82_1831 VPWR VGND sg13g2_decap_4
X_21156_ _21209_/B _22430_/B _21201_/B VPWR VGND sg13g2_or2_1
XFILLER_104_266 VPWR VGND sg13g2_fill_1
XFILLER_59_810 VPWR VGND sg13g2_decap_8
XFILLER_99_990 VPWR VGND sg13g2_fill_2
XFILLER_59_821 VPWR VGND sg13g2_decap_8
X_20107_ _20107_/Y _19913_/Y _20106_/Y _20367_/A VPWR VGND sg13g2_a21oi_1
XFILLER_59_832 VPWR VGND sg13g2_fill_1
X_21087_ _22363_/B _21087_/A _21087_/B VPWR VGND sg13g2_nand2_1
XFILLER_63_1263 VPWR VGND sg13g2_decap_8
XFILLER_24_1225 VPWR VGND sg13g2_fill_1
XFILLER_59_854 VPWR VGND sg13g2_fill_1
XFILLER_115_1353 VPWR VGND sg13g2_decap_8
XFILLER_59_865 VPWR VGND sg13g2_fill_2
X_20038_ _20040_/B _20038_/A _20038_/B VPWR VGND sg13g2_nor2_1
XFILLER_24_1258 VPWR VGND sg13g2_fill_1
XFILLER_115_1386 VPWR VGND sg13g2_decap_8
XFILLER_115_1397 VPWR VGND sg13g2_fill_2
XFILLER_85_172 VPWR VGND sg13g2_decap_8
XFILLER_58_386 VPWR VGND sg13g2_fill_2
XFILLER_100_483 VPWR VGND sg13g2_decap_8
XFILLER_74_846 VPWR VGND sg13g2_decap_8
XFILLER_6_1190 VPWR VGND sg13g2_fill_1
XFILLER_41_1583 VPWR VGND sg13g2_decap_4
X_11811_ _11812_/D _13889_/B _11810_/X _13801_/A1 VPWR VGND sg13g2_o21ai_1
XFILLER_2_1054 VPWR VGND sg13g2_decap_8
XFILLER_15_913 VPWR VGND sg13g2_decap_8
X_12791_ _12791_/Y _12791_/A _12791_/B VPWR VGND sg13g2_nor2_1
X_21989_ _21989_/Y _21989_/A _22031_/S VPWR VGND sg13g2_nand2_1
XFILLER_42_721 VPWR VGND sg13g2_fill_1
XFILLER_15_946 VPWR VGND sg13g2_decap_8
XFILLER_37_1608 VPWR VGND sg13g2_fill_2
X_14530_ _14530_/Y _16774_/B _14530_/B VPWR VGND sg13g2_nand2_1
XFILLER_15_957 VPWR VGND sg13g2_fill_1
X_23728_ _23728_/Q clkload49/A _23728_/D fanout2674/X VPWR VGND sg13g2_dfrbpq_1
XFILLER_54_1900 VPWR VGND sg13g2_decap_8
XFILLER_42_754 VPWR VGND sg13g2_fill_2
XFILLER_35_1310 VPWR VGND sg13g2_fill_1
XFILLER_41_253 VPWR VGND sg13g2_decap_8
X_14461_ _19235_/C _14461_/A _14461_/B _14614_/B VPWR VGND sg13g2_or3_1
X_11673_ _11674_/B _14026_/A _11673_/B _12340_/A VPWR VGND sg13g2_nor3_1
XFILLER_30_938 VPWR VGND sg13g2_fill_2
XFILLER_39_1490 VPWR VGND sg13g2_decap_8
X_23659_ _23659_/Q clkload49/A _23659_/D fanout2670/X VPWR VGND sg13g2_dfrbpq_1
XFILLER_15_1906 VPWR VGND sg13g2_decap_8
XFILLER_41_275 VPWR VGND sg13g2_decap_8
X_16200_ _22511_/D _16199_/B _16198_/Y _16199_/Y VPWR VGND sg13g2_o21ai_1
X_13412_ _13412_/X _24172_/Q _24204_/Q _23308_/Q _23340_/Q _13578_/S0 _13578_/S1 VPWR
+ VGND sg13g2_mux4_1
X_17180_ _17181_/B _17195_/A _17218_/B VPWR VGND sg13g2_nor2_1
XFILLER_70_1245 VPWR VGND sg13g2_fill_1
XFILLER_10_651 VPWR VGND sg13g2_decap_8
X_16131_ _16131_/Y _22499_/Q _16183_/B _16130_/Y VPWR VGND sg13g2_a21oi_1
X_13343_ _13343_/Y _13342_/X _13343_/B VPWR VGND sg13g2_nand2b_1
XFILLER_115_509 VPWR VGND sg13g2_decap_8
X_13274_ _13274_/X _23850_/Q _23882_/Q _23946_/Q _23978_/Q _13274_/S0 _12789_/S VPWR
+ VGND sg13g2_mux4_1
XFILLER_48_1704 VPWR VGND sg13g2_decap_4
X_15013_ _15013_/Y _16295_/A _15073_/A _15012_/Y VPWR VGND sg13g2_o21ai_1
XFILLER_87_1775 VPWR VGND sg13g2_fill_1
X_12225_ _12232_/A _12243_/A _12225_/B VPWR VGND sg13g2_nor2_1
XFILLER_108_594 VPWR VGND sg13g2_decap_8
XFILLER_5_187 VPWR VGND sg13g2_decap_8
XFILLER_29_1125 VPWR VGND sg13g2_decap_8
XFILLER_97_916 VPWR VGND sg13g2_fill_2
XFILLER_69_607 VPWR VGND sg13g2_decap_8
X_19821_ _23226_/D _19857_/B _22401_/A1 _19820_/Y VPWR VGND sg13g2_o21ai_1
X_12156_ _12156_/X _23292_/Q _23324_/Q _23356_/Q _23388_/Q _11904_/B _11427_/B VPWR
+ VGND sg13g2_mux4_1
Xfanout2820 fanout2820/X fanout2822/X VPWR VGND sg13g2_buf_1
XFILLER_29_1169 VPWR VGND sg13g2_fill_2
Xfanout2831 fanout2831/X fanout2902/X VPWR VGND sg13g2_buf_1
XFILLER_38_7 VPWR VGND sg13g2_fill_1
XFILLER_78_72 VPWR VGND sg13g2_decap_8
Xfanout2842 fanout2842/X fanout2843/X VPWR VGND sg13g2_buf_1
XFILLER_68_106 VPWR VGND sg13g2_decap_8
XFILLER_111_737 VPWR VGND sg13g2_decap_8
XFILLER_110_203 VPWR VGND sg13g2_decap_8
Xfanout2853 fanout2853/X fanout2854/X VPWR VGND sg13g2_buf_1
XFILLER_81_1341 VPWR VGND sg13g2_decap_8
Xfanout2864 fanout2864/X fanout2865/X VPWR VGND sg13g2_buf_1
XFILLER_46_1472 VPWR VGND sg13g2_decap_8
X_12087_ _12090_/A _12088_/A _12085_/Y _12086_/Y VPWR VGND sg13g2_a21o_1
Xfanout2875 fanout2875/X fanout2877/X VPWR VGND sg13g2_buf_1
XFILLER_81_1363 VPWR VGND sg13g2_fill_2
X_16964_ _22702_/D _17007_/A1 _16962_/Y _16963_/Y VPWR VGND sg13g2_o21ai_1
XFILLER_61_1937 VPWR VGND sg13g2_decap_8
Xfanout2886 fanout2886/X fanout2891/X VPWR VGND sg13g2_buf_1
XFILLER_81_1374 VPWR VGND sg13g2_fill_1
XFILLER_49_331 VPWR VGND sg13g2_fill_2
Xfanout2897 fanout2897/X fanout2901/X VPWR VGND sg13g2_buf_1
X_18703_ _18703_/Y _18729_/A _18708_/B _18692_/B VPWR VGND sg13g2_o21ai_1
X_15915_ _22477_/D _15981_/S _15910_/Y _15914_/Y VPWR VGND sg13g2_a21oi_1
X_19683_ _19684_/B _19886_/A1 _20278_/A0 _19509_/Y _23215_/Q VPWR VGND sg13g2_a22oi_1
XFILLER_42_1358 VPWR VGND sg13g2_fill_1
XFILLER_49_364 VPWR VGND sg13g2_decap_8
XFILLER_76_150 VPWR VGND sg13g2_decap_8
X_16895_ _22689_/D _16894_/X _17080_/A _16895_/S VPWR VGND sg13g2_mux2_1
XFILLER_65_824 VPWR VGND sg13g2_decap_8
XFILLER_76_161 VPWR VGND sg13g2_fill_2
X_18634_ _23005_/D _14871_/Y _14875_/X _18633_/X _14244_/Y VPWR VGND sg13g2_a22oi_1
X_15846_ _16171_/A _18714_/A _15889_/S _15845_/Y VPWR VGND sg13g2_o21ai_1
XFILLER_80_805 VPWR VGND sg13g2_fill_1
XFILLER_0_1717 VPWR VGND sg13g2_decap_4
XFILLER_98_1871 VPWR VGND sg13g2_fill_2
XFILLER_4_1886 VPWR VGND sg13g2_decap_8
XFILLER_64_367 VPWR VGND sg13g2_decap_4
XFILLER_98_1893 VPWR VGND sg13g2_fill_1
XFILLER_18_773 VPWR VGND sg13g2_decap_8
X_18565_ _18565_/Y _22995_/Q _18565_/B VPWR VGND sg13g2_nand2_1
X_12989_ _12990_/A _12989_/A _12989_/B _12989_/C _12989_/D VPWR VGND sg13g2_or4_1
X_15777_ _15777_/Y _22471_/Q _15935_/S VPWR VGND sg13g2_nand2b_1
XFILLER_33_710 VPWR VGND sg13g2_decap_4
X_17516_ _17518_/A _17527_/A _16084_/C _17629_/B VPWR VGND sg13g2_a21oi_1
X_14728_ _14728_/X _14668_/Y _14666_/Y _14728_/S VPWR VGND sg13g2_mux2_1
X_18496_ _18497_/C _18363_/Y _18530_/B _18297_/A VPWR VGND sg13g2_o21ai_1
XFILLER_32_242 VPWR VGND sg13g2_decap_8
XFILLER_33_776 VPWR VGND sg13g2_decap_8
X_14659_ _14659_/Y _14659_/A _14659_/B VPWR VGND sg13g2_nand2_1
X_17447_ _17447_/Y _17447_/A _17467_/B VPWR VGND sg13g2_nand2_1
XFILLER_92_1470 VPWR VGND sg13g2_decap_8
XFILLER_21_938 VPWR VGND sg13g2_fill_2
XFILLER_53_1421 VPWR VGND sg13g2_decap_8
XFILLER_60_584 VPWR VGND sg13g2_fill_2
XFILLER_105_1500 VPWR VGND sg13g2_fill_1
XFILLER_92_1481 VPWR VGND sg13g2_fill_1
XFILLER_18_1563 VPWR VGND sg13g2_decap_8
XFILLER_14_990 VPWR VGND sg13g2_decap_8
Xrebuffer5416 _11781_/B _11882_/B VPWR VGND sg13g2_buf_1
Xplace3703 _15319_/A _11865_/A VPWR VGND sg13g2_buf_1
X_17378_ _17379_/B _22815_/Q _16357_/A _17385_/S VPWR VGND sg13g2_mux2_1
Xrebuffer5427 _15585_/A _12464_/Y VPWR VGND sg13g2_buf_1
XFILLER_14_1427 VPWR VGND sg13g2_fill_1
Xrebuffer5438 _13290_/A2 _13035_/A2 VPWR VGND sg13g2_buf_2
Xplace3714 _20117_/B place3714/A VPWR VGND sg13g2_buf_2
Xplace3725 _19777_/B place3725/A VPWR VGND sg13g2_buf_2
XFILLER_9_460 VPWR VGND sg13g2_fill_2
XFILLER_105_1566 VPWR VGND sg13g2_fill_1
X_19117_ _23095_/D _23095_/Q _18024_/B _19130_/S VPWR VGND sg13g2_mux2_1
Xrebuffer5449 _13222_/B _13356_/B VPWR VGND sg13g2_buf_1
Xplace3736 _20294_/A _19351_/B VPWR VGND sg13g2_buf_1
X_16329_ _22541_/D _16331_/B _16331_/C _16328_/Y VPWR VGND sg13g2_a21oi_1
Xplace3747 _19463_/S _19325_/X VPWR VGND sg13g2_buf_1
XFILLER_70_1790 VPWR VGND sg13g2_fill_2
XFILLER_88_1528 VPWR VGND sg13g2_fill_2
Xplace3758 _20179_/B _13220_/A VPWR VGND sg13g2_buf_1
Xplace3769 _14039_/A _12340_/A VPWR VGND sg13g2_buf_1
XFILLER_64_0 VPWR VGND sg13g2_decap_8
Xhold5106 _20419_/A _23274_/Q VPWR VGND sg13g2_dlygate4sd3_1
XFILLER_31_1763 VPWR VGND sg13g2_decap_4
X_19048_ _19048_/Y _23061_/Q _19019_/A _19048_/B1 VPWR VGND sg13g2_o21ai_1
Xhold5117 _22178_/A _24080_/Q VPWR VGND sg13g2_dlygate4sd3_1
Xhold5128 _20386_/A _23258_/Q VPWR VGND sg13g2_dlygate4sd3_1
Xhold5139 _21859_/A _23926_/Q VPWR VGND sg13g2_dlygate4sd3_1
X_21010_ _21010_/Y _21010_/A _21019_/B VPWR VGND sg13g2_nand2_1
XFILLER_114_564 VPWR VGND sg13g2_decap_8
XFILLER_99_253 VPWR VGND sg13g2_decap_8
XFILLER_59_106 VPWR VGND sg13g2_fill_1
XFILLER_9_1731 VPWR VGND sg13g2_decap_8
XFILLER_60_1403 VPWR VGND sg13g2_fill_2
XFILLER_68_640 VPWR VGND sg13g2_decap_4
XFILLER_25_1545 VPWR VGND sg13g2_decap_8
X_22961_ _22961_/Q _23187_/CLK _22961_/D fanout2916/X VPWR VGND sg13g2_dfrbpq_1
XFILLER_21_1409 VPWR VGND sg13g2_decap_8
XFILLER_28_515 VPWR VGND sg13g2_decap_8
XFILLER_28_526 VPWR VGND sg13g2_fill_1
XFILLER_42_1870 VPWR VGND sg13g2_fill_1
XFILLER_56_846 VPWR VGND sg13g2_decap_8
X_21912_ _23953_/D _21978_/A0 _23953_/Q _21915_/S VPWR VGND sg13g2_mux2_1
XFILLER_112_1559 VPWR VGND sg13g2_fill_2
X_22892_ _22892_/Q _22893_/CLK _22892_/D fanout2820/X VPWR VGND sg13g2_dfrbpq_1
XFILLER_82_142 VPWR VGND sg13g2_fill_1
XFILLER_3_1363 VPWR VGND sg13g2_decap_8
XFILLER_43_507 VPWR VGND sg13g2_decap_8
X_21843_ _21843_/Y _23920_/Q _21843_/B VPWR VGND sg13g2_nand2_1
XFILLER_70_359 VPWR VGND sg13g2_fill_1
XFILLER_51_540 VPWR VGND sg13g2_fill_1
Xinput4359 _17888_/A1 boot_addr_i[17] VPWR VGND sg13g2_buf_1
XFILLER_58_1387 VPWR VGND sg13g2_fill_1
X_23513_ _23513_/Q clkload55/A _23513_/D fanout2782/X VPWR VGND sg13g2_dfrbpq_1
XFILLER_24_776 VPWR VGND sg13g2_decap_8
XFILLER_106_1308 VPWR VGND sg13g2_fill_2
X_20725_ _20725_/Y _20725_/A _20727_/B VPWR VGND sg13g2_nand2_1
XFILLER_11_404 VPWR VGND sg13g2_fill_2
XFILLER_51_584 VPWR VGND sg13g2_fill_1
XFILLER_11_426 VPWR VGND sg13g2_decap_8
XFILLER_71_1532 VPWR VGND sg13g2_decap_8
XFILLER_17_1040 VPWR VGND sg13g2_decap_8
XFILLER_36_1663 VPWR VGND sg13g2_decap_8
XFILLER_11_448 VPWR VGND sg13g2_decap_4
X_23444_ _23444_/Q _24210_/CLK _23444_/D fanout2635/X VPWR VGND sg13g2_dfrbpq_1
XFILLER_71_1554 VPWR VGND sg13g2_decap_4
X_20656_ _20656_/Y _20656_/A _20666_/B VPWR VGND sg13g2_nand2_1
XFILLER_32_1527 VPWR VGND sg13g2_decap_8
XFILLER_7_419 VPWR VGND sg13g2_fill_1
XFILLER_23_78 VPWR VGND sg13g2_decap_8
XFILLER_109_314 VPWR VGND sg13g2_decap_8
XFILLER_104_1032 VPWR VGND sg13g2_decap_8
XFILLER_104_1043 VPWR VGND sg13g2_fill_2
XFILLER_32_1549 VPWR VGND sg13g2_decap_8
X_23375_ _23375_/Q clkload31/A _23375_/D fanout2645/X VPWR VGND sg13g2_dfrbpq_1
XFILLER_104_1076 VPWR VGND sg13g2_decap_4
XFILLER_99_49 VPWR VGND sg13g2_decap_8
X_22326_ _22326_/Y _24151_/Q _22335_/B VPWR VGND sg13g2_nand2_1
XFILLER_10_1858 VPWR VGND sg13g2_decap_8
X_22257_ _22257_/Y _24117_/Q _22269_/B VPWR VGND sg13g2_nand2_1
XFILLER_65_1314 VPWR VGND sg13g2_decap_8
XFILLER_69_1494 VPWR VGND sg13g2_decap_4
XFILLER_3_669 VPWR VGND sg13g2_fill_2
X_12010_ _12017_/A _12774_/B _12010_/B VPWR VGND sg13g2_nor2_1
Xhold4950 _21961_/A _23975_/Q VPWR VGND sg13g2_dlygate4sd3_1
X_21208_ _23627_/D _21677_/A1 _21209_/B _21207_/Y VPWR VGND sg13g2_o21ai_1
Xhold4961 _22170_/A _24075_/Q VPWR VGND sg13g2_dlygate4sd3_1
XFILLER_78_415 VPWR VGND sg13g2_fill_2
XFILLER_26_1309 VPWR VGND sg13g2_fill_1
XFILLER_65_1358 VPWR VGND sg13g2_fill_2
XFILLER_105_586 VPWR VGND sg13g2_decap_8
Xhold4972 _21022_/A _23549_/Q VPWR VGND sg13g2_dlygate4sd3_1
Xhold4983 _20025_/A _23233_/Q VPWR VGND sg13g2_dlygate4sd3_1
Xhold4994 _17396_/A _22820_/Q VPWR VGND sg13g2_dlygate4sd3_1
X_21139_ _23594_/D _21606_/A1 _21138_/B _21138_/Y VPWR VGND sg13g2_o21ai_1
XFILLER_82_1672 VPWR VGND sg13g2_decap_8
XFILLER_63_1060 VPWR VGND sg13g2_decap_4
X_13961_ _13961_/X _23604_/Q _23636_/Q _23668_/Q _23700_/Q _13961_/S0 _13964_/S1 VPWR
+ VGND sg13g2_mux4_1
XFILLER_4_1116 VPWR VGND sg13g2_decap_8
XFILLER_21_1910 VPWR VGND sg13g2_decap_8
XFILLER_101_792 VPWR VGND sg13g2_decap_8
X_12912_ _12912_/Y _12712_/A _12904_/X _12906_/X _12911_/Y VPWR VGND sg13g2_a22oi_1
X_15700_ _15704_/A _22767_/Q _15700_/B VPWR VGND sg13g2_nand2_1
XFILLER_19_548 VPWR VGND sg13g2_fill_2
X_13892_ _13892_/X _24179_/Q _24211_/Q _23251_/Q _23283_/Q _13900_/S0 _13900_/S1 VPWR
+ VGND sg13g2_mux4_1
XFILLER_47_868 VPWR VGND sg13g2_decap_8
XFILLER_59_1107 VPWR VGND sg13g2_decap_4
Xclkbuf_3_3_0_clk_i clkbuf_3_3_0_clk_i/X clkbuf_0_clk_i/X VPWR VGND sg13g2_buf_16
XFILLER_73_131 VPWR VGND sg13g2_decap_4
XFILLER_104_70 VPWR VGND sg13g2_decap_8
XFILLER_0_49 VPWR VGND sg13g2_decap_8
XFILLER_21_1954 VPWR VGND sg13g2_fill_1
X_15631_ _15631_/Y _22464_/Q _16000_/S VPWR VGND sg13g2_nand2b_1
XFILLER_64_41 VPWR VGND sg13g2_decap_4
X_12843_ _12843_/Y _12843_/A _20066_/A VPWR VGND sg13g2_nand2_1
XFILLER_76_1432 VPWR VGND sg13g2_fill_2
X_18350_ _18350_/Y _18350_/A VPWR VGND sg13g2_inv_1
X_15562_ _15562_/Y _15562_/A _15562_/B _15562_/C _15562_/D VPWR VGND sg13g2_nor4_1
X_12774_ _12774_/Y _12782_/A _12774_/B VPWR VGND sg13g2_nor2_1
XFILLER_14_242 VPWR VGND sg13g2_decap_4
XFILLER_37_1427 VPWR VGND sg13g2_fill_1
XFILLER_9_14 VPWR VGND sg13g2_fill_2
X_17301_ _22780_/D _16203_/A _17300_/B _17300_/Y VPWR VGND sg13g2_o21ai_1
X_14513_ _14519_/C _14513_/A _14513_/B _14513_/C _14513_/D VPWR VGND sg13g2_nand4_1
X_11725_ _11731_/A _11725_/A _11725_/B _11725_/C _11725_/D VPWR VGND sg13g2_nor4_2
XFILLER_37_1449 VPWR VGND sg13g2_fill_2
XFILLER_70_871 VPWR VGND sg13g2_decap_8
XFILLER_19_1850 VPWR VGND sg13g2_decap_4
X_18281_ _18281_/Y _18541_/A1 _18464_/A _18318_/A VPWR VGND sg13g2_a21oi_1
XFILLER_15_798 VPWR VGND sg13g2_decap_8
XFILLER_80_40 VPWR VGND sg13g2_fill_2
XFILLER_70_1020 VPWR VGND sg13g2_decap_8
XFILLER_80_51 VPWR VGND sg13g2_fill_2
X_14444_ _14444_/X _17532_/A _22992_/Q _22993_/Q _14444_/D VPWR VGND sg13g2_and4_1
X_17232_ _17232_/Y _22749_/Q _16084_/C _14885_/C VPWR VGND sg13g2_a21oi_1
X_11656_ _11656_/Y _15257_/A _14021_/B VPWR VGND sg13g2_nor2_1
XFILLER_70_1031 VPWR VGND sg13g2_fill_1
XFILLER_106_1853 VPWR VGND sg13g2_decap_8
XFILLER_50_1627 VPWR VGND sg13g2_decap_8
XFILLER_50_1638 VPWR VGND sg13g2_fill_2
XFILLER_70_1064 VPWR VGND sg13g2_fill_1
X_17163_ _17163_/Y _22736_/Q _17163_/B VPWR VGND sg13g2_xnor2_1
XFILLER_11_971 VPWR VGND sg13g2_fill_1
XFILLER_7_920 VPWR VGND sg13g2_decap_4
X_14375_ _14377_/C _15247_/A _15247_/B _15187_/C VPWR VGND sg13g2_or3_1
XFILLER_50_1649 VPWR VGND sg13g2_fill_2
XFILLER_89_1837 VPWR VGND sg13g2_fill_2
XFILLER_10_470 VPWR VGND sg13g2_fill_1
X_11587_ _14080_/B _14118_/A _14118_/C _11623_/D VPWR VGND sg13g2_and3_2
XFILLER_7_953 VPWR VGND sg13g2_fill_2
X_13326_ _13326_/Y _17762_/A _13987_/B VPWR VGND sg13g2_nand2_1
X_17094_ _17100_/A _22724_/Q VPWR VGND sg13g2_inv_1
XFILLER_7_975 VPWR VGND sg13g2_fill_1
XFILLER_109_870 VPWR VGND sg13g2_decap_8
X_13257_ _13257_/Y _23498_/Q _13259_/B VPWR VGND sg13g2_nand2b_1
X_12208_ _12209_/D _12318_/A _12207_/X _11951_/A VPWR VGND sg13g2_o21ai_1
XFILLER_48_1556 VPWR VGND sg13g2_decap_8
X_13188_ _13188_/X _23561_/Q _24009_/Q _13645_/A VPWR VGND sg13g2_mux2_1
XFILLER_9_1027 VPWR VGND sg13g2_fill_1
XFILLER_96_223 VPWR VGND sg13g2_decap_4
X_19804_ _19804_/Y _19804_/A _19930_/B VPWR VGND sg13g2_nor2_1
XFILLER_61_1701 VPWR VGND sg13g2_decap_8
XFILLER_111_534 VPWR VGND sg13g2_decap_8
X_12139_ _12139_/Y _11477_/X _12138_/Y _13028_/B VPWR VGND sg13g2_a21oi_1
Xfanout2650 fanout2650/X fanout2651/X VPWR VGND sg13g2_buf_1
Xfanout2661 fanout2661/X fanout2663/X VPWR VGND sg13g2_buf_1
XFILLER_96_234 VPWR VGND sg13g2_fill_1
XFILLER_85_908 VPWR VGND sg13g2_fill_1
XFILLER_42_1100 VPWR VGND sg13g2_fill_1
X_17996_ _18155_/B _18560_/S _17992_/X _17995_/Y VPWR VGND sg13g2_a21o_1
Xfanout2672 fanout2672/X fanout2673/X VPWR VGND sg13g2_buf_1
Xfanout2683 fanout2683/X fanout2685/X VPWR VGND sg13g2_buf_1
XFILLER_96_278 VPWR VGND sg13g2_fill_2
X_19735_ _19735_/Y _20005_/A _19735_/B VPWR VGND sg13g2_nand2_1
Xfanout2694 fanout2694/X fanout2696/X VPWR VGND sg13g2_buf_1
X_16947_ _16948_/B _16947_/A _17024_/A _16947_/C _16947_/D VPWR VGND sg13g2_nor4_1
XFILLER_81_1193 VPWR VGND sg13g2_decap_8
Xclkbuf_4_6__f_clk_i clkbuf_leaf_9_clk_i/A clkbuf_3_3_0_clk_i/X VPWR VGND sg13g2_buf_8
XFILLER_78_993 VPWR VGND sg13g2_decap_8
XFILLER_113_1857 VPWR VGND sg13g2_decap_8
XFILLER_77_492 VPWR VGND sg13g2_decap_8
X_16878_ _16878_/Y _22686_/Q _16878_/B VPWR VGND sg13g2_xnor2_1
XFILLER_37_356 VPWR VGND sg13g2_decap_4
XFILLER_53_816 VPWR VGND sg13g2_decap_8
XFILLER_4_1683 VPWR VGND sg13g2_decap_8
X_15829_ _15829_/Y _15829_/A _15829_/B _15829_/C _15829_/D VPWR VGND sg13g2_nand4_1
X_19597_ _19597_/X _19608_/A _19603_/B VPWR VGND sg13g2_and2_1
XFILLER_53_849 VPWR VGND sg13g2_decap_8
XFILLER_64_186 VPWR VGND sg13g2_decap_8
XFILLER_52_337 VPWR VGND sg13g2_decap_8
X_18548_ _18860_/B _17994_/B _23076_/Q _18548_/S VPWR VGND sg13g2_mux2_1
XFILLER_100_28 VPWR VGND sg13g2_decap_8
XFILLER_94_1598 VPWR VGND sg13g2_decap_8
XFILLER_21_713 VPWR VGND sg13g2_decap_4
X_18479_ _18479_/X _18562_/B _18498_/A _18479_/C _18479_/D VPWR VGND sg13g2_and4_1
XFILLER_33_584 VPWR VGND sg13g2_fill_2
XFILLER_72_1830 VPWR VGND sg13g2_fill_2
Xplace4201 _13274_/S0 _13962_/S0 VPWR VGND sg13g2_buf_4
XFILLER_60_392 VPWR VGND sg13g2_fill_2
Xplace4212 _13275_/S0 _12577_/C VPWR VGND sg13g2_buf_2
Xplace4223 _13008_/B _13985_/B VPWR VGND sg13g2_buf_2
Xplace4234 _12906_/A _12452_/A VPWR VGND sg13g2_buf_1
X_21490_ _23764_/D _21622_/A1 _21489_/B _21489_/Y VPWR VGND sg13g2_o21ai_1
Xrebuffer5213 _13138_/A _13553_/A1 VPWR VGND sg13g2_buf_1
Xplace3500 _17444_/A1 _16356_/A VPWR VGND sg13g2_buf_1
Xplace4245 _13606_/S1 _13614_/S1 VPWR VGND sg13g2_buf_1
Xrebuffer5224 _19801_/A _11933_/Y VPWR VGND sg13g2_buf_2
Xplace3511 _17173_/B _17177_/A VPWR VGND sg13g2_buf_1
Xrebuffer5235 _11736_/A _11329_/B VPWR VGND sg13g2_buf_1
Xplace4256 _13983_/S1 _13680_/S1 VPWR VGND sg13g2_buf_8
Xplace4267 _12297_/S1 _11538_/S1 VPWR VGND sg13g2_buf_1
Xrebuffer5246 _16684_/A1 _16036_/A VPWR VGND sg13g2_buf_1
Xplace3522 _15873_/B _15992_/A2 VPWR VGND sg13g2_buf_1
X_20441_ _20504_/B _20649_/B _22318_/B VPWR VGND sg13g2_nand2_1
Xrebuffer5257 _19607_/A1 place3729/A VPWR VGND sg13g2_buf_1
Xplace4278 _13591_/B _13676_/B VPWR VGND sg13g2_buf_2
Xplace3533 _15945_/A2 _15639_/B VPWR VGND sg13g2_buf_1
Xplace3544 _15989_/A2 _16005_/B VPWR VGND sg13g2_buf_1
Xplace4289 _13606_/S0 _13621_/S VPWR VGND sg13g2_buf_4
Xrebuffer5268 _14720_/A _12797_/B2 VPWR VGND sg13g2_buf_1
Xplace3555 _15924_/B _15289_/X VPWR VGND sg13g2_buf_1
Xrebuffer5279 _12458_/A place3978/A VPWR VGND sg13g2_buf_1
Xplace3566 _12968_/B _13526_/B VPWR VGND sg13g2_buf_1
X_23160_ _23160_/Q clkload15/A _23160_/D fanout2860/X VPWR VGND sg13g2_dfrbpq_1
Xplace3577 _16774_/D _15323_/X VPWR VGND sg13g2_buf_1
XFILLER_88_1347 VPWR VGND sg13g2_fill_1
Xplace3588 _19760_/A _19874_/B VPWR VGND sg13g2_buf_1
Xrebuffer4578 _11497_/B2 _11491_/Y VPWR VGND sg13g2_buf_2
Xplace3599 _17824_/B1 _17580_/B VPWR VGND sg13g2_buf_1
X_22111_ _22111_/Y _22111_/A _22117_/B VPWR VGND sg13g2_nand2_1
Xrebuffer4589 _13526_/B _12114_/Y VPWR VGND sg13g2_buf_4
X_23091_ _23091_/Q _23215_/CLK _23091_/D fanout2911/X VPWR VGND sg13g2_dfrbpq_1
XFILLER_115_873 VPWR VGND sg13g2_decap_8
XFILLER_86_1082 VPWR VGND sg13g2_decap_8
X_22042_ _22042_/Y _22042_/A _22048_/B VPWR VGND sg13g2_nand2_1
XFILLER_88_724 VPWR VGND sg13g2_fill_1
XFILLER_102_512 VPWR VGND sg13g2_decap_8
XFILLER_60_1200 VPWR VGND sg13g2_decap_8
XFILLER_85_18 VPWR VGND sg13g2_decap_8
XFILLER_60_1222 VPWR VGND sg13g2_decap_8
XFILLER_102_589 VPWR VGND sg13g2_decap_8
XFILLER_87_278 VPWR VGND sg13g2_decap_8
XFILLER_87_289 VPWR VGND sg13g2_fill_1
X_23993_ _23993_/Q clkload56/A _23993_/D fanout2748/X VPWR VGND sg13g2_dfrbpq_1
XFILLER_29_824 VPWR VGND sg13g2_decap_8
XFILLER_5_1436 VPWR VGND sg13g2_fill_1
XFILLER_68_470 VPWR VGND sg13g2_fill_1
XFILLER_99_1443 VPWR VGND sg13g2_fill_1
X_22944_ _22944_/Q _23187_/CLK _22944_/D fanout2917/X VPWR VGND sg13g2_dfrbpq_1
XFILLER_21_1239 VPWR VGND sg13g2_fill_1
XFILLER_29_879 VPWR VGND sg13g2_decap_8
XFILLER_55_131 VPWR VGND sg13g2_decap_8
XFILLER_71_613 VPWR VGND sg13g2_decap_4
XFILLER_28_389 VPWR VGND sg13g2_decap_8
X_22875_ _22875_/Q clkload27/A _22875_/D fanout2894/X VPWR VGND sg13g2_dfrbpq_1
XFILLER_3_1193 VPWR VGND sg13g2_decap_8
XFILLER_43_337 VPWR VGND sg13g2_decap_8
XFILLER_77_1763 VPWR VGND sg13g2_decap_8
X_21826_ _21826_/Y _23910_/Q _21826_/B VPWR VGND sg13g2_nand2_1
XFILLER_93_1053 VPWR VGND sg13g2_fill_2
XFILLER_24_562 VPWR VGND sg13g2_decap_8
XFILLER_90_1941 VPWR VGND sg13g2_decap_8
XFILLER_12_735 VPWR VGND sg13g2_decap_8
X_11510_ _12575_/A _22988_/Q _12778_/A VPWR VGND sg13g2_nor2b_2
XFILLER_51_392 VPWR VGND sg13g2_fill_2
XFILLER_54_1059 VPWR VGND sg13g2_decap_8
XFILLER_12_757 VPWR VGND sg13g2_decap_4
X_20708_ _23408_/D _20297_/Y _20713_/B _20707_/Y VPWR VGND sg13g2_o21ai_1
XFILLER_12_779 VPWR VGND sg13g2_decap_8
XFILLER_11_245 VPWR VGND sg13g2_decap_8
X_21688_ _23858_/D _21980_/A1 _21687_/B _21687_/Y VPWR VGND sg13g2_o21ai_1
X_23427_ _23427_/Q _24196_/CLK _23427_/D fanout2701/X VPWR VGND sg13g2_dfrbpq_1
X_11441_ _11441_/X _11440_/Y _22549_/Q _11441_/S VPWR VGND sg13g2_mux2_1
XFILLER_71_1384 VPWR VGND sg13g2_fill_1
X_20639_ _23374_/D _22442_/A1 _20638_/B _20638_/Y VPWR VGND sg13g2_o21ai_1
XFILLER_109_133 VPWR VGND sg13g2_decap_8
XFILLER_7_249 VPWR VGND sg13g2_fill_1
XFILLER_32_1357 VPWR VGND sg13g2_fill_1
XFILLER_50_43 VPWR VGND sg13g2_fill_2
X_14160_ _17039_/B _14428_/A _14585_/B VPWR VGND sg13g2_nand2_1
X_11372_ _11372_/Y _11331_/Y _11365_/Y _11371_/Y VPWR VGND sg13g2_o21ai_1
XFILLER_4_901 VPWR VGND sg13g2_decap_8
X_23358_ _23358_/Q _24190_/CLK _23358_/D fanout2775/X VPWR VGND sg13g2_dfrbpq_1
XFILLER_4_912 VPWR VGND sg13g2_fill_2
XFILLER_3_400 VPWR VGND sg13g2_decap_4
XFILLER_101_1750 VPWR VGND sg13g2_decap_8
XFILLER_49_1810 VPWR VGND sg13g2_decap_4
X_13111_ _13111_/X _13111_/A _13111_/B VPWR VGND sg13g2_and2_1
X_22309_ _24143_/D _22309_/A0 _24143_/Q _22315_/S VPWR VGND sg13g2_mux2_1
XFILLER_84_1712 VPWR VGND sg13g2_fill_2
XFILLER_49_1832 VPWR VGND sg13g2_decap_4
X_14091_ _19494_/B _19480_/B _11592_/A VPWR VGND sg13g2_nor2b_1
XFILLER_10_1666 VPWR VGND sg13g2_decap_8
X_23289_ _23289_/Q _24190_/CLK _23289_/D fanout2773/X VPWR VGND sg13g2_dfrbpq_1
XFILLER_10_1677 VPWR VGND sg13g2_decap_8
XFILLER_106_862 VPWR VGND sg13g2_decap_8
XFILLER_65_1111 VPWR VGND sg13g2_fill_1
X_13042_ _13042_/Y _13042_/A _13042_/B VPWR VGND sg13g2_nand2_1
XFILLER_45_1718 VPWR VGND sg13g2_fill_2
XFILLER_65_1144 VPWR VGND sg13g2_fill_1
Xhold4780 _20690_/A _23398_/Q VPWR VGND sg13g2_dlygate4sd3_1
XFILLER_79_757 VPWR VGND sg13g2_decap_8
X_17850_ _22915_/D _16063_/A _17849_/C _17849_/Y VPWR VGND sg13g2_o21ai_1
Xhold4791 _21735_/A _23873_/Q VPWR VGND sg13g2_dlygate4sd3_1
X_16801_ _16802_/A _22671_/Q VPWR VGND sg13g2_inv_1
XFILLER_94_727 VPWR VGND sg13g2_decap_4
XFILLER_93_204 VPWR VGND sg13g2_decap_8
XFILLER_8_1071 VPWR VGND sg13g2_fill_1
X_17781_ _17781_/Y _17192_/A _17810_/A2 _17810_/B1 _17780_/Y VPWR VGND sg13g2_a22oi_1
X_14993_ _14993_/Y _22531_/Q VPWR VGND sg13g2_inv_1
XFILLER_87_790 VPWR VGND sg13g2_decap_8
XFILLER_115_91 VPWR VGND sg13g2_decap_8
X_19520_ _19520_/Y _20294_/A _19486_/Y _19519_/Y VPWR VGND sg13g2_o21ai_1
X_16732_ _16735_/C _22654_/Q _22653_/Q VPWR VGND sg13g2_nand2_1
XFILLER_93_248 VPWR VGND sg13g2_decap_8
X_13944_ _13944_/Y _13931_/A _13869_/Y _13941_/Y _13943_/Y VPWR VGND sg13g2_a22oi_1
XFILLER_19_345 VPWR VGND sg13g2_decap_8
XFILLER_19_356 VPWR VGND sg13g2_fill_1
XFILLER_62_602 VPWR VGND sg13g2_fill_1
X_19451_ _19451_/Y _19703_/A _19646_/B VPWR VGND sg13g2_nor2_1
X_16663_ _22647_/D _15934_/A _16673_/A _16662_/Y VPWR VGND sg13g2_a21oi_1
X_13875_ _13877_/A _13541_/Y _13874_/Y _13729_/Y VPWR VGND sg13g2_a21o_1
XFILLER_62_624 VPWR VGND sg13g2_fill_1
XFILLER_1_1867 VPWR VGND sg13g2_decap_8
X_18402_ _18402_/Y _18539_/A _18403_/B _18401_/Y VPWR VGND sg13g2_a21oi_1
X_15614_ _15628_/B _22923_/Q _15552_/B _15698_/A2 _22495_/Q VPWR VGND sg13g2_a22oi_1
X_19382_ _19483_/A _14021_/B _20356_/A _19448_/B VPWR VGND sg13g2_mux2_1
XFILLER_34_359 VPWR VGND sg13g2_decap_8
XFILLER_56_1814 VPWR VGND sg13g2_decap_8
X_16594_ _16638_/B _16594_/A _16594_/B VPWR VGND sg13g2_nor2_1
XFILLER_95_1874 VPWR VGND sg13g2_decap_8
XFILLER_56_1825 VPWR VGND sg13g2_decap_8
XFILLER_108_1904 VPWR VGND sg13g2_decap_8
XFILLER_95_1885 VPWR VGND sg13g2_fill_2
XFILLER_91_1716 VPWR VGND sg13g2_fill_2
XFILLER_15_551 VPWR VGND sg13g2_decap_4
XFILLER_72_1104 VPWR VGND sg13g2_decap_8
X_18333_ _18334_/C _18562_/C _18377_/A _18332_/Y VPWR VGND sg13g2_a21oi_1
X_15545_ _15545_/Y _23007_/Q VPWR VGND sg13g2_inv_1
X_12757_ _12757_/Y _20009_/B _12757_/B VPWR VGND sg13g2_nor2_1
XFILLER_91_83 VPWR VGND sg13g2_fill_2
X_11708_ _12473_/A _12128_/A _11708_/B VPWR VGND sg13g2_or2_1
X_18264_ _18264_/Y _18264_/A _18403_/A VPWR VGND sg13g2_nand2_1
X_15476_ _15481_/A _22885_/Q _15182_/X _17399_/B _22838_/Q VPWR VGND sg13g2_a22oi_1
X_12688_ _12691_/C _13028_/A _13028_/B _12688_/C VPWR VGND sg13g2_nor3_1
XFILLER_19_1691 VPWR VGND sg13g2_decap_8
XFILLER_15_1533 VPWR VGND sg13g2_decap_4
XFILLER_50_1413 VPWR VGND sg13g2_decap_8
X_14427_ _14578_/A _14427_/A _14427_/B _14427_/C _14427_/D VPWR VGND sg13g2_and4_1
X_17215_ _17215_/Y _17215_/A _17220_/B VPWR VGND sg13g2_nor2_1
XFILLER_30_587 VPWR VGND sg13g2_decap_8
XFILLER_102_1514 VPWR VGND sg13g2_decap_8
X_18195_ _22966_/D _11247_/B _18286_/A _18194_/Y VPWR VGND sg13g2_a21oi_1
XFILLER_102_1525 VPWR VGND sg13g2_fill_2
X_14358_ _17391_/A _15245_/A _14358_/B VPWR VGND sg13g2_nor2_1
XFILLER_7_761 VPWR VGND sg13g2_decap_8
X_13309_ _13309_/X _24043_/Q _24075_/Q _13591_/B VPWR VGND sg13g2_mux2_1
X_17077_ _17083_/C _22720_/Q _22719_/Q _22718_/Q _22717_/Q VPWR VGND sg13g2_nand4_1
XFILLER_67_1921 VPWR VGND sg13g2_fill_2
X_14289_ _16782_/B _19673_/A _14347_/B VPWR VGND sg13g2_nand2_1
XFILLER_115_147 VPWR VGND sg13g2_decap_8
XFILLER_83_1200 VPWR VGND sg13g2_fill_2
XFILLER_67_1954 VPWR VGND sg13g2_fill_1
XFILLER_87_1391 VPWR VGND sg13g2_fill_2
XFILLER_83_1222 VPWR VGND sg13g2_fill_1
XFILLER_48_1342 VPWR VGND sg13g2_fill_2
XFILLER_112_810 VPWR VGND sg13g2_decap_8
XFILLER_100_1293 VPWR VGND sg13g2_fill_2
XFILLER_83_1233 VPWR VGND sg13g2_decap_8
XFILLER_69_212 VPWR VGND sg13g2_fill_1
XFILLER_28_1949 VPWR VGND sg13g2_decap_4
XFILLER_83_1288 VPWR VGND sg13g2_fill_2
XFILLER_111_342 VPWR VGND sg13g2_fill_2
XFILLER_27_0 VPWR VGND sg13g2_fill_2
XFILLER_69_267 VPWR VGND sg13g2_fill_2
XFILLER_112_887 VPWR VGND sg13g2_decap_4
XFILLER_97_587 VPWR VGND sg13g2_fill_2
XFILLER_26_1662 VPWR VGND sg13g2_decap_8
XFILLER_113_1621 VPWR VGND sg13g2_fill_2
X_17979_ _18069_/A _17979_/A VPWR VGND sg13g2_inv_1
XFILLER_113_1632 VPWR VGND sg13g2_fill_1
XFILLER_6_1756 VPWR VGND sg13g2_decap_8
X_19718_ _19719_/B _20005_/A _19711_/Y _19717_/Y VPWR VGND sg13g2_a21oi_1
XFILLER_61_1586 VPWR VGND sg13g2_decap_8
X_20990_ _20990_/Y _20990_/A _20990_/B VPWR VGND sg13g2_nand2_1
XFILLER_93_760 VPWR VGND sg13g2_decap_8
XFILLER_26_805 VPWR VGND sg13g2_fill_2
XFILLER_93_771 VPWR VGND sg13g2_fill_1
XFILLER_1_70 VPWR VGND sg13g2_decap_8
X_19649_ _19649_/Y _19702_/A _19645_/Y _19648_/Y VPWR VGND sg13g2_o21ai_1
XFILLER_93_793 VPWR VGND sg13g2_fill_2
XFILLER_80_410 VPWR VGND sg13g2_fill_2
XFILLER_25_315 VPWR VGND sg13g2_decap_8
XFILLER_52_101 VPWR VGND sg13g2_decap_8
XFILLER_77_1037 VPWR VGND sg13g2_decap_8
XFILLER_25_326 VPWR VGND sg13g2_decap_8
XFILLER_77_1048 VPWR VGND sg13g2_fill_1
XFILLER_77_1059 VPWR VGND sg13g2_decap_8
X_22660_ _22660_/Q clkload24/A _22660_/D fanout2888/X VPWR VGND sg13g2_dfrbpq_1
XFILLER_80_443 VPWR VGND sg13g2_decap_8
XFILLER_111_49 VPWR VGND sg13g2_decap_8
X_21611_ _23821_/D _21972_/A0 _23821_/Q _21620_/S VPWR VGND sg13g2_mux2_1
XFILLER_34_882 VPWR VGND sg13g2_fill_1
XFILLER_52_178 VPWR VGND sg13g2_fill_2
XFILLER_94_1395 VPWR VGND sg13g2_decap_8
X_22591_ _22591_/Q clkload22/A _22591_/D fanout2875/X VPWR VGND sg13g2_dfrbpq_1
XFILLER_90_1259 VPWR VGND sg13g2_decap_8
X_21542_ _23787_/D _21677_/A1 _21549_/B _21541_/Y VPWR VGND sg13g2_o21ai_1
XFILLER_33_1611 VPWR VGND sg13g2_fill_1
XFILLER_33_1622 VPWR VGND sg13g2_decap_4
Xplace4020 _18444_/A1 _13131_/A VPWR VGND sg13g2_buf_2
Xplace4031 _14147_/C _12889_/C VPWR VGND sg13g2_buf_2
Xplace4042 _15073_/A _24228_/Q VPWR VGND sg13g2_buf_1
Xplace4053 _19045_/B _19023_/B VPWR VGND sg13g2_buf_1
X_24261_ _24261_/X _24261_/A VPWR VGND sg13g2_buf_1
X_21473_ _21473_/Y _23754_/Q _21473_/B VPWR VGND sg13g2_nand2_1
XFILLER_88_1100 VPWR VGND sg13g2_fill_2
Xplace4064 _18048_/S _18009_/A VPWR VGND sg13g2_buf_1
Xplace3330 _21343_/A0 _22373_/A1 VPWR VGND sg13g2_buf_1
Xplace4075 _14788_/A _24219_/Q VPWR VGND sg13g2_buf_1
X_23212_ _23212_/Q clkload33/A _23212_/D fanout2932/X VPWR VGND sg13g2_dfrbpq_1
Xplace4086 _20350_/A _19912_/S VPWR VGND sg13g2_buf_1
Xplace3341 _22288_/A1 _20075_/Y VPWR VGND sg13g2_buf_1
XFILLER_107_604 VPWR VGND sg13g2_decap_8
Xplace4097 _18463_/S _18393_/S VPWR VGND sg13g2_buf_1
X_20424_ _23276_/D _20702_/A1 _20429_/B _20423_/Y VPWR VGND sg13g2_o21ai_1
Xplace3352 _22407_/A1 _21178_/A1 VPWR VGND sg13g2_buf_1
Xplace3363 _21307_/A1 _19854_/Y VPWR VGND sg13g2_buf_1
X_24192_ _24192_/Q clkload41/A _24192_/D fanout2724/X VPWR VGND sg13g2_dfrbpq_1
XFILLER_14_1098 VPWR VGND sg13g2_decap_4
Xplace3374 _17872_/A _17517_/D VPWR VGND sg13g2_buf_1
Xplace3385 _17884_/A _15693_/A VPWR VGND sg13g2_buf_1
Xplace3396 _17502_/S _17439_/Y VPWR VGND sg13g2_buf_1
X_23143_ _23143_/Q clkload5/A _23143_/D fanout2840/X VPWR VGND sg13g2_dfrbpq_1
XFILLER_31_1390 VPWR VGND sg13g2_fill_1
X_20355_ _20355_/Y _20355_/A _20355_/B VPWR VGND sg13g2_nand2_1
XFILLER_105_7 VPWR VGND sg13g2_decap_8
XFILLER_106_147 VPWR VGND sg13g2_decap_8
X_23074_ _23074_/Q _23114_/CLK _23074_/D fanout2906/X VPWR VGND sg13g2_dfrbpq_1
XFILLER_115_670 VPWR VGND sg13g2_decap_8
XFILLER_27_1404 VPWR VGND sg13g2_fill_1
X_20286_ _20296_/B _24272_/A _20286_/B VPWR VGND sg13g2_nand2_1
XFILLER_96_28 VPWR VGND sg13g2_decap_8
XFILLER_81_1918 VPWR VGND sg13g2_decap_8
XFILLER_66_1464 VPWR VGND sg13g2_decap_8
XFILLER_81_1929 VPWR VGND sg13g2_fill_2
X_22025_ _22025_/Y _22025_/A _22025_/B VPWR VGND sg13g2_nand2_1
XFILLER_103_854 VPWR VGND sg13g2_fill_1
XFILLER_7_1509 VPWR VGND sg13g2_decap_4
XFILLER_62_1328 VPWR VGND sg13g2_decap_4
XFILLER_102_342 VPWR VGND sg13g2_decap_8
XFILLER_44_1762 VPWR VGND sg13g2_decap_8
XFILLER_102_375 VPWR VGND sg13g2_decap_8
XFILLER_9_1380 VPWR VGND sg13g2_decap_8
XFILLER_76_738 VPWR VGND sg13g2_fill_1
XFILLER_5_1244 VPWR VGND sg13g2_fill_1
XFILLER_29_88 VPWR VGND sg13g2_decap_4
X_23976_ _23976_/Q clkload31/A _23976_/D fanout2653/X VPWR VGND sg13g2_dfrbpq_1
X_11990_ _11990_/Y _11981_/Y _11982_/Y _11983_/Y _11989_/Y VPWR VGND sg13g2_a22oi_1
XFILLER_60_1085 VPWR VGND sg13g2_fill_1
XFILLER_56_451 VPWR VGND sg13g2_fill_2
XFILLER_1_1119 VPWR VGND sg13g2_fill_1
X_22927_ _22927_/Q _22941_/CLK _22927_/D fanout2801/X VPWR VGND sg13g2_dfrbpq_1
XFILLER_112_1186 VPWR VGND sg13g2_decap_8
XFILLER_56_484 VPWR VGND sg13g2_fill_1
XFILLER_95_1148 VPWR VGND sg13g2_fill_2
X_13660_ _13660_/Y _14103_/A _13660_/B VPWR VGND sg13g2_nor2_1
XFILLER_72_966 VPWR VGND sg13g2_fill_2
X_22858_ _22858_/Q _22869_/CLK _22858_/D fanout2793/X VPWR VGND sg13g2_dfrbpq_1
XFILLER_44_668 VPWR VGND sg13g2_decap_8
XFILLER_25_860 VPWR VGND sg13g2_fill_2
X_13591_ _13591_/Y _24142_/Q _13591_/B VPWR VGND sg13g2_nand2b_1
X_22789_ _22789_/Q clkload22/A _22789_/D fanout2876/X VPWR VGND sg13g2_dfrbpq_1
XFILLER_12_510 VPWR VGND sg13g2_decap_8
XFILLER_52_690 VPWR VGND sg13g2_decap_8
X_15330_ _15331_/B _15923_/A _15327_/Y _15329_/Y VPWR VGND sg13g2_o21ai_1
X_12542_ _12542_/Y _12542_/A _12623_/A VPWR VGND sg13g2_nor2b_1
XFILLER_8_503 VPWR VGND sg13g2_decap_8
XFILLER_40_863 VPWR VGND sg13g2_fill_2
XFILLER_16_1842 VPWR VGND sg13g2_decap_8
X_15261_ _15261_/Y _15261_/A _15261_/B _15972_/B _15261_/D VPWR VGND sg13g2_nor4_1
XFILLER_103_1812 VPWR VGND sg13g2_decap_8
X_12473_ _12480_/A _12473_/A _12473_/B VPWR VGND sg13g2_nor2_1
XFILLER_51_1755 VPWR VGND sg13g2_fill_1
X_14212_ _14213_/D _14743_/A _22835_/Q VPWR VGND sg13g2_nand2_1
X_17000_ _17000_/Y _22709_/Q _17000_/B VPWR VGND sg13g2_xnor2_1
XFILLER_103_1889 VPWR VGND sg13g2_decap_8
X_14143_ _14436_/C _14438_/C _22991_/Q _14143_/C VPWR VGND sg13g2_nand3b_1
X_11355_ _11355_/Y _11355_/A _11418_/A VPWR VGND sg13g2_nand2_1
XFILLER_10_1452 VPWR VGND sg13g2_fill_1
XFILLER_98_307 VPWR VGND sg13g2_fill_2
X_18951_ _18953_/B _18951_/A _18951_/B VPWR VGND sg13g2_nand2_1
X_11286_ _11287_/B _24183_/Q _23255_/Q _23319_/Q _23383_/Q _11508_/S0 _11295_/A VPWR
+ VGND sg13g2_mux4_1
XFILLER_84_1575 VPWR VGND sg13g2_decap_4
X_17902_ _17904_/A _17902_/A1 _17929_/A2 _17920_/B1 _17902_/B2 VPWR VGND sg13g2_a22oi_1
X_13025_ _14653_/B _13271_/A _13022_/X _13024_/X VPWR VGND sg13g2_o21ai_1
X_18882_ _18882_/Y _23046_/Q _18886_/A _18580_/X VPWR VGND sg13g2_o21ai_1
XFILLER_79_576 VPWR VGND sg13g2_fill_1
XFILLER_39_407 VPWR VGND sg13g2_decap_8
XFILLER_86_50 VPWR VGND sg13g2_decap_8
X_17833_ _17833_/Y _22910_/Q _17855_/A _17855_/B VPWR VGND sg13g2_nor3_1
XFILLER_114_1930 VPWR VGND sg13g2_decap_8
XFILLER_0_981 VPWR VGND sg13g2_fill_2
XFILLER_3_1918 VPWR VGND sg13g2_decap_8
X_17764_ _17764_/Y _23179_/Q _17801_/A2 _17822_/B1 _14441_/A VPWR VGND sg13g2_a22oi_1
XFILLER_94_579 VPWR VGND sg13g2_decap_8
X_14976_ _14976_/Y _14976_/A _14976_/B VPWR VGND sg13g2_nand2_1
XFILLER_97_1925 VPWR VGND sg13g2_decap_8
Xclkbuf_leaf_40_clk_i _24131_/CLK clkload2/A VPWR VGND sg13g2_buf_16
XFILLER_19_153 VPWR VGND sg13g2_decap_8
X_19503_ _19503_/Y _19505_/A _20249_/A1 VPWR VGND sg13g2_nor2b_1
XFILLER_110_1838 VPWR VGND sg13g2_decap_8
X_16715_ _16715_/Y _16728_/A _16715_/B VPWR VGND sg13g2_nor2_1
X_13927_ _13940_/A _13929_/A VPWR VGND sg13g2_inv_1
XFILLER_47_484 VPWR VGND sg13g2_fill_2
XFILLER_63_933 VPWR VGND sg13g2_fill_1
XFILLER_21_1581 VPWR VGND sg13g2_fill_1
XFILLER_63_955 VPWR VGND sg13g2_fill_1
X_19434_ _19434_/X _19760_/A _19757_/B _19757_/C VPWR VGND sg13g2_and3_1
XFILLER_78_1368 VPWR VGND sg13g2_fill_2
X_16646_ _16646_/Y _16656_/A _16646_/B VPWR VGND sg13g2_nor2_1
XFILLER_90_763 VPWR VGND sg13g2_decap_4
X_13858_ _13860_/C _13858_/A _13858_/B VPWR VGND sg13g2_and2_1
XFILLER_63_999 VPWR VGND sg13g2_fill_1
XFILLER_34_178 VPWR VGND sg13g2_decap_8
XFILLER_50_627 VPWR VGND sg13g2_fill_1
X_19365_ _19365_/Y _19443_/A _19367_/B VPWR VGND sg13g2_nand2_1
X_12809_ _12809_/X _12809_/A _23524_/Q VPWR VGND sg13g2_and2_1
X_16577_ _16577_/Y _16591_/A _16577_/B VPWR VGND sg13g2_nor2_1
XFILLER_16_893 VPWR VGND sg13g2_decap_4
XFILLER_15_370 VPWR VGND sg13g2_fill_2
X_13789_ _13790_/B _23601_/Q _23633_/Q _23665_/Q _23697_/Q _13798_/B2 _13795_/S1 VPWR
+ VGND sg13g2_mux4_1
XFILLER_91_1546 VPWR VGND sg13g2_decap_8
Xclkbuf_leaf_55_clk_i clkload42/A clkbuf_leaf_55_clk_i/A VPWR VGND sg13g2_buf_16
XFILLER_37_1054 VPWR VGND sg13g2_fill_1
XFILLER_108_1745 VPWR VGND sg13g2_decap_8
X_18316_ _18316_/Y _18530_/A _18415_/B _18315_/Y _18007_/Y _18334_/B VPWR VGND sg13g2_a221oi_1
X_15528_ _15535_/A _22759_/Q _15312_/Y _15317_/Y _22596_/Q VPWR VGND sg13g2_a22oi_1
X_19296_ _23213_/D _23213_/Q _20249_/A0 _19298_/S VPWR VGND sg13g2_mux2_1
X_18247_ _18247_/Y _18253_/B _18244_/X _18246_/Y _18498_/C VPWR VGND sg13g2_a22oi_1
XFILLER_30_384 VPWR VGND sg13g2_fill_2
XFILLER_30_1839 VPWR VGND sg13g2_fill_2
X_18178_ _18178_/Y _18425_/B _18498_/B VPWR VGND sg13g2_nor2_1
X_17129_ _17129_/Y _22730_/Q _17129_/B VPWR VGND sg13g2_xnor2_1
X_20140_ _20140_/Y _20140_/A _20140_/B _20140_/C _20140_/D VPWR VGND sg13g2_nand4_1
XFILLER_83_1041 VPWR VGND sg13g2_decap_4
XFILLER_67_1784 VPWR VGND sg13g2_decap_4
X_20071_ _20071_/Y _20071_/A _20071_/B VPWR VGND sg13g2_nand2_1
XFILLER_8_1818 VPWR VGND sg13g2_decap_8
XFILLER_28_1757 VPWR VGND sg13g2_decap_8
XFILLER_44_1014 VPWR VGND sg13g2_decap_8
XFILLER_83_1074 VPWR VGND sg13g2_decap_4
XFILLER_106_49 VPWR VGND sg13g2_decap_8
XFILLER_83_1085 VPWR VGND sg13g2_decap_4
XFILLER_100_813 VPWR VGND sg13g2_decap_8
XFILLER_115_1749 VPWR VGND sg13g2_decap_8
XFILLER_112_684 VPWR VGND sg13g2_decap_8
XFILLER_111_161 VPWR VGND sg13g2_decap_8
XFILLER_57_215 VPWR VGND sg13g2_fill_1
XFILLER_61_1350 VPWR VGND sg13g2_fill_2
XFILLER_100_846 VPWR VGND sg13g2_decap_8
X_23830_ _23830_/Q clkload58/A _23830_/D fanout2759/X VPWR VGND sg13g2_dfrbpq_1
XFILLER_57_248 VPWR VGND sg13g2_decap_8
XFILLER_22_1323 VPWR VGND sg13g2_fill_1
XFILLER_6_1575 VPWR VGND sg13g2_decap_8
XFILLER_96_1402 VPWR VGND sg13g2_decap_8
XFILLER_22_1345 VPWR VGND sg13g2_decap_8
XFILLER_61_1394 VPWR VGND sg13g2_decap_4
XFILLER_22_1356 VPWR VGND sg13g2_fill_1
X_23761_ _23761_/Q _24113_/CLK _23761_/D fanout2685/X VPWR VGND sg13g2_dfrbpq_1
XFILLER_54_922 VPWR VGND sg13g2_decap_8
X_20973_ _20973_/Y _20973_/A _20983_/B VPWR VGND sg13g2_nand2_1
XFILLER_38_495 VPWR VGND sg13g2_decap_8
XFILLER_54_955 VPWR VGND sg13g2_fill_1
XFILLER_57_1408 VPWR VGND sg13g2_decap_4
X_22712_ _22712_/Q clkload20/A _22712_/D fanout2868/X VPWR VGND sg13g2_dfrbpq_1
XFILLER_80_240 VPWR VGND sg13g2_decap_8
X_23692_ _23692_/Q clkload36/A _23692_/D fanout2710/X VPWR VGND sg13g2_dfrbpq_1
XFILLER_13_318 VPWR VGND sg13g2_decap_4
XFILLER_80_273 VPWR VGND sg13g2_decap_8
XFILLER_15_35 VPWR VGND sg13g2_decap_4
X_22643_ _22643_/Q clkload19/A _22643_/D fanout2862/X VPWR VGND sg13g2_dfrbpq_1
XFILLER_41_638 VPWR VGND sg13g2_decap_8
XFILLER_53_498 VPWR VGND sg13g2_decap_8
XFILLER_15_57 VPWR VGND sg13g2_decap_4
XFILLER_55_1143 VPWR VGND sg13g2_fill_1
XFILLER_90_1045 VPWR VGND sg13g2_decap_8
XFILLER_55_1165 VPWR VGND sg13g2_decap_8
XFILLER_70_1619 VPWR VGND sg13g2_decap_4
X_22574_ _22574_/Q clkload11/A _22574_/D fanout2839/X VPWR VGND sg13g2_dfrbpq_1
XFILLER_90_1089 VPWR VGND sg13g2_decap_8
X_21525_ _23778_/D _21952_/A1 _21530_/B _21524_/Y VPWR VGND sg13g2_o21ai_1
XFILLER_33_1441 VPWR VGND sg13g2_fill_1
XFILLER_72_1490 VPWR VGND sg13g2_fill_1
XFILLER_107_1288 VPWR VGND sg13g2_decap_8
X_21456_ _21456_/Y _23746_/Q _21456_/B VPWR VGND sg13g2_nand2_1
Xplace3160 _20727_/B _20784_/B VPWR VGND sg13g2_buf_1
Xplace3171 _20638_/B _20647_/B VPWR VGND sg13g2_buf_1
Xplace3182 _20572_/B _20581_/B VPWR VGND sg13g2_buf_1
X_20407_ _23267_/D _20685_/A1 _20426_/B _20406_/Y VPWR VGND sg13g2_o21ai_1
XFILLER_68_1526 VPWR VGND sg13g2_decap_8
Xplace3193 _20380_/B _20434_/S VPWR VGND sg13g2_buf_1
X_24175_ _24175_/Q clkload32/A _24175_/D fanout2647/X VPWR VGND sg13g2_dfrbpq_1
XFILLER_107_456 VPWR VGND sg13g2_decap_4
X_21387_ _21387_/Y _23713_/Q _21389_/B VPWR VGND sg13g2_nand2_1
XFILLER_107_478 VPWR VGND sg13g2_decap_8
XFILLER_85_1840 VPWR VGND sg13g2_decap_4
X_23126_ _23126_/Q clkload5/A _23126_/D fanout2833/X VPWR VGND sg13g2_dfrbpq_1
X_20338_ _20338_/Y _20338_/A _20338_/B _20338_/C VPWR VGND sg13g2_nand3_1
X_23057_ _23057_/Q _24214_/CLK _23057_/D fanout2928/X VPWR VGND sg13g2_dfrbpq_1
X_20269_ _20269_/Y _23246_/Q _20269_/B VPWR VGND sg13g2_nand2_1
XFILLER_62_1114 VPWR VGND sg13g2_decap_4
XFILLER_66_1294 VPWR VGND sg13g2_decap_8
XFILLER_89_885 VPWR VGND sg13g2_fill_1
X_22008_ _22008_/Y _23998_/Q _22008_/B VPWR VGND sg13g2_nand2_1
XFILLER_49_749 VPWR VGND sg13g2_decap_4
XFILLER_76_535 VPWR VGND sg13g2_fill_1
XFILLER_102_183 VPWR VGND sg13g2_decap_8
XFILLER_114_1259 VPWR VGND sg13g2_fill_1
X_14830_ _14831_/C _14853_/A1 _14829_/Y _14213_/B VPWR VGND sg13g2_o21ai_1
XFILLER_79_1600 VPWR VGND sg13g2_fill_1
XFILLER_5_1041 VPWR VGND sg13g2_decap_8
XFILLER_76_568 VPWR VGND sg13g2_decap_4
XFILLER_56_42 VPWR VGND sg13g2_decap_4
XFILLER_45_911 VPWR VGND sg13g2_decap_8
XFILLER_91_527 VPWR VGND sg13g2_decap_8
XFILLER_40_1467 VPWR VGND sg13g2_decap_8
XFILLER_45_922 VPWR VGND sg13g2_fill_2
XFILLER_56_75 VPWR VGND sg13g2_fill_2
X_11973_ _11973_/Y _11973_/A _11973_/B _11973_/C _11973_/D VPWR VGND sg13g2_nand4_1
X_14761_ _14762_/B _14756_/A _14755_/Y _17540_/A VPWR VGND sg13g2_a21oi_1
X_23959_ _23959_/Q clkload52/A _23959_/D fanout2690/X VPWR VGND sg13g2_dfrbpq_1
XFILLER_40_1478 VPWR VGND sg13g2_fill_2
XFILLER_56_86 VPWR VGND sg13g2_decap_8
XFILLER_56_281 VPWR VGND sg13g2_decap_8
X_16500_ _16500_/Y _15884_/A _15883_/Y _15884_/Y VPWR VGND sg13g2_a21oi_1
X_13712_ _13712_/Y _13960_/S1 _13706_/X _13708_/Y _13711_/Y _13966_/B VPWR VGND sg13g2_a221oi_1
X_14692_ _14692_/Y _14692_/A1 _14714_/A2 _14691_/Y VPWR VGND sg13g2_a21oi_1
X_17480_ _22857_/D _17480_/A1 _17489_/B _17479_/Y VPWR VGND sg13g2_o21ai_1
XFILLER_112_70 VPWR VGND sg13g2_decap_8
XFILLER_92_1822 VPWR VGND sg13g2_fill_1
XFILLER_18_1904 VPWR VGND sg13g2_decap_8
X_16431_ _16431_/Y _22583_/Q _16431_/B VPWR VGND sg13g2_nand2_1
X_13643_ _13643_/X _24047_/Q _24111_/Q _13643_/S VPWR VGND sg13g2_mux2_1
XFILLER_71_284 VPWR VGND sg13g2_fill_2
XFILLER_31_126 VPWR VGND sg13g2_decap_8
XFILLER_72_74 VPWR VGND sg13g2_decap_4
X_19150_ _19176_/B _19150_/A _19150_/B VPWR VGND sg13g2_nor2_1
XFILLER_9_801 VPWR VGND sg13g2_decap_8
XFILLER_92_1888 VPWR VGND sg13g2_fill_2
X_13574_ _13575_/B _23726_/Q _23758_/Q _23790_/Q _23822_/Q _13586_/A1 _13680_/S1 VPWR
+ VGND sg13g2_mux4_1
XFILLER_72_85 VPWR VGND sg13g2_decap_8
X_16362_ _16362_/Y _22749_/Q _16364_/B VPWR VGND sg13g2_nand2_1
XFILLER_12_362 VPWR VGND sg13g2_decap_8
X_18101_ _18103_/B _18288_/A _18279_/A VPWR VGND sg13g2_nand2_1
XFILLER_40_671 VPWR VGND sg13g2_fill_2
X_12525_ _12526_/B _12535_/A _12525_/B VPWR VGND sg13g2_xnor2_1
XFILLER_34_1249 VPWR VGND sg13g2_decap_8
X_19081_ _19081_/X _17982_/B _23109_/Q _19085_/S VPWR VGND sg13g2_mux2_1
X_16293_ _16295_/B _16322_/B _16293_/B VPWR VGND sg13g2_nand2_1
XFILLER_12_395 VPWR VGND sg13g2_decap_4
XFILLER_9_878 VPWR VGND sg13g2_fill_1
XFILLER_51_1563 VPWR VGND sg13g2_decap_8
XFILLER_51_1574 VPWR VGND sg13g2_fill_1
X_12456_ _12461_/B _14129_/A _12456_/B _12456_/C VPWR VGND sg13g2_nand3_1
XFILLER_51_1585 VPWR VGND sg13g2_decap_8
XFILLER_68_7 VPWR VGND sg13g2_fill_1
X_11407_ _11408_/A _11407_/A _11407_/B VPWR VGND sg13g2_nor2_1
X_15175_ _15577_/A _16774_/A _15625_/B VPWR VGND sg13g2_nand2_1
X_12387_ _12387_/X _13649_/A _12387_/B VPWR VGND sg13g2_and2_2
XFILLER_67_1025 VPWR VGND sg13g2_decap_8
X_14126_ _14127_/C _14428_/A _14117_/C _14591_/B _14125_/Y _22944_/Q VPWR VGND sg13g2_a221oi_1
XFILLER_10_1271 VPWR VGND sg13g2_decap_8
X_11338_ _12394_/B _11418_/B _11774_/A VPWR VGND sg13g2_nor2b_1
XFILLER_99_638 VPWR VGND sg13g2_decap_8
X_19983_ _19984_/C _19983_/A _19983_/B _20117_/C VPWR VGND sg13g2_nor3_1
XFILLER_45_1312 VPWR VGND sg13g2_decap_4
XFILLER_80_1203 VPWR VGND sg13g2_decap_8
X_18934_ _18936_/B _18931_/Y _18956_/B VPWR VGND sg13g2_nand2b_1
X_14057_ _14057_/Y _12639_/S _12539_/Y _14055_/A _14056_/X _12538_/A VPWR VGND sg13g2_a221oi_1
XFILLER_98_159 VPWR VGND sg13g2_decap_4
X_11269_ _11502_/C _11250_/A _11258_/B _22970_/Q VPWR VGND sg13g2_o21ai_1
X_13008_ _13008_/Y _13007_/X _13008_/B VPWR VGND sg13g2_nand2b_1
X_18865_ _18870_/A _23045_/Q _18865_/B _18865_/C VPWR VGND sg13g2_nand3_1
XFILLER_23_1621 VPWR VGND sg13g2_decap_8
XFILLER_7_1862 VPWR VGND sg13g2_decap_8
X_17816_ _17816_/Y _17823_/A1 _17814_/X _17815_/Y VPWR VGND sg13g2_o21ai_1
XFILLER_55_708 VPWR VGND sg13g2_decap_8
XFILLER_3_1715 VPWR VGND sg13g2_decap_8
X_18796_ _18801_/A _23034_/Q _18821_/B _18821_/C VPWR VGND sg13g2_nand3_1
XFILLER_97_1711 VPWR VGND sg13g2_fill_1
XFILLER_94_376 VPWR VGND sg13g2_decap_8
XFILLER_54_207 VPWR VGND sg13g2_decap_8
XFILLER_110_1635 VPWR VGND sg13g2_decap_8
X_17747_ _17747_/X _22569_/Q _17747_/B VPWR VGND sg13g2_xor2_1
X_14959_ _14959_/Y _17882_/A1 _14801_/B _14949_/A VPWR VGND sg13g2_o21ai_1
XFILLER_78_1165 VPWR VGND sg13g2_decap_8
X_17678_ _17678_/Y _17687_/A _22961_/Q VPWR VGND sg13g2_nand2_1
XFILLER_63_774 VPWR VGND sg13g2_decap_4
XFILLER_39_1138 VPWR VGND sg13g2_fill_1
XFILLER_62_262 VPWR VGND sg13g2_fill_1
X_19417_ _19417_/Y _19638_/S _19417_/B VPWR VGND sg13g2_nor2_1
XFILLER_90_571 VPWR VGND sg13g2_decap_8
XFILLER_78_1198 VPWR VGND sg13g2_fill_1
XFILLER_56_1430 VPWR VGND sg13g2_fill_1
X_16629_ _16634_/B _16629_/A VPWR VGND sg13g2_inv_1
XFILLER_50_435 VPWR VGND sg13g2_decap_4
XFILLER_22_148 VPWR VGND sg13g2_decap_8
XFILLER_91_1354 VPWR VGND sg13g2_fill_2
XFILLER_108_1553 VPWR VGND sg13g2_decap_8
XFILLER_91_1365 VPWR VGND sg13g2_fill_2
XFILLER_50_468 VPWR VGND sg13g2_decap_8
XFILLER_56_1496 VPWR VGND sg13g2_decap_4
XFILLER_108_1564 VPWR VGND sg13g2_fill_1
XFILLER_108_1575 VPWR VGND sg13g2_fill_2
XFILLER_104_1428 VPWR VGND sg13g2_decap_8
X_19279_ _23197_/D _23197_/Q _20249_/A1 _19298_/S VPWR VGND sg13g2_mux2_1
XFILLER_104_1439 VPWR VGND sg13g2_fill_1
X_22290_ _24132_/D _22356_/A1 _22291_/B _22289_/Y VPWR VGND sg13g2_o21ai_1
XFILLER_30_1636 VPWR VGND sg13g2_fill_2
XFILLER_11_1024 VPWR VGND sg13g2_fill_1
XFILLER_30_1647 VPWR VGND sg13g2_decap_8
XFILLER_30_1658 VPWR VGND sg13g2_fill_2
X_21241_ _23643_/D _21307_/A1 _21247_/B _21240_/Y VPWR VGND sg13g2_o21ai_1
XFILLER_105_905 VPWR VGND sg13g2_decap_8
XFILLER_69_1868 VPWR VGND sg13g2_fill_2
X_21172_ _23610_/D _21305_/A1 _21175_/B _21171_/Y VPWR VGND sg13g2_o21ai_1
X_20123_ _20123_/Y _20123_/A1 _20334_/B _20122_/Y VPWR VGND sg13g2_o21ai_1
XFILLER_8_1626 VPWR VGND sg13g2_decap_8
XFILLER_8_1637 VPWR VGND sg13g2_fill_2
XFILLER_112_481 VPWR VGND sg13g2_decap_8
XFILLER_28_1598 VPWR VGND sg13g2_decap_8
XFILLER_100_632 VPWR VGND sg13g2_decap_8
XFILLER_85_332 VPWR VGND sg13g2_decap_8
XFILLER_41_1732 VPWR VGND sg13g2_fill_2
XFILLER_86_888 VPWR VGND sg13g2_decap_8
XFILLER_41_1765 VPWR VGND sg13g2_fill_1
X_23813_ _23813_/Q clkload39/A _23813_/D fanout2738/X VPWR VGND sg13g2_dfrbpq_1
XFILLER_22_1164 VPWR VGND sg13g2_decap_8
XFILLER_27_933 VPWR VGND sg13g2_decap_8
XFILLER_73_549 VPWR VGND sg13g2_decap_8
XFILLER_38_281 VPWR VGND sg13g2_decap_8
XFILLER_26_34 VPWR VGND sg13g2_decap_8
X_23744_ _23744_/Q _24190_/CLK _23744_/D fanout2774/X VPWR VGND sg13g2_dfrbpq_1
X_20956_ _20956_/Y _23523_/Q _20962_/B VPWR VGND sg13g2_nand2_1
XFILLER_57_1216 VPWR VGND sg13g2_fill_1
XFILLER_76_1839 VPWR VGND sg13g2_decap_8
XFILLER_54_774 VPWR VGND sg13g2_decap_4
XFILLER_26_67 VPWR VGND sg13g2_fill_1
XFILLER_57_1238 VPWR VGND sg13g2_decap_8
XFILLER_13_104 VPWR VGND sg13g2_decap_8
XFILLER_109_1328 VPWR VGND sg13g2_fill_1
X_23675_ _23675_/Q clkload59/A _23675_/D fanout2789/X VPWR VGND sg13g2_dfrbpq_1
XFILLER_13_115 VPWR VGND sg13g2_fill_1
X_20887_ _23489_/D _21321_/A1 _20888_/B _20886_/Y VPWR VGND sg13g2_o21ai_1
XFILLER_35_1503 VPWR VGND sg13g2_decap_8
XFILLER_42_969 VPWR VGND sg13g2_decap_4
X_22626_ _22626_/Q clkload24/A _22626_/D fanout2898/X VPWR VGND sg13g2_dfrbpq_1
XFILLER_74_1563 VPWR VGND sg13g2_decap_4
XFILLER_13_159 VPWR VGND sg13g2_decap_8
XFILLER_70_1416 VPWR VGND sg13g2_decap_8
X_22557_ _22557_/Q clkload26/A _22557_/D fanout2853/X VPWR VGND sg13g2_dfrbpq_1
XFILLER_52_1872 VPWR VGND sg13g2_fill_2
X_12310_ _12310_/X _24158_/Q _23230_/Q _23294_/Q _23358_/Q _12203_/S _12485_/S VPWR
+ VGND sg13g2_mux4_1
X_21508_ _21508_/Y _23771_/Q _21508_/B VPWR VGND sg13g2_nand2_1
XFILLER_10_866 VPWR VGND sg13g2_decap_4
XFILLER_6_826 VPWR VGND sg13g2_decap_8
X_13290_ _13290_/X _11861_/A _13290_/A2 _13148_/Y VPWR VGND sg13g2_a21o_2
X_22488_ _22488_/Q clkload28/A _22488_/D fanout2871/X VPWR VGND sg13g2_dfrbpq_1
XFILLER_100_1804 VPWR VGND sg13g2_decap_8
XFILLER_10_899 VPWR VGND sg13g2_fill_2
XFILLER_5_325 VPWR VGND sg13g2_decap_8
X_12241_ _12256_/B _12241_/A _12241_/B _12241_/C _12241_/D VPWR VGND sg13g2_nor4_1
XFILLER_13_1878 VPWR VGND sg13g2_decap_8
X_24227_ _24227_/Q clkload5/A _24227_/D fanout2844/X VPWR VGND sg13g2_dfrbpq_1
XFILLER_5_336 VPWR VGND sg13g2_fill_1
X_21439_ _21439_/Y _21439_/A _21441_/B VPWR VGND sg13g2_nand2_1
XFILLER_68_1323 VPWR VGND sg13g2_fill_1
XFILLER_107_253 VPWR VGND sg13g2_decap_4
X_12172_ _12172_/X _23580_/Q _23612_/Q _23644_/Q _23676_/Q _12239_/S _12297_/S1 VPWR
+ VGND sg13g2_mux4_1
X_24158_ _24158_/Q _24190_/CLK _24158_/D fanout2773/X VPWR VGND sg13g2_dfrbpq_1
XFILLER_68_1367 VPWR VGND sg13g2_fill_1
XFILLER_107_286 VPWR VGND sg13g2_fill_2
XFILLER_107_297 VPWR VGND sg13g2_decap_4
X_23109_ _23109_/Q _23114_/CLK _23109_/D fanout2906/X VPWR VGND sg13g2_dfrbpq_1
X_24089_ _24089_/Q clkload56/A _24089_/D fanout2677/X VPWR VGND sg13g2_dfrbpq_1
X_16980_ _16993_/C _22705_/Q _22701_/Q _16980_/C _16980_/D VPWR VGND sg13g2_nand4_1
XFILLER_104_960 VPWR VGND sg13g2_decap_8
XFILLER_107_70 VPWR VGND sg13g2_decap_8
XFILLER_27_1031 VPWR VGND sg13g2_fill_1
XFILLER_110_418 VPWR VGND sg13g2_fill_2
XFILLER_46_1665 VPWR VGND sg13g2_fill_2
XFILLER_42_1507 VPWR VGND sg13g2_fill_1
X_15931_ _15931_/Y _20290_/A _15963_/B VPWR VGND sg13g2_nor2_1
XFILLER_103_470 VPWR VGND sg13g2_decap_8
XFILLER_49_524 VPWR VGND sg13g2_decap_8
XFILLER_77_833 VPWR VGND sg13g2_fill_1
XFILLER_103_481 VPWR VGND sg13g2_fill_2
XFILLER_27_1075 VPWR VGND sg13g2_decap_8
XFILLER_42_1529 VPWR VGND sg13g2_fill_2
XFILLER_103_492 VPWR VGND sg13g2_decap_8
XFILLER_81_1589 VPWR VGND sg13g2_fill_2
XFILLER_7_1169 VPWR VGND sg13g2_decap_8
X_18650_ _18655_/B _18657_/B _18661_/B _18657_/D VPWR VGND sg13g2_nor3_1
X_15862_ _15862_/Y _15947_/A1 _15861_/Y _15947_/B1 VPWR VGND sg13g2_o21ai_1
XFILLER_92_814 VPWR VGND sg13g2_decap_8
XFILLER_37_719 VPWR VGND sg13g2_decap_8
XFILLER_114_1078 VPWR VGND sg13g2_fill_1
XFILLER_97_1029 VPWR VGND sg13g2_fill_2
X_14813_ _14813_/Y _14220_/A _14812_/Y _16029_/A VPWR VGND sg13g2_a21oi_1
X_15793_ _15796_/B _14225_/A _15893_/B1 _15872_/B1 _22826_/Q VPWR VGND sg13g2_a22oi_1
XFILLER_40_1264 VPWR VGND sg13g2_decap_4
XFILLER_18_955 VPWR VGND sg13g2_decap_8
XFILLER_17_421 VPWR VGND sg13g2_fill_1
XFILLER_20_1849 VPWR VGND sg13g2_fill_2
XFILLER_29_281 VPWR VGND sg13g2_fill_1
X_17532_ _17586_/A _17532_/A _22945_/Q VPWR VGND sg13g2_nand2_1
XFILLER_94_1928 VPWR VGND sg13g2_decap_8
X_14744_ _14744_/Y _14213_/C _14743_/X _14210_/B VPWR VGND sg13g2_o21ai_1
X_11956_ _11956_/X _23738_/Q _23802_/Q _11960_/S VPWR VGND sg13g2_mux2_1
XFILLER_91_379 VPWR VGND sg13g2_fill_2
XFILLER_33_914 VPWR VGND sg13g2_fill_2
XFILLER_60_700 VPWR VGND sg13g2_decap_8
XFILLER_75_1327 VPWR VGND sg13g2_fill_1
XFILLER_2_1792 VPWR VGND sg13g2_decap_8
XFILLER_45_796 VPWR VGND sg13g2_fill_1
X_17463_ _22849_/D _16080_/Y _17462_/B _17462_/Y VPWR VGND sg13g2_o21ai_1
X_11887_ _11888_/B _11887_/A _11887_/B _11887_/C _11887_/D VPWR VGND sg13g2_and4_1
X_14675_ _14675_/Y _14715_/A _14720_/B VPWR VGND sg13g2_nand2_1
XFILLER_32_446 VPWR VGND sg13g2_fill_1
X_19202_ _23160_/D _11889_/A _19231_/S _19201_/Y VPWR VGND sg13g2_o21ai_1
X_16414_ _16414_/Y _22574_/Q _18697_/A VPWR VGND sg13g2_nand2_1
XFILLER_53_1614 VPWR VGND sg13g2_fill_1
X_13626_ _13626_/X _13778_/A1 _13923_/A2 _22574_/Q VPWR VGND sg13g2_a21o_1
XFILLER_109_1862 VPWR VGND sg13g2_decap_8
X_17394_ _17394_/Y _17394_/A _17629_/B VPWR VGND sg13g2_nor2_1
XFILLER_105_1704 VPWR VGND sg13g2_fill_2
XFILLER_18_1756 VPWR VGND sg13g2_decap_8
X_19133_ _23110_/D _23110_/Q _18871_/A _19134_/S VPWR VGND sg13g2_mux2_1
X_16345_ _16351_/C _22814_/Q _17373_/A _16344_/Y VPWR VGND sg13g2_a21oi_1
XFILLER_9_631 VPWR VGND sg13g2_decap_8
Xplace3907 _18363_/A _18451_/B VPWR VGND sg13g2_buf_1
X_13557_ _13568_/D _13271_/A _13554_/X _13556_/X VPWR VGND sg13g2_o21ai_1
XFILLER_105_1748 VPWR VGND sg13g2_decap_8
Xplace3918 _18297_/A _18331_/A VPWR VGND sg13g2_buf_1
XFILLER_70_1950 VPWR VGND sg13g2_decap_4
Xplace3929 _13234_/B2 _11379_/Y VPWR VGND sg13g2_buf_2
X_19064_ _19064_/X _19123_/A1 _23101_/Q _19077_/S VPWR VGND sg13g2_mux2_1
X_13488_ _13488_/Y _24077_/Q _13617_/B VPWR VGND sg13g2_nand2b_1
X_16276_ _16277_/B _14962_/B _16272_/Y _16276_/S VPWR VGND sg13g2_mux2_1
XFILLER_69_1109 VPWR VGND sg13g2_decap_8
XFILLER_103_1450 VPWR VGND sg13g2_decap_4
X_18015_ _18015_/X _18995_/A _23057_/Q _18015_/S VPWR VGND sg13g2_mux2_1
XFILLER_12_1344 VPWR VGND sg13g2_fill_1
X_15227_ _15227_/Y _15227_/A _15247_/A VPWR VGND sg13g2_nor2_1
X_12439_ _12440_/C _12439_/A _12531_/B _12439_/C VPWR VGND sg13g2_or3_1
XFILLER_99_413 VPWR VGND sg13g2_decap_8
XFILLER_86_1456 VPWR VGND sg13g2_decap_8
XFILLER_99_424 VPWR VGND sg13g2_fill_2
XFILLER_114_746 VPWR VGND sg13g2_decap_8
XFILLER_4_380 VPWR VGND sg13g2_fill_1
XFILLER_9_1913 VPWR VGND sg13g2_decap_8
XFILLER_4_391 VPWR VGND sg13g2_fill_1
X_14109_ _14110_/S _14433_/A _14433_/C VPWR VGND sg13g2_nor2_1
XFILLER_113_245 VPWR VGND sg13g2_decap_8
XFILLER_99_468 VPWR VGND sg13g2_fill_1
X_15089_ _15089_/Y _15089_/A _15089_/B VPWR VGND sg13g2_nor2_2
X_19966_ _19966_/Y _19956_/A _15562_/Y _20345_/A1 VPWR VGND sg13g2_a21oi_1
XFILLER_64_1743 VPWR VGND sg13g2_decap_8
XFILLER_101_407 VPWR VGND sg13g2_fill_2
XFILLER_80_1022 VPWR VGND sg13g2_fill_1
XFILLER_29_1874 VPWR VGND sg13g2_fill_1
XFILLER_64_1754 VPWR VGND sg13g2_fill_2
XFILLER_68_811 VPWR VGND sg13g2_decap_8
X_18917_ _23049_/D _18911_/Y _18914_/Y _18915_/Y _18916_/Y VPWR VGND sg13g2_a22oi_1
XFILLER_64_1765 VPWR VGND sg13g2_fill_2
XFILLER_86_129 VPWR VGND sg13g2_fill_1
XFILLER_29_1896 VPWR VGND sg13g2_decap_8
XFILLER_64_1776 VPWR VGND sg13g2_decap_8
X_19897_ _19898_/B _19824_/A _19364_/X _19896_/Y VPWR VGND sg13g2_o21ai_1
XFILLER_64_1787 VPWR VGND sg13g2_fill_1
XFILLER_95_630 VPWR VGND sg13g2_decap_8
XFILLER_80_1055 VPWR VGND sg13g2_fill_1
XFILLER_99_1806 VPWR VGND sg13g2_fill_2
XFILLER_95_652 VPWR VGND sg13g2_fill_1
XFILLER_80_1077 VPWR VGND sg13g2_fill_1
X_18848_ _18850_/B _18846_/Y _18847_/Y _18868_/S VPWR VGND sg13g2_mux2_1
XFILLER_67_354 VPWR VGND sg13g2_decap_4
XFILLER_95_685 VPWR VGND sg13g2_decap_8
XFILLER_103_28 VPWR VGND sg13g2_decap_8
XFILLER_94_184 VPWR VGND sg13g2_fill_2
X_18779_ _18779_/Y _18029_/S _23031_/Q _18766_/Y _18024_/B VPWR VGND sg13g2_a22oi_1
XFILLER_48_590 VPWR VGND sg13g2_fill_1
XFILLER_3_1567 VPWR VGND sg13g2_decap_8
X_20810_ _23454_/D _21314_/A1 _20809_/B _20809_/Y VPWR VGND sg13g2_o21ai_1
XFILLER_97_1563 VPWR VGND sg13g2_fill_1
X_21790_ _21790_/Y _21790_/A _21848_/B VPWR VGND sg13g2_nand2_1
XFILLER_51_700 VPWR VGND sg13g2_fill_1
XFILLER_58_1536 VPWR VGND sg13g2_decap_4
XFILLER_97_1596 VPWR VGND sg13g2_decap_8
XFILLER_35_262 VPWR VGND sg13g2_decap_4
XFILLER_36_796 VPWR VGND sg13g2_decap_8
X_20741_ _23421_/D _21312_/A1 _20742_/B _20740_/Y VPWR VGND sg13g2_o21ai_1
XFILLER_35_284 VPWR VGND sg13g2_decap_8
XFILLER_36_1801 VPWR VGND sg13g2_decap_8
XFILLER_51_766 VPWR VGND sg13g2_decap_8
X_23460_ _23460_/Q clkload41/A _23460_/D fanout2702/X VPWR VGND sg13g2_dfrbpq_1
XFILLER_75_1883 VPWR VGND sg13g2_fill_2
X_20672_ _23389_/D _22407_/A1 _20673_/B _20671_/Y VPWR VGND sg13g2_o21ai_1
XFILLER_91_1162 VPWR VGND sg13g2_decap_4
X_22411_ _22411_/Y _24191_/Q _22417_/B VPWR VGND sg13g2_nand2_1
XFILLER_104_1214 VPWR VGND sg13g2_decap_8
X_23391_ _23391_/Q clkload42/A _23391_/D fanout2728/X VPWR VGND sg13g2_dfrbpq_1
XFILLER_108_1383 VPWR VGND sg13g2_fill_2
XFILLER_17_1288 VPWR VGND sg13g2_fill_1
X_22342_ _24158_/D _22409_/A1 _22341_/B _22341_/Y VPWR VGND sg13g2_o21ai_1
XFILLER_30_1433 VPWR VGND sg13g2_decap_4
Xoutput4473 data_addr_o[15] _24260_/X VPWR VGND sg13g2_buf_1
Xoutput4484 data_addr_o[26] _24271_/X VPWR VGND sg13g2_buf_1
XFILLER_69_1632 VPWR VGND sg13g2_decap_8
Xoutput4495 data_addr_o[7] _24252_/X VPWR VGND sg13g2_buf_1
XFILLER_3_807 VPWR VGND sg13g2_fill_1
XFILLER_3_818 VPWR VGND sg13g2_decap_4
X_24012_ _24012_/Q _24210_/CLK _24012_/D fanout2637/X VPWR VGND sg13g2_dfrbpq_1
XFILLER_69_1665 VPWR VGND sg13g2_decap_8
XFILLER_65_1529 VPWR VGND sg13g2_decap_8
XFILLER_47_1941 VPWR VGND sg13g2_fill_2
X_21155_ _23604_/D _21622_/A1 _21154_/B _21154_/Y VPWR VGND sg13g2_o21ai_1
XFILLER_47_1952 VPWR VGND sg13g2_fill_2
X_20106_ _20106_/Y _24214_/Q _23188_/Q _20106_/C VPWR VGND sg13g2_nand3_1
X_21086_ _23572_/D _22317_/A1 _21085_/B _21085_/Y VPWR VGND sg13g2_o21ai_1
XFILLER_101_941 VPWR VGND sg13g2_decap_4
XFILLER_101_963 VPWR VGND sg13g2_fill_1
X_20037_ _20038_/B _20034_/Y _20117_/C _20036_/Y _20034_/A VPWR VGND sg13g2_a22oi_1
XFILLER_85_151 VPWR VGND sg13g2_decap_8
XFILLER_74_814 VPWR VGND sg13g2_decap_8
XFILLER_41_1540 VPWR VGND sg13g2_decap_4
XFILLER_74_825 VPWR VGND sg13g2_decap_8
XFILLER_41_1551 VPWR VGND sg13g2_decap_8
XFILLER_41_1562 VPWR VGND sg13g2_fill_2
XFILLER_73_313 VPWR VGND sg13g2_decap_8
XFILLER_46_549 VPWR VGND sg13g2_fill_1
X_11810_ _11810_/X _23801_/Q _23961_/Q _11810_/S VPWR VGND sg13g2_mux2_1
XFILLER_27_763 VPWR VGND sg13g2_decap_8
X_12790_ _12791_/B _23908_/Q _12889_/C _12789_/X _13275_/S0 _11457_/B VPWR VGND sg13g2_a221oi_1
XFILLER_27_774 VPWR VGND sg13g2_fill_2
XFILLER_61_519 VPWR VGND sg13g2_decap_8
XFILLER_15_925 VPWR VGND sg13g2_decap_8
XFILLER_2_1077 VPWR VGND sg13g2_fill_1
XFILLER_82_880 VPWR VGND sg13g2_decap_8
XFILLER_26_262 VPWR VGND sg13g2_decap_8
XFILLER_42_711 VPWR VGND sg13g2_decap_4
X_23727_ _23727_/Q clkload30/A _23727_/D fanout2656/X VPWR VGND sg13g2_dfrbpq_1
X_20939_ _23515_/D _21307_/A1 _20945_/B _20938_/Y VPWR VGND sg13g2_o21ai_1
XFILLER_14_424 VPWR VGND sg13g2_decap_8
XFILLER_57_1057 VPWR VGND sg13g2_decap_8
XFILLER_18_1019 VPWR VGND sg13g2_fill_1
XFILLER_54_1923 VPWR VGND sg13g2_decap_4
X_11672_ _11672_/Y _14028_/B _11671_/Y _19673_/B VPWR VGND sg13g2_o21ai_1
XFILLER_30_917 VPWR VGND sg13g2_fill_2
X_14460_ _14460_/Y _22943_/Q _19306_/C _14263_/A VPWR VGND sg13g2_a21oi_1
X_23658_ _23658_/Q clkload45/A _23658_/D fanout2729/X VPWR VGND sg13g2_dfrbpq_1
XFILLER_70_1202 VPWR VGND sg13g2_fill_2
X_13411_ _13428_/A _13576_/A1 _13408_/X _13410_/X VPWR VGND sg13g2_o21ai_1
X_22609_ _22609_/Q clkload10/A _22609_/D fanout2811/X VPWR VGND sg13g2_dfrbpq_1
X_14391_ _14434_/B _15216_/A _15216_/B _15216_/C VPWR VGND sg13g2_and3_1
X_23589_ _23589_/Q clkload42/A _23589_/D fanout2718/X VPWR VGND sg13g2_dfrbpq_1
X_16130_ _16130_/Y _17887_/A _16183_/B VPWR VGND sg13g2_nor2_1
X_13342_ _13342_/X _13338_/X _13339_/X _13340_/X _13341_/X _13131_/A _12674_/C VPWR
+ VGND sg13g2_mux4_1
XFILLER_87_1710 VPWR VGND sg13g2_decap_4
XFILLER_6_645 VPWR VGND sg13g2_decap_4
X_13273_ _13273_/Y _13552_/A VPWR VGND sg13g2_inv_1
X_16061_ _22486_/D _16060_/B _16059_/Y _16060_/Y VPWR VGND sg13g2_o21ai_1
XFILLER_13_1675 VPWR VGND sg13g2_decap_8
XFILLER_108_573 VPWR VGND sg13g2_decap_8
X_12224_ _12225_/B _24157_/Q _24189_/Q _12248_/S VPWR VGND sg13g2_mux2_1
X_15012_ _15012_/Y _15073_/A _23144_/Q VPWR VGND sg13g2_nand2_1
XFILLER_100_1667 VPWR VGND sg13g2_fill_2
XFILLER_29_1104 VPWR VGND sg13g2_decap_8
XFILLER_48_1727 VPWR VGND sg13g2_fill_2
XFILLER_68_1153 VPWR VGND sg13g2_decap_4
XFILLER_68_1175 VPWR VGND sg13g2_fill_2
X_19820_ _19820_/Y _19820_/A _19857_/B VPWR VGND sg13g2_nand2_1
Xfanout2810 fanout2810/X fanout2831/X VPWR VGND sg13g2_buf_1
XFILLER_78_51 VPWR VGND sg13g2_decap_8
Xfanout2821 fanout2821/X fanout2822/X VPWR VGND sg13g2_buf_1
XFILLER_97_928 VPWR VGND sg13g2_decap_4
Xfanout2832 fanout2832/X fanout2835/X VPWR VGND sg13g2_buf_1
XFILLER_111_716 VPWR VGND sg13g2_decap_8
Xfanout2843 fanout2843/X fanout2845/X VPWR VGND sg13g2_buf_1
Xfanout2854 fanout2854/X fanout2861/X VPWR VGND sg13g2_buf_1
X_12086_ _12086_/Y _14039_/A _12088_/A _14304_/C VPWR VGND sg13g2_nor3_1
XFILLER_2_895 VPWR VGND sg13g2_decap_4
X_16963_ _16963_/Y _17153_/A _17021_/B VPWR VGND sg13g2_nand2_1
Xfanout2865 fanout2865/X fanout2878/X VPWR VGND sg13g2_buf_1
Xfanout2876 fanout2876/X fanout2877/X VPWR VGND sg13g2_buf_1
XFILLER_1_383 VPWR VGND sg13g2_decap_4
Xfanout2887 fanout2887/X fanout2890/X VPWR VGND sg13g2_buf_1
XFILLER_42_1315 VPWR VGND sg13g2_decap_8
XFILLER_46_1495 VPWR VGND sg13g2_decap_8
Xfanout2898 fanout2898/X fanout2900/X VPWR VGND sg13g2_buf_1
X_15914_ _15914_/Y _15981_/S _16185_/A VPWR VGND sg13g2_nor2_1
X_19682_ _19682_/Y _20344_/A1 _19680_/Y _19681_/Y VPWR VGND sg13g2_a21oi_1
X_16894_ _16894_/X _22689_/Q _16894_/B VPWR VGND sg13g2_xor2_1
X_18633_ _18633_/X _23005_/Q _18633_/B VPWR VGND sg13g2_xor2_1
XFILLER_77_696 VPWR VGND sg13g2_fill_2
X_15845_ _15845_/Y _22571_/Q _15889_/S VPWR VGND sg13g2_nand2_1
XFILLER_65_847 VPWR VGND sg13g2_fill_1
XFILLER_111_1741 VPWR VGND sg13g2_decap_8
XFILLER_4_1865 VPWR VGND sg13g2_decap_8
XFILLER_92_655 VPWR VGND sg13g2_fill_1
XFILLER_91_132 VPWR VGND sg13g2_fill_1
XFILLER_111_1774 VPWR VGND sg13g2_fill_1
X_18564_ _18564_/Y _18564_/A1 _18560_/X _18563_/Y _18103_/B VPWR VGND sg13g2_a22oi_1
XFILLER_52_508 VPWR VGND sg13g2_fill_2
XFILLER_64_379 VPWR VGND sg13g2_fill_2
XFILLER_91_165 VPWR VGND sg13g2_fill_1
X_12988_ _12989_/B _13271_/A _12985_/X _12987_/X VPWR VGND sg13g2_o21ai_1
XFILLER_45_582 VPWR VGND sg13g2_fill_1
X_17515_ _17515_/Y _22748_/Q VPWR VGND sg13g2_inv_1
X_14727_ _14727_/X _14663_/Y _14661_/Y _14729_/S VPWR VGND sg13g2_mux2_1
X_18495_ _18497_/B _18498_/C _18259_/B _18479_/X _18494_/Y VPWR VGND sg13g2_a22oi_1
XFILLER_32_210 VPWR VGND sg13g2_decap_8
XFILLER_32_221 VPWR VGND sg13g2_fill_2
XFILLER_21_906 VPWR VGND sg13g2_fill_2
X_17446_ _22841_/D _16043_/A _17453_/B _17445_/Y VPWR VGND sg13g2_o21ai_1
XFILLER_18_1531 VPWR VGND sg13g2_decap_4
X_14658_ _14658_/X _14655_/Y _14657_/Y _14726_/S VPWR VGND sg13g2_mux2_1
X_13609_ _13609_/X _24175_/Q _24207_/Q _23247_/Q _23279_/Q _13610_/S0 _13981_/S1 VPWR
+ VGND sg13g2_mux4_1
X_17377_ _22814_/D _17372_/Y _17388_/B _17376_/Y VPWR VGND sg13g2_o21ai_1
Xrebuffer5417 _11886_/C _11882_/B VPWR VGND sg13g2_buf_1
XFILLER_53_1466 VPWR VGND sg13g2_decap_4
Xplace3704 _19322_/A _11778_/A VPWR VGND sg13g2_buf_1
Xrebuffer5428 _19978_/A _12464_/Y VPWR VGND sg13g2_buf_1
X_19116_ _23094_/D _23094_/Q _19116_/A1 _19130_/S VPWR VGND sg13g2_mux2_1
Xrebuffer5439 _13035_/A2 _12553_/Y VPWR VGND sg13g2_buf_2
Xplace3715 _20035_/B _12836_/B VPWR VGND sg13g2_buf_1
Xplace3726 _15289_/A _19671_/A VPWR VGND sg13g2_buf_1
X_16328_ _16328_/Y _16326_/A _16331_/B _16326_/B VPWR VGND sg13g2_a21oi_1
Xplace3737 _19443_/B _19448_/B VPWR VGND sg13g2_buf_1
Xplace3748 _17815_/A2 _17822_/A2 VPWR VGND sg13g2_buf_1
XFILLER_31_1742 VPWR VGND sg13g2_decap_8
Xplace3759 _16090_/S _19953_/B VPWR VGND sg13g2_buf_2
X_19047_ _19047_/Y _19047_/A _23093_/Q _19047_/C VPWR VGND sg13g2_nand3_1
Xhold5107 _20624_/A _23366_/Q VPWR VGND sg13g2_dlygate4sd3_1
X_16259_ _22522_/D _15117_/A _16256_/Y _16258_/Y _14908_/Y VPWR VGND sg13g2_a22oi_1
Xhold5118 _20644_/A _23378_/Q VPWR VGND sg13g2_dlygate4sd3_1
Xhold5129 _22236_/A _24107_/Q VPWR VGND sg13g2_dlygate4sd3_1
XFILLER_12_1185 VPWR VGND sg13g2_decap_8
XFILLER_57_0 VPWR VGND sg13g2_decap_4
XFILLER_114_543 VPWR VGND sg13g2_decap_8
XFILLER_99_232 VPWR VGND sg13g2_decap_8
XFILLER_82_1128 VPWR VGND sg13g2_decap_4
XFILLER_86_1297 VPWR VGND sg13g2_decap_8
XFILLER_99_276 VPWR VGND sg13g2_fill_1
XFILLER_102_749 VPWR VGND sg13g2_decap_8
XFILLER_101_248 VPWR VGND sg13g2_fill_1
XFILLER_9_1787 VPWR VGND sg13g2_decap_8
XFILLER_5_1618 VPWR VGND sg13g2_decap_4
XFILLER_96_972 VPWR VGND sg13g2_fill_2
X_22960_ _22960_/Q _23187_/CLK _22960_/D fanout2915/X VPWR VGND sg13g2_dfrbpq_1
XFILLER_68_663 VPWR VGND sg13g2_decap_8
XFILLER_112_1516 VPWR VGND sg13g2_fill_1
XFILLER_60_1448 VPWR VGND sg13g2_decap_8
XFILLER_114_49 VPWR VGND sg13g2_decap_8
XFILLER_60_1459 VPWR VGND sg13g2_fill_1
XFILLER_56_825 VPWR VGND sg13g2_decap_8
XFILLER_99_1647 VPWR VGND sg13g2_decap_8
XFILLER_95_482 VPWR VGND sg13g2_fill_2
X_21911_ _23952_/D _21977_/A1 _21910_/B _21910_/Y VPWR VGND sg13g2_o21ai_1
X_22891_ _22891_/Q _22893_/CLK _22891_/D fanout2820/X VPWR VGND sg13g2_dfrbpq_1
XFILLER_56_858 VPWR VGND sg13g2_decap_8
XFILLER_83_655 VPWR VGND sg13g2_fill_1
XFILLER_23_1281 VPWR VGND sg13g2_fill_1
X_21842_ _23919_/D _22309_/A0 _23919_/Q _21848_/B VPWR VGND sg13g2_mux2_1
XFILLER_71_828 VPWR VGND sg13g2_decap_8
XFILLER_3_1397 VPWR VGND sg13g2_decap_8
XFILLER_70_338 VPWR VGND sg13g2_decap_4
XFILLER_110_1295 VPWR VGND sg13g2_fill_2
X_21773_ _23887_/D _23887_/Q _21975_/A0 _21781_/S VPWR VGND sg13g2_mux2_1
XFILLER_93_1235 VPWR VGND sg13g2_decap_8
X_20724_ _23413_/D _20927_/A1 _20727_/B _20723_/Y VPWR VGND sg13g2_o21ai_1
X_23512_ _23512_/Q clkload54/A _23512_/D fanout2781/X VPWR VGND sg13g2_dfrbpq_1
XFILLER_12_917 VPWR VGND sg13g2_decap_8
XFILLER_12_928 VPWR VGND sg13g2_fill_2
XFILLER_71_1522 VPWR VGND sg13g2_fill_1
XFILLER_23_24 VPWR VGND sg13g2_fill_2
X_23443_ _23443_/Q clkload51/A _23443_/D fanout2665/X VPWR VGND sg13g2_dfrbpq_1
X_20655_ _23381_/D _20927_/A1 _20712_/S _20654_/Y VPWR VGND sg13g2_o21ai_1
X_23374_ _23374_/Q clkload35/A _23374_/D fanout2632/X VPWR VGND sg13g2_dfrbpq_1
XFILLER_20_972 VPWR VGND sg13g2_decap_8
XFILLER_17_1096 VPWR VGND sg13g2_decap_8
XFILLER_20_994 VPWR VGND sg13g2_decap_8
XFILLER_99_28 VPWR VGND sg13g2_decap_8
X_22325_ _24150_/D _19628_/Y _22328_/B _22324_/Y VPWR VGND sg13g2_o21ai_1
XFILLER_101_1943 VPWR VGND sg13g2_decap_8
XFILLER_101_1954 VPWR VGND sg13g2_fill_1
XFILLER_10_1837 VPWR VGND sg13g2_decap_8
XFILLER_30_1285 VPWR VGND sg13g2_decap_8
X_21207_ _21207_/Y _21207_/A _21209_/B VPWR VGND sg13g2_nand2_1
Xhold4940 _21564_/A _23798_/Q VPWR VGND sg13g2_dlygate4sd3_1
Xhold4951 _21232_/A _23639_/Q VPWR VGND sg13g2_dlygate4sd3_1
XFILLER_105_565 VPWR VGND sg13g2_decap_8
Xhold4962 _21584_/A _23807_/Q VPWR VGND sg13g2_dlygate4sd3_1
Xhold4973 _21465_/A _23750_/Q VPWR VGND sg13g2_dlygate4sd3_1
Xhold4984 _21638_/A _23833_/Q VPWR VGND sg13g2_dlygate4sd3_1
X_21138_ _21138_/Y _23594_/Q _21138_/B VPWR VGND sg13g2_nand2_1
XFILLER_43_1602 VPWR VGND sg13g2_fill_2
XFILLER_78_449 VPWR VGND sg13g2_fill_2
XFILLER_43_1613 VPWR VGND sg13g2_decap_8
Xhold4995 _21406_/A _23722_/Q VPWR VGND sg13g2_dlygate4sd3_1
XFILLER_47_1782 VPWR VGND sg13g2_decap_8
XFILLER_87_950 VPWR VGND sg13g2_fill_2
XFILLER_82_1695 VPWR VGND sg13g2_fill_1
XFILLER_43_1646 VPWR VGND sg13g2_fill_2
X_21069_ _23565_/D _23565_/Q _22440_/A1 _21082_/B VPWR VGND sg13g2_mux2_1
X_13960_ _13960_/X _13954_/X _13957_/Y _13958_/X _13959_/X _18444_/A1 _13960_/S1 VPWR
+ VGND sg13g2_mux4_1
XFILLER_43_1657 VPWR VGND sg13g2_decap_4
XFILLER_101_760 VPWR VGND sg13g2_fill_1
XFILLER_93_419 VPWR VGND sg13g2_fill_2
XFILLER_59_674 VPWR VGND sg13g2_decap_4
XFILLER_74_600 VPWR VGND sg13g2_fill_1
XFILLER_115_1173 VPWR VGND sg13g2_decap_8
XFILLER_24_1056 VPWR VGND sg13g2_fill_2
XFILLER_43_1679 VPWR VGND sg13g2_decap_8
X_12911_ _12911_/Y _13595_/B2 _12908_/Y _12910_/Y _13587_/B2 _12712_/A VPWR VGND sg13g2_a221oi_1
XFILLER_46_324 VPWR VGND sg13g2_fill_1
XFILLER_100_281 VPWR VGND sg13g2_decap_8
X_13891_ _13891_/X _23315_/Q _23347_/Q _23379_/Q _23411_/Q _13900_/S0 _13900_/S1 VPWR
+ VGND sg13g2_mux4_1
XFILLER_0_28 VPWR VGND sg13g2_decap_8
XFILLER_24_1089 VPWR VGND sg13g2_fill_2
XFILLER_46_335 VPWR VGND sg13g2_decap_8
XFILLER_47_858 VPWR VGND sg13g2_fill_1
XFILLER_74_644 VPWR VGND sg13g2_decap_8
XFILLER_59_1119 VPWR VGND sg13g2_fill_2
X_15630_ _17124_/A _16107_/A _16107_/B VPWR VGND sg13g2_nand2_1
XFILLER_73_143 VPWR VGND sg13g2_fill_1
X_12842_ _12847_/A _12830_/Y _12832_/Y _12834_/Y _12841_/Y VPWR VGND sg13g2_a22oi_1
XFILLER_46_379 VPWR VGND sg13g2_decap_4
XFILLER_64_53 VPWR VGND sg13g2_fill_1
XFILLER_55_880 VPWR VGND sg13g2_decap_8
X_15561_ _15562_/D _22850_/Q _15561_/B VPWR VGND sg13g2_and2_1
X_12773_ _12773_/X _24164_/Q _23300_/Q _13019_/A VPWR VGND sg13g2_mux2_1
XFILLER_15_755 VPWR VGND sg13g2_decap_8
XFILLER_64_97 VPWR VGND sg13g2_fill_1
X_17300_ _17300_/Y _17300_/A _17300_/B VPWR VGND sg13g2_nand2_1
XFILLER_15_766 VPWR VGND sg13g2_fill_1
X_14512_ _14513_/D _22591_/Q _23002_/Q VPWR VGND sg13g2_xnor2_1
XFILLER_72_1319 VPWR VGND sg13g2_decap_4
X_11724_ _11725_/D _13889_/B _11723_/X _11724_/B1 VPWR VGND sg13g2_o21ai_1
X_18280_ _18280_/Y _18361_/B _18279_/Y _18541_/A1 VPWR VGND sg13g2_o21ai_1
X_15492_ _17523_/A _15491_/A _15335_/B _15490_/Y _15491_/Y VPWR VGND sg13g2_a22oi_1
XFILLER_14_265 VPWR VGND sg13g2_decap_8
XFILLER_93_1791 VPWR VGND sg13g2_decap_8
XFILLER_54_1753 VPWR VGND sg13g2_decap_8
X_17231_ _22748_/D _16340_/Y _14882_/B _17527_/A _15572_/Y _17230_/Y VPWR VGND sg13g2_a221oi_1
XFILLER_14_298 VPWR VGND sg13g2_decap_4
X_14443_ _14444_/D _14434_/Y _14435_/Y _14442_/Y VPWR VGND sg13g2_o21ai_1
XFILLER_106_1832 VPWR VGND sg13g2_decap_8
XFILLER_19_1884 VPWR VGND sg13g2_decap_8
XFILLER_50_1606 VPWR VGND sg13g2_fill_2
XFILLER_89_1805 VPWR VGND sg13g2_decap_8
X_17162_ _17163_/B _17195_/A _17173_/B _17171_/B VPWR VGND sg13g2_nor3_1
XFILLER_80_85 VPWR VGND sg13g2_decap_8
X_14374_ _15247_/B _19673_/A _15186_/A VPWR VGND sg13g2_xnor2_1
XFILLER_11_983 VPWR VGND sg13g2_fill_1
XFILLER_31_1027 VPWR VGND sg13g2_fill_2
X_11586_ _14118_/C _22991_/Q _22992_/Q _22993_/Q _14436_/A VPWR VGND sg13g2_nor4_2
XFILLER_31_1038 VPWR VGND sg13g2_fill_1
XFILLER_102_1729 VPWR VGND sg13g2_fill_2
XFILLER_11_994 VPWR VGND sg13g2_decap_8
XFILLER_89_1849 VPWR VGND sg13g2_decap_8
XFILLER_31_1049 VPWR VGND sg13g2_fill_2
X_16113_ _17878_/A _16113_/A _15651_/B VPWR VGND sg13g2_nor2b_1
X_13325_ _17762_/A _22570_/Q VPWR VGND sg13g2_inv_1
X_17093_ _22723_/D _17092_/B _17091_/Y _17092_/Y VPWR VGND sg13g2_a21oi_1
XFILLER_13_1461 VPWR VGND sg13g2_fill_1
XFILLER_100_1420 VPWR VGND sg13g2_decap_8
XFILLER_6_475 VPWR VGND sg13g2_decap_8
XFILLER_115_329 VPWR VGND sg13g2_decap_8
XFILLER_50_7 VPWR VGND sg13g2_fill_1
X_16044_ _16044_/Y _22483_/Q _16071_/B _16043_/Y VPWR VGND sg13g2_a21oi_1
X_13256_ _13278_/C _13256_/A _13256_/B VPWR VGND sg13g2_nand2_1
XFILLER_87_1573 VPWR VGND sg13g2_decap_8
X_12207_ _12207_/X _23325_/Q _23389_/Q _12216_/S VPWR VGND sg13g2_mux2_1
XFILLER_9_1006 VPWR VGND sg13g2_decap_8
X_13187_ _13187_/Y _13187_/A1 _13383_/C _13186_/X VPWR VGND sg13g2_o21ai_1
XFILLER_69_416 VPWR VGND sg13g2_fill_1
XFILLER_111_513 VPWR VGND sg13g2_decap_8
X_12138_ _12138_/Y _12193_/S _23612_/Q _12137_/Y VPWR VGND sg13g2_o21ai_1
X_19803_ _19803_/Y _19803_/A _19803_/B VPWR VGND sg13g2_nor2_1
Xfanout2640 fanout2640/X fanout2643/X VPWR VGND sg13g2_buf_1
Xfanout2651 fanout2651/X fanout2652/X VPWR VGND sg13g2_buf_1
XFILLER_2_681 VPWR VGND sg13g2_decap_8
XFILLER_69_438 VPWR VGND sg13g2_decap_8
X_17995_ _17995_/Y _17993_/Y _17994_/Y _18549_/S VPWR VGND sg13g2_a21oi_1
Xfanout2662 fanout2662/X fanout2663/X VPWR VGND sg13g2_buf_1
XFILLER_97_769 VPWR VGND sg13g2_decap_8
Xfanout2673 fanout2673/X fanout2692/X VPWR VGND sg13g2_buf_1
XFILLER_81_1161 VPWR VGND sg13g2_fill_1
XFILLER_46_1281 VPWR VGND sg13g2_decap_8
Xfanout2684 fanout2684/X fanout2685/X VPWR VGND sg13g2_buf_1
XFILLER_96_257 VPWR VGND sg13g2_decap_8
XFILLER_81_1172 VPWR VGND sg13g2_decap_8
XFILLER_26_1855 VPWR VGND sg13g2_decap_8
X_19734_ _19734_/Y _19874_/B _19733_/Y _19538_/A VPWR VGND sg13g2_a21oi_1
X_16946_ _22699_/D _16945_/Y _17135_/A _16946_/S VPWR VGND sg13g2_mux2_1
X_12069_ _12111_/B _15227_/A _19446_/A VPWR VGND sg13g2_xnor2_1
XFILLER_6_1938 VPWR VGND sg13g2_decap_8
Xfanout2695 fanout2695/X fanout2696/X VPWR VGND sg13g2_buf_1
XFILLER_22_1708 VPWR VGND sg13g2_fill_1
XFILLER_113_1836 VPWR VGND sg13g2_decap_8
XFILLER_77_460 VPWR VGND sg13g2_fill_1
XFILLER_65_611 VPWR VGND sg13g2_fill_2
XFILLER_77_471 VPWR VGND sg13g2_decap_8
X_19665_ _19665_/Y _20033_/A1 _19662_/Y _19663_/X VPWR VGND sg13g2_a21oi_1
X_16877_ _16878_/B _16877_/A _16877_/B _16893_/A VPWR VGND sg13g2_nor3_1
XFILLER_49_195 VPWR VGND sg13g2_fill_2
XFILLER_65_644 VPWR VGND sg13g2_decap_8
X_18616_ _18626_/A _23000_/Q _23001_/Q _23002_/Q _18616_/D VPWR VGND sg13g2_nand4_1
X_15828_ _15829_/D _22773_/Q _15940_/B VPWR VGND sg13g2_nand2_1
XFILLER_93_997 VPWR VGND sg13g2_fill_1
X_19596_ _19612_/B _20307_/A _20335_/B VPWR VGND sg13g2_nor2_1
XFILLER_37_379 VPWR VGND sg13g2_decap_8
XFILLER_52_305 VPWR VGND sg13g2_decap_8
XFILLER_64_165 VPWR VGND sg13g2_decap_8
XFILLER_92_496 VPWR VGND sg13g2_decap_8
XFILLER_18_582 VPWR VGND sg13g2_fill_1
XFILLER_20_1476 VPWR VGND sg13g2_fill_2
XFILLER_59_1653 VPWR VGND sg13g2_decap_4
XFILLER_18_593 VPWR VGND sg13g2_decap_8
X_18547_ _22993_/D _18557_/B _18545_/Y _18546_/Y VPWR VGND sg13g2_o21ai_1
X_15759_ _22470_/D _16145_/A _15758_/X _15936_/S VPWR VGND sg13g2_mux2_1
XFILLER_94_1566 VPWR VGND sg13g2_decap_8
XFILLER_60_371 VPWR VGND sg13g2_decap_8
Xplace4202 _13962_/S0 _12577_/C VPWR VGND sg13g2_buf_4
X_17429_ _22834_/D _16197_/A _17432_/S _17428_/Y VPWR VGND sg13g2_o21ai_1
Xplace4213 _12577_/C _22984_/Q VPWR VGND sg13g2_buf_8
XFILLER_53_1252 VPWR VGND sg13g2_decap_8
Xplace4224 _13985_/B _22983_/Q VPWR VGND sg13g2_buf_4
Xplace4235 _12452_/A _12443_/A VPWR VGND sg13g2_buf_1
Xrebuffer5214 _13553_/A1 _12670_/Y VPWR VGND sg13g2_buf_2
Xplace4246 _13614_/S1 _13111_/A VPWR VGND sg13g2_buf_1
Xrebuffer5225 _14673_/A1 _11975_/B VPWR VGND sg13g2_buf_1
Xplace3501 _24269_/A _15048_/A1 VPWR VGND sg13g2_buf_2
XFILLER_20_268 VPWR VGND sg13g2_fill_2
XFILLER_33_1848 VPWR VGND sg13g2_decap_8
Xplace3512 _19234_/S _19200_/S VPWR VGND sg13g2_buf_1
Xplace4257 _13242_/S1 _12409_/S1 VPWR VGND sg13g2_buf_1
XFILLER_72_1897 VPWR VGND sg13g2_decap_8
Xrebuffer5236 _11554_/A2 _11329_/B VPWR VGND sg13g2_buf_1
Xrebuffer5247 _16036_/A _14397_/Y VPWR VGND sg13g2_buf_8
Xplace4268 _11427_/B _11538_/S1 VPWR VGND sg13g2_buf_4
Xplace3523 _15992_/A2 _15964_/A2 VPWR VGND sg13g2_buf_1
Xrebuffer5258 _11662_/A place3729/A VPWR VGND sg13g2_buf_1
Xplace4279 _13676_/B _13586_/A1 VPWR VGND sg13g2_buf_2
Xplace3534 _15639_/B _15270_/A VPWR VGND sg13g2_buf_1
Xplace3545 _15966_/B1 _16005_/B VPWR VGND sg13g2_buf_1
Xrebuffer5269 _12797_/B2 _12796_/Y VPWR VGND sg13g2_buf_8
XFILLER_101_1217 VPWR VGND sg13g2_decap_8
Xplace3556 _14005_/A place3556/A VPWR VGND sg13g2_buf_8
XFILLER_107_819 VPWR VGND sg13g2_fill_2
Xplace3567 _12531_/A _12439_/A VPWR VGND sg13g2_buf_1
X_20371_ _20435_/B _22430_/A _22252_/A VPWR VGND sg13g2_nand2b_1
XFILLER_109_49 VPWR VGND sg13g2_decap_8
Xplace3578 _19274_/B _19237_/S VPWR VGND sg13g2_buf_1
Xplace3589 _19702_/A _20028_/A VPWR VGND sg13g2_buf_1
Xclkload50 clkload50/Y clkload50/A VPWR VGND sg13g2_inv_4
XFILLER_88_1359 VPWR VGND sg13g2_decap_8
X_22110_ _24047_/D _24047_/Q _22177_/A1 _22116_/S VPWR VGND sg13g2_mux2_1
Xrebuffer4579 _15410_/A place3725/A VPWR VGND sg13g2_buf_1
X_23090_ _23090_/Q _23215_/CLK _23090_/D fanout2924/X VPWR VGND sg13g2_dfrbpq_1
XFILLER_115_852 VPWR VGND sg13g2_decap_8
X_22041_ _24015_/D _22309_/A0 _24015_/Q _22047_/S VPWR VGND sg13g2_mux2_1
XFILLER_66_1635 VPWR VGND sg13g2_fill_2
XFILLER_66_1679 VPWR VGND sg13g2_fill_2
XFILLER_69_950 VPWR VGND sg13g2_fill_1
XFILLER_102_568 VPWR VGND sg13g2_decap_8
XFILLER_9_1573 VPWR VGND sg13g2_fill_2
XFILLER_75_408 VPWR VGND sg13g2_decap_8
XFILLER_60_1234 VPWR VGND sg13g2_decap_8
X_23992_ _23992_/Q clkload46/A _23992_/D fanout2673/X VPWR VGND sg13g2_dfrbpq_1
XFILLER_25_1354 VPWR VGND sg13g2_fill_1
XFILLER_40_1819 VPWR VGND sg13g2_fill_2
XFILLER_60_1245 VPWR VGND sg13g2_fill_2
XFILLER_18_35 VPWR VGND sg13g2_decap_8
XFILLER_112_1346 VPWR VGND sg13g2_decap_8
X_22943_ _22943_/Q clkload27/A _22943_/D fanout2859/X VPWR VGND sg13g2_dfrbpq_1
XFILLER_83_430 VPWR VGND sg13g2_decap_8
XFILLER_83_441 VPWR VGND sg13g2_fill_1
XFILLER_18_57 VPWR VGND sg13g2_decap_4
XFILLER_95_1319 VPWR VGND sg13g2_decap_8
XFILLER_99_1499 VPWR VGND sg13g2_fill_1
X_22874_ _22874_/Q _22917_/CLK _22874_/D fanout2893/X VPWR VGND sg13g2_dfrbpq_1
XFILLER_3_1172 VPWR VGND sg13g2_decap_8
XFILLER_70_102 VPWR VGND sg13g2_fill_1
XFILLER_77_1742 VPWR VGND sg13g2_fill_1
X_21825_ _23909_/D _22292_/A1 _21826_/B _21824_/Y VPWR VGND sg13g2_o21ai_1
XFILLER_70_124 VPWR VGND sg13g2_decap_4
XFILLER_93_1032 VPWR VGND sg13g2_decap_8
XFILLER_24_530 VPWR VGND sg13g2_decap_8
XFILLER_73_1606 VPWR VGND sg13g2_decap_8
XFILLER_71_669 VPWR VGND sg13g2_decap_4
X_21756_ _21781_/S _22430_/B _21756_/B VPWR VGND sg13g2_nor2_1
X_20707_ _20707_/Y _20707_/A _20713_/B VPWR VGND sg13g2_nand2_1
XFILLER_34_89 VPWR VGND sg13g2_decap_8
XFILLER_11_224 VPWR VGND sg13g2_fill_1
X_21687_ _21687_/Y _21687_/A _21687_/B VPWR VGND sg13g2_nand2_1
XFILLER_11_257 VPWR VGND sg13g2_decap_8
XFILLER_7_206 VPWR VGND sg13g2_fill_1
Xclkload0 clkload0/X clkload0/A VPWR VGND sg13g2_buf_16
X_11440_ _11440_/Y _11917_/A _11929_/B _20272_/A VPWR VGND sg13g2_nor3_1
X_20638_ _20638_/Y _23374_/Q _20638_/B VPWR VGND sg13g2_nand2_1
X_23426_ _23426_/Q clkload41/A _23426_/D fanout2727/X VPWR VGND sg13g2_dfrbpq_1
XFILLER_36_1494 VPWR VGND sg13g2_fill_1
XFILLER_109_112 VPWR VGND sg13g2_decap_8
XFILLER_32_1369 VPWR VGND sg13g2_decap_8
X_11371_ _11371_/Y _23158_/Q _11929_/B _11441_/S _11367_/Y _11370_/X VPWR VGND sg13g2_a221oi_1
X_23357_ _23357_/Q clkload55/A _23357_/D fanout2775/X VPWR VGND sg13g2_dfrbpq_1
X_20569_ _20569_/Y _20569_/A _20581_/B VPWR VGND sg13g2_nand2_1
XFILLER_50_88 VPWR VGND sg13g2_decap_8
XFILLER_4_924 VPWR VGND sg13g2_fill_2
X_22308_ _24142_/D _22308_/A1 _22310_/B _22307_/Y VPWR VGND sg13g2_o21ai_1
X_13110_ _13111_/B _23240_/Q _23272_/Q _23368_/Q _23400_/Q _13610_/S0 _13115_/A VPWR
+ VGND sg13g2_mux4_1
XFILLER_109_189 VPWR VGND sg13g2_decap_8
X_14090_ _19480_/C _14090_/A _14090_/B _19489_/B _19489_/C VPWR VGND sg13g2_nor4_1
X_23288_ _23288_/Q clkload56/A _23288_/D fanout2747/X VPWR VGND sg13g2_dfrbpq_1
XFILLER_30_1082 VPWR VGND sg13g2_decap_8
XFILLER_88_1893 VPWR VGND sg13g2_decap_8
XFILLER_84_1735 VPWR VGND sg13g2_fill_2
X_13041_ _13042_/B _23911_/Q _24007_/Q _24103_/Q _24135_/Q _13039_/S _13582_/A VPWR
+ VGND sg13g2_mux4_1
X_22239_ _24108_/D _22305_/A1 _22241_/B _22238_/Y VPWR VGND sg13g2_o21ai_1
XFILLER_105_373 VPWR VGND sg13g2_fill_1
XFILLER_84_1779 VPWR VGND sg13g2_decap_8
XFILLER_3_489 VPWR VGND sg13g2_decap_8
XFILLER_26_1107 VPWR VGND sg13g2_fill_1
Xhold4770 _21242_/A _23644_/Q VPWR VGND sg13g2_dlygate4sd3_1
XFILLER_105_395 VPWR VGND sg13g2_decap_8
Xhold4781 _20590_/A _23350_/Q VPWR VGND sg13g2_dlygate4sd3_1
Xhold4792 _21119_/A _23585_/Q VPWR VGND sg13g2_dlygate4sd3_1
XFILLER_67_909 VPWR VGND sg13g2_decap_8
XFILLER_59_97 VPWR VGND sg13g2_decap_8
X_16800_ _22671_/D _16142_/A _16774_/Y _16799_/Y VPWR VGND sg13g2_o21ai_1
XFILLER_94_717 VPWR VGND sg13g2_decap_4
X_17780_ _17780_/Y _17809_/A1 _17778_/Y _17779_/Y VPWR VGND sg13g2_o21ai_1
XFILLER_66_419 VPWR VGND sg13g2_decap_8
X_14992_ _14992_/X _23142_/Q _16322_/A _15082_/A VPWR VGND sg13g2_mux2_1
XFILLER_115_70 VPWR VGND sg13g2_decap_8
XFILLER_43_1476 VPWR VGND sg13g2_decap_8
X_13943_ _13943_/Y _20338_/A _20338_/B _13942_/Y VPWR VGND sg13g2_o21ai_1
XFILLER_75_953 VPWR VGND sg13g2_decap_8
XFILLER_47_655 VPWR VGND sg13g2_decap_8
XFILLER_75_964 VPWR VGND sg13g2_fill_2
X_19450_ _19646_/B _19447_/Y _19589_/B _19587_/A VPWR VGND sg13g2_mux2_1
XFILLER_21_1741 VPWR VGND sg13g2_fill_2
X_16662_ _16662_/Y _16673_/A _16662_/B VPWR VGND sg13g2_nor2_1
XFILLER_74_463 VPWR VGND sg13g2_decap_8
XFILLER_46_165 VPWR VGND sg13g2_decap_8
XFILLER_47_688 VPWR VGND sg13g2_decap_8
X_13874_ _13874_/Y _20245_/B _13545_/B _20260_/A VPWR VGND sg13g2_a21oi_1
XFILLER_90_934 VPWR VGND sg13g2_fill_2
XFILLER_34_316 VPWR VGND sg13g2_decap_4
XFILLER_95_1831 VPWR VGND sg13g2_fill_1
XFILLER_1_1846 VPWR VGND sg13g2_decap_8
X_18401_ _18401_/Y _18401_/A _18217_/Y VPWR VGND sg13g2_nor2b_1
X_15613_ _15628_/A _22464_/Q _15639_/B _15964_/A2 _22600_/Q VPWR VGND sg13g2_a22oi_1
X_12825_ _20087_/B _13989_/A1 _12822_/X _12824_/Y VPWR VGND sg13g2_a21oi_2
XFILLER_76_1230 VPWR VGND sg13g2_fill_2
X_16593_ _16594_/B _22633_/Q _22632_/Q _22631_/Q VPWR VGND sg13g2_nand3_1
XFILLER_15_530 VPWR VGND sg13g2_decap_8
XFILLER_76_1241 VPWR VGND sg13g2_decap_8
XFILLER_43_850 VPWR VGND sg13g2_decap_8
X_18332_ _18332_/Y _18332_/A _18332_/B VPWR VGND sg13g2_nor2_1
X_15544_ _15544_/Y _15694_/S _17102_/A _15543_/Y VPWR VGND sg13g2_o21ai_1
X_12756_ _12756_/Y _13520_/A _12843_/A VPWR VGND sg13g2_nor2_1
XFILLER_98_7 VPWR VGND sg13g2_decap_8
XFILLER_43_894 VPWR VGND sg13g2_fill_1
XFILLER_70_691 VPWR VGND sg13g2_decap_8
X_11707_ _11716_/B _11707_/A _11707_/B VPWR VGND sg13g2_nor2_1
X_18263_ _18263_/Y _18288_/A _18322_/C _18279_/A VPWR VGND sg13g2_a21oi_1
XFILLER_19_1670 VPWR VGND sg13g2_fill_2
X_15475_ _17399_/B _15482_/B _15478_/D VPWR VGND sg13g2_nor2_1
XFILLER_15_1512 VPWR VGND sg13g2_fill_2
X_12687_ _12688_/C _23426_/Q _23490_/Q _23586_/Q _23650_/Q _12474_/S _12377_/S VPWR
+ VGND sg13g2_mux4_1
XFILLER_54_1561 VPWR VGND sg13g2_decap_8
XFILLER_30_555 VPWR VGND sg13g2_fill_1
X_17214_ _17214_/Y _22745_/Q _17214_/B VPWR VGND sg13g2_xnor2_1
XFILLER_106_1662 VPWR VGND sg13g2_decap_4
X_18194_ _18194_/Y _18194_/A _18194_/B _18194_/C VPWR VGND sg13g2_nor3_1
XFILLER_50_1436 VPWR VGND sg13g2_fill_1
XFILLER_106_1695 VPWR VGND sg13g2_decap_8
XFILLER_89_1635 VPWR VGND sg13g2_decap_4
X_17145_ _17145_/Y _22733_/Q _17145_/B VPWR VGND sg13g2_xnor2_1
XFILLER_50_1469 VPWR VGND sg13g2_decap_8
X_14357_ _15461_/B _16789_/A _19401_/B _15319_/A VPWR VGND sg13g2_a21oi_1
XFILLER_32_1870 VPWR VGND sg13g2_decap_4
X_11569_ _11569_/Y _11569_/A _14098_/B _14098_/A _11596_/C VPWR VGND sg13g2_nor4_2
X_13308_ _13308_/X _23915_/Q _24011_/Q _24107_/Q _24139_/Q _13591_/B _13689_/S1 VPWR
+ VGND sg13g2_mux4_1
XFILLER_115_126 VPWR VGND sg13g2_decap_8
X_17076_ _22720_/D _17080_/B _17074_/Y _17075_/Y VPWR VGND sg13g2_a21oi_1
X_14288_ _14347_/B _11734_/A _11734_/B _15140_/A VPWR VGND sg13g2_a21oi_1
XFILLER_6_283 VPWR VGND sg13g2_fill_2
X_16027_ _16364_/B _14167_/A _15274_/Y _15133_/A VPWR VGND sg13g2_a21o_1
X_13239_ _13239_/X _23850_/Q _23882_/Q _23946_/Q _23978_/Q _12721_/S _12050_/C VPWR
+ VGND sg13g2_mux4_1
XFILLER_69_202 VPWR VGND sg13g2_fill_2
XFILLER_63_1819 VPWR VGND sg13g2_decap_8
XFILLER_111_310 VPWR VGND sg13g2_fill_1
XFILLER_48_1387 VPWR VGND sg13g2_decap_8
XFILLER_69_246 VPWR VGND sg13g2_decap_8
XFILLER_112_866 VPWR VGND sg13g2_decap_8
XFILLER_85_706 VPWR VGND sg13g2_decap_8
XFILLER_65_1690 VPWR VGND sg13g2_fill_2
XFILLER_61_1532 VPWR VGND sg13g2_decap_8
X_17978_ _17979_/A _17978_/A _18187_/B VPWR VGND sg13g2_nand2_1
XFILLER_61_1543 VPWR VGND sg13g2_fill_2
XFILLER_85_739 VPWR VGND sg13g2_fill_2
XFILLER_6_1735 VPWR VGND sg13g2_decap_8
XFILLER_111_387 VPWR VGND sg13g2_decap_8
X_19717_ _19717_/Y _20005_/A _19986_/B VPWR VGND sg13g2_nor2_1
X_16929_ _16930_/B _17024_/A _16933_/B VPWR VGND sg13g2_nor2b_1
XFILLER_37_121 VPWR VGND sg13g2_fill_2
XFILLER_65_430 VPWR VGND sg13g2_fill_1
XFILLER_53_603 VPWR VGND sg13g2_decap_4
X_19648_ _19648_/Y _19702_/A _19828_/B VPWR VGND sg13g2_nand2_1
XFILLER_0_1301 VPWR VGND sg13g2_decap_4
XFILLER_37_165 VPWR VGND sg13g2_fill_1
XFILLER_92_282 VPWR VGND sg13g2_decap_8
XFILLER_111_28 VPWR VGND sg13g2_decap_8
X_19579_ _19580_/B _19406_/Y _19415_/Y _19584_/S VPWR VGND sg13g2_mux2_1
XFILLER_74_1904 VPWR VGND sg13g2_fill_2
XFILLER_94_1341 VPWR VGND sg13g2_decap_8
XFILLER_41_809 VPWR VGND sg13g2_fill_2
XFILLER_94_1352 VPWR VGND sg13g2_fill_1
XFILLER_20_1295 VPWR VGND sg13g2_decap_8
XFILLER_55_1303 VPWR VGND sg13g2_fill_1
X_21610_ _23820_/D _21971_/A1 _21615_/B _21609_/Y VPWR VGND sg13g2_o21ai_1
XFILLER_90_1205 VPWR VGND sg13g2_decap_8
XFILLER_0_1389 VPWR VGND sg13g2_decap_4
X_22590_ _22590_/Q clkload28/A _22590_/D fanout2871/X VPWR VGND sg13g2_dfrbpq_1
XFILLER_74_1948 VPWR VGND sg13g2_decap_8
XFILLER_55_1336 VPWR VGND sg13g2_decap_4
XFILLER_90_1238 VPWR VGND sg13g2_decap_8
X_21541_ _21541_/Y _21541_/A _21549_/B VPWR VGND sg13g2_nand2_1
XFILLER_21_544 VPWR VGND sg13g2_decap_8
Xplace4010 _14129_/D _13681_/S VPWR VGND sg13g2_buf_2
Xplace4021 _13131_/A _13706_/S VPWR VGND sg13g2_buf_1
X_24260_ _24260_/X _24260_/A VPWR VGND sg13g2_buf_1
Xplace4032 _12889_/C _11276_/Y VPWR VGND sg13g2_buf_2
X_21472_ _23753_/D _23753_/Q _21965_/A0 _21488_/S VPWR VGND sg13g2_mux2_1
XFILLER_14_1022 VPWR VGND sg13g2_fill_2
Xplace4043 _19114_/S _19098_/S VPWR VGND sg13g2_buf_1
Xplace4054 _19023_/B _18890_/B VPWR VGND sg13g2_buf_1
Xplace4065 _18009_/A _24225_/Q VPWR VGND sg13g2_buf_1
Xplace3320 _22311_/A1 _21977_/A1 VPWR VGND sg13g2_buf_1
Xplace3331 _22373_/A1 _20251_/Y VPWR VGND sg13g2_buf_1
X_23211_ _23211_/Q clkload33/A _23211_/D fanout2930/X VPWR VGND sg13g2_dfrbpq_1
Xplace4076 _15133_/A _24216_/Q VPWR VGND sg13g2_buf_1
Xplace3342 _21325_/A1 _20685_/A1 VPWR VGND sg13g2_buf_1
X_20423_ _20423_/Y _23276_/Q _20429_/B VPWR VGND sg13g2_nand2_1
Xplace4087 _20224_/A _19912_/S VPWR VGND sg13g2_buf_1
X_24191_ _24191_/Q clkload41/A _24191_/D fanout2727/X VPWR VGND sg13g2_dfrbpq_1
Xplace3353 _21312_/A1 _21178_/A1 VPWR VGND sg13g2_buf_1
XFILLER_14_1077 VPWR VGND sg13g2_decap_8
Xplace4098 _18393_/S _18030_/A VPWR VGND sg13g2_buf_1
Xplace3364 _21237_/A1 _21303_/A1 VPWR VGND sg13g2_buf_1
XFILLER_4_209 VPWR VGND sg13g2_decap_8
Xplace3375 _16054_/A _15375_/Y VPWR VGND sg13g2_buf_1
XFILLER_101_1047 VPWR VGND sg13g2_fill_1
X_23142_ _23142_/Q clkload5/A _23142_/D fanout2840/X VPWR VGND sg13g2_dfrbpq_1
Xplace3386 _17476_/A1 _17881_/A VPWR VGND sg13g2_buf_1
X_20354_ _20354_/Y _20356_/A _20354_/B VPWR VGND sg13g2_nor2_1
XFILLER_106_126 VPWR VGND sg13g2_decap_8
XFILLER_84_1009 VPWR VGND sg13g2_decap_4
Xplace3397 _17419_/B _17425_/B VPWR VGND sg13g2_buf_1
X_23073_ _23073_/Q _23114_/CLK _23073_/D fanout2906/X VPWR VGND sg13g2_dfrbpq_1
XFILLER_103_800 VPWR VGND sg13g2_fill_1
X_20285_ _20285_/Y _20284_/X _20317_/B VPWR VGND sg13g2_nand2b_1
XFILLER_103_822 VPWR VGND sg13g2_decap_8
X_22024_ _24005_/D _22292_/A1 _22025_/B _22023_/Y VPWR VGND sg13g2_o21ai_1
XFILLER_103_877 VPWR VGND sg13g2_decap_8
XFILLER_44_1741 VPWR VGND sg13g2_decap_8
XFILLER_103_888 VPWR VGND sg13g2_fill_2
XFILLER_25_1140 VPWR VGND sg13g2_decap_8
XFILLER_25_1151 VPWR VGND sg13g2_fill_1
XFILLER_29_67 VPWR VGND sg13g2_decap_8
XFILLER_40_1605 VPWR VGND sg13g2_fill_1
XFILLER_57_920 VPWR VGND sg13g2_decap_8
XFILLER_57_931 VPWR VGND sg13g2_fill_2
XFILLER_29_644 VPWR VGND sg13g2_decap_8
X_23975_ _23975_/Q clkload37/A _23975_/D fanout2709/X VPWR VGND sg13g2_dfrbpq_1
XFILLER_28_132 VPWR VGND sg13g2_decap_4
XFILLER_57_964 VPWR VGND sg13g2_decap_8
XFILLER_28_143 VPWR VGND sg13g2_fill_2
X_22926_ _22926_/Q _22941_/CLK _22926_/D fanout2801/X VPWR VGND sg13g2_dfrbpq_1
XFILLER_57_997 VPWR VGND sg13g2_decap_8
XFILLER_17_839 VPWR VGND sg13g2_decap_8
XFILLER_72_934 VPWR VGND sg13g2_decap_4
XFILLER_83_282 VPWR VGND sg13g2_fill_1
XFILLER_44_647 VPWR VGND sg13g2_decap_8
X_22857_ _22857_/Q _22893_/CLK _22857_/D fanout2819/X VPWR VGND sg13g2_dfrbpq_1
XFILLER_77_1583 VPWR VGND sg13g2_decap_8
XFILLER_31_308 VPWR VGND sg13g2_decap_4
X_12610_ _20013_/B _12628_/A1 _12607_/X _12609_/Y VPWR VGND sg13g2_a21oi_1
XFILLER_25_872 VPWR VGND sg13g2_decap_8
X_21808_ _23901_/D _19921_/Y _21833_/B _21807_/Y VPWR VGND sg13g2_o21ai_1
XFILLER_77_1594 VPWR VGND sg13g2_fill_2
X_13590_ _13590_/Y _13589_/B _23918_/Q _13589_/Y VPWR VGND sg13g2_o21ai_1
X_22788_ _22788_/Q clkload21/A _22788_/D fanout2877/X VPWR VGND sg13g2_dfrbpq_1
X_12541_ _12541_/Y _12623_/A _12623_/B VPWR VGND sg13g2_nand2_1
XFILLER_38_1589 VPWR VGND sg13g2_fill_1
XFILLER_40_842 VPWR VGND sg13g2_fill_1
X_21739_ _23874_/D _21952_/A1 _21738_/B _21738_/Y VPWR VGND sg13g2_o21ai_1
XFILLER_16_1821 VPWR VGND sg13g2_decap_8
X_15260_ _15261_/D _16784_/A _15260_/B VPWR VGND sg13g2_nor2_1
XFILLER_90_1783 VPWR VGND sg13g2_decap_8
XFILLER_12_577 VPWR VGND sg13g2_fill_2
X_12472_ _12473_/B _23424_/Q _23488_/Q _12474_/S VPWR VGND sg13g2_mux2_1
XFILLER_71_1182 VPWR VGND sg13g2_decap_8
X_14211_ _14213_/C _14211_/A _22836_/Q VPWR VGND sg13g2_nand2_1
X_23409_ _23409_/Q clkload50/A _23409_/D fanout2681/X VPWR VGND sg13g2_dfrbpq_1
X_11423_ _12247_/A _11427_/B _11423_/B VPWR VGND sg13g2_nand2b_2
XFILLER_16_1898 VPWR VGND sg13g2_decap_8
X_15191_ _15482_/B _15287_/A _15191_/B VPWR VGND sg13g2_nand2b_1
XFILLER_103_1868 VPWR VGND sg13g2_decap_8
XFILLER_86_1808 VPWR VGND sg13g2_decap_8
X_14142_ _14151_/B _14189_/A _14766_/A _14189_/C VPWR VGND sg13g2_nand3_1
XFILLER_4_765 VPWR VGND sg13g2_fill_1
X_11285_ _11285_/X _24151_/Q _23223_/Q _23287_/Q _23351_/Q _11508_/S0 _11295_/A VPWR
+ VGND sg13g2_mux4_1
X_18950_ _23052_/D _18944_/Y _18947_/Y _18948_/Y _18949_/Y VPWR VGND sg13g2_a22oi_1
X_14073_ _19320_/A _14073_/A _14102_/C VPWR VGND sg13g2_and2_1
XFILLER_49_1674 VPWR VGND sg13g2_fill_1
X_17901_ _22931_/D _17901_/A VPWR VGND sg13g2_inv_1
X_13024_ _13024_/X _13636_/A _13024_/B VPWR VGND sg13g2_or2_1
XFILLER_79_533 VPWR VGND sg13g2_fill_2
XFILLER_79_555 VPWR VGND sg13g2_fill_2
XFILLER_45_1549 VPWR VGND sg13g2_fill_1
XFILLER_62_1830 VPWR VGND sg13g2_fill_2
XFILLER_79_588 VPWR VGND sg13g2_fill_2
XFILLER_66_205 VPWR VGND sg13g2_decap_8
XFILLER_62_1874 VPWR VGND sg13g2_decap_8
X_17763_ _17763_/Y _22571_/Q _17777_/C VPWR VGND sg13g2_xnor2_1
XFILLER_94_558 VPWR VGND sg13g2_fill_1
X_14975_ _14976_/B _22468_/Q _15114_/A2 _14826_/X VPWR VGND sg13g2_a21oi_1
XFILLER_48_953 VPWR VGND sg13g2_decap_8
XFILLER_110_1817 VPWR VGND sg13g2_decap_8
XFILLER_78_1303 VPWR VGND sg13g2_fill_1
X_16714_ _16715_/B _22658_/Q _16714_/B VPWR VGND sg13g2_xnor2_1
Xwire1182 wire1182/X wire1182/A VPWR VGND sg13g2_buf_8
XFILLER_63_912 VPWR VGND sg13g2_decap_8
XFILLER_78_1325 VPWR VGND sg13g2_decap_8
X_17694_ _17715_/C _22562_/Q _22561_/Q _17694_/C VPWR VGND sg13g2_and3_1
XFILLER_35_625 VPWR VGND sg13g2_decap_8
XFILLER_21_1560 VPWR VGND sg13g2_decap_8
X_19433_ _19757_/C _19696_/B _19433_/B VPWR VGND sg13g2_nand2_1
XFILLER_47_496 VPWR VGND sg13g2_fill_2
X_16645_ _16646_/B _22644_/Q _16645_/B VPWR VGND sg13g2_xnor2_1
X_13857_ _13857_/Y _13867_/B _13867_/C _13864_/A VPWR VGND sg13g2_o21ai_1
XFILLER_35_669 VPWR VGND sg13g2_decap_8
XFILLER_63_978 VPWR VGND sg13g2_decap_8
XFILLER_95_1661 VPWR VGND sg13g2_decap_8
XFILLER_50_606 VPWR VGND sg13g2_decap_8
XFILLER_34_157 VPWR VGND sg13g2_decap_8
XFILLER_62_466 VPWR VGND sg13g2_decap_8
X_19364_ _19364_/X _19349_/X _19760_/B _19872_/A VPWR VGND sg13g2_mux2_1
X_12808_ _12808_/Y _14129_/C _23652_/Q _12807_/X VPWR VGND sg13g2_a21oi_1
X_16576_ _16577_/B _22630_/Q _16576_/B VPWR VGND sg13g2_xnor2_1
X_13788_ _13788_/X _23441_/Q _23473_/Q _23505_/Q _23537_/Q _13798_/B2 _13795_/S1 VPWR
+ VGND sg13g2_mux4_1
X_18315_ _18315_/Y _18485_/B _18187_/A _18465_/B VPWR VGND sg13g2_o21ai_1
XFILLER_91_1558 VPWR VGND sg13g2_decap_8
X_15527_ _15539_/A _16871_/C _15524_/Y _15526_/Y VPWR VGND sg13g2_o21ai_1
X_19295_ _23212_/D _23212_/Q _20095_/A0 _19303_/S VPWR VGND sg13g2_mux2_1
X_12739_ _12740_/B _23299_/Q _23331_/Q _23363_/Q _23395_/Q _12983_/A _12986_/S1 VPWR
+ VGND sg13g2_mux4_1
XFILLER_31_864 VPWR VGND sg13g2_fill_2
XFILLER_50_1200 VPWR VGND sg13g2_decap_8
XFILLER_30_363 VPWR VGND sg13g2_decap_8
X_18246_ _18246_/Y _18279_/A _18245_/Y _18399_/A VPWR VGND sg13g2_o21ai_1
XFILLER_37_1099 VPWR VGND sg13g2_fill_1
X_15458_ _15465_/A _22846_/Q _15561_/B _15284_/Y _22788_/Q VPWR VGND sg13g2_a22oi_1
XFILLER_34_1954 VPWR VGND sg13g2_fill_1
XFILLER_15_1342 VPWR VGND sg13g2_decap_8
XFILLER_89_1410 VPWR VGND sg13g2_decap_8
XFILLER_102_1312 VPWR VGND sg13g2_fill_1
X_15389_ _15391_/A _15389_/A _15461_/B VPWR VGND sg13g2_and2_1
XFILLER_15_1397 VPWR VGND sg13g2_decap_4
XFILLER_50_1277 VPWR VGND sg13g2_decap_4
XFILLER_89_1454 VPWR VGND sg13g2_decap_8
XFILLER_11_1239 VPWR VGND sg13g2_decap_8
X_17128_ _17129_/B _17144_/B _17173_/B _17133_/D VPWR VGND sg13g2_nor3_1
XFILLER_85_1318 VPWR VGND sg13g2_fill_2
X_17059_ _22717_/D _16357_/A _17055_/Y _17080_/B VPWR VGND sg13g2_mux2_1
XFILLER_67_1752 VPWR VGND sg13g2_fill_1
X_20070_ _20071_/B _20343_/A1 _20343_/A3 _20343_/A0 _20343_/A2 _20343_/S1 _20072_/S1
+ VPWR VGND sg13g2_mux4_1
XFILLER_106_28 VPWR VGND sg13g2_decap_8
XFILLER_63_1627 VPWR VGND sg13g2_fill_1
XFILLER_115_1728 VPWR VGND sg13g2_decap_8
XFILLER_112_663 VPWR VGND sg13g2_decap_8
XFILLER_58_717 VPWR VGND sg13g2_fill_1
XFILLER_111_140 VPWR VGND sg13g2_decap_8
XFILLER_98_897 VPWR VGND sg13g2_decap_4
XFILLER_85_514 VPWR VGND sg13g2_fill_1
XFILLER_57_227 VPWR VGND sg13g2_decap_8
XFILLER_41_1936 VPWR VGND sg13g2_fill_2
XFILLER_61_1362 VPWR VGND sg13g2_fill_2
XFILLER_6_1554 VPWR VGND sg13g2_fill_1
XFILLER_26_1493 VPWR VGND sg13g2_fill_1
XFILLER_41_1947 VPWR VGND sg13g2_decap_8
XFILLER_26_603 VPWR VGND sg13g2_decap_8
XFILLER_66_772 VPWR VGND sg13g2_fill_2
X_20972_ _23530_/D _20972_/A1 _20971_/B _20971_/Y VPWR VGND sg13g2_o21ai_1
X_23760_ _23760_/Q clkload49/A _23760_/D fanout2674/X VPWR VGND sg13g2_dfrbpq_1
XFILLER_25_113 VPWR VGND sg13g2_decap_8
XFILLER_25_124 VPWR VGND sg13g2_decap_8
X_22711_ _22711_/Q clkload20/A _22711_/D fanout2864/X VPWR VGND sg13g2_dfrbpq_1
XFILLER_54_978 VPWR VGND sg13g2_decap_4
X_23691_ _23691_/Q clkload49/A _23691_/D fanout2675/X VPWR VGND sg13g2_dfrbpq_1
XFILLER_74_1701 VPWR VGND sg13g2_fill_1
XFILLER_53_455 VPWR VGND sg13g2_fill_1
XFILLER_15_14 VPWR VGND sg13g2_fill_1
XFILLER_20_1092 VPWR VGND sg13g2_decap_8
XFILLER_15_25 VPWR VGND sg13g2_fill_1
XFILLER_25_179 VPWR VGND sg13g2_fill_2
X_22642_ _22642_/Q clkload19/A _22642_/D fanout2863/X VPWR VGND sg13g2_dfrbpq_1
XFILLER_22_820 VPWR VGND sg13g2_decap_8
XFILLER_40_116 VPWR VGND sg13g2_decap_4
XFILLER_90_1024 VPWR VGND sg13g2_decap_4
X_22573_ _22573_/Q _23029_/CLK _22573_/D fanout2836/X VPWR VGND sg13g2_dfrbpq_1
XFILLER_74_1778 VPWR VGND sg13g2_fill_2
XFILLER_22_886 VPWR VGND sg13g2_fill_1
XFILLER_33_1420 VPWR VGND sg13g2_fill_1
XFILLER_22_897 VPWR VGND sg13g2_fill_1
X_21524_ _21524_/Y _23778_/Q _21530_/B VPWR VGND sg13g2_nand2_1
XFILLER_107_1278 VPWR VGND sg13g2_decap_4
XFILLER_21_396 VPWR VGND sg13g2_fill_1
X_21455_ _23745_/D _21950_/A1 _21456_/B _21454_/Y VPWR VGND sg13g2_o21ai_1
XFILLER_107_402 VPWR VGND sg13g2_decap_8
Xplace3150 _20853_/B _20847_/B VPWR VGND sg13g2_buf_1
Xplace3161 _20682_/B _20690_/B VPWR VGND sg13g2_buf_1
XFILLER_107_424 VPWR VGND sg13g2_fill_2
X_20406_ _20406_/Y _20406_/A _20426_/B VPWR VGND sg13g2_nand2_1
Xplace3172 _20647_/B _20644_/B VPWR VGND sg13g2_buf_1
X_24174_ _24174_/Q clkload38/A _24174_/D fanout2630/X VPWR VGND sg13g2_dfrbpq_1
XFILLER_107_435 VPWR VGND sg13g2_decap_8
Xplace3183 _20581_/B _20516_/Y VPWR VGND sg13g2_buf_1
X_21386_ _23712_/D _21948_/A1 _21389_/B _21385_/Y VPWR VGND sg13g2_o21ai_1
Xplace3194 _20434_/S _20435_/B VPWR VGND sg13g2_buf_1
X_23125_ _23125_/Q _23215_/CLK _23125_/D fanout2924/X VPWR VGND sg13g2_dfrbpq_1
X_20337_ _20337_/Y _20338_/B _20338_/C _20336_/Y VPWR VGND sg13g2_o21ai_1
XFILLER_89_831 VPWR VGND sg13g2_fill_2
XFILLER_81_1716 VPWR VGND sg13g2_fill_2
X_23056_ _23056_/Q _24214_/CLK _23056_/D fanout2928/X VPWR VGND sg13g2_dfrbpq_1
XFILLER_81_1727 VPWR VGND sg13g2_fill_2
XFILLER_66_1273 VPWR VGND sg13g2_decap_8
XFILLER_88_352 VPWR VGND sg13g2_fill_2
XFILLER_49_706 VPWR VGND sg13g2_fill_2
X_22007_ _23997_/D _19921_/Y _22008_/B _22006_/Y VPWR VGND sg13g2_o21ai_1
XFILLER_7_1329 VPWR VGND sg13g2_decap_8
XFILLER_27_1257 VPWR VGND sg13g2_fill_1
XFILLER_102_151 VPWR VGND sg13g2_fill_1
XFILLER_0_267 VPWR VGND sg13g2_decap_8
XFILLER_76_514 VPWR VGND sg13g2_decap_8
X_20199_ _20199_/Y _20112_/A _19962_/B _20198_/Y VPWR VGND sg13g2_o21ai_1
XFILLER_5_1020 VPWR VGND sg13g2_decap_8
XFILLER_29_452 VPWR VGND sg13g2_decap_8
XFILLER_91_517 VPWR VGND sg13g2_decap_4
XFILLER_5_1064 VPWR VGND sg13g2_fill_1
XFILLER_29_463 VPWR VGND sg13g2_fill_1
X_14760_ _14760_/Y _17538_/B _17621_/B _14760_/C VPWR VGND sg13g2_nor3_1
XFILLER_57_772 VPWR VGND sg13g2_decap_4
X_23958_ _23958_/Q clkload58/A _23958_/D fanout2759/X VPWR VGND sg13g2_dfrbpq_1
XFILLER_79_1645 VPWR VGND sg13g2_fill_2
X_11972_ _11973_/A _12686_/B _11972_/B VPWR VGND sg13g2_or2_1
XFILLER_57_794 VPWR VGND sg13g2_decap_8
XFILLER_16_113 VPWR VGND sg13g2_decap_8
XFILLER_84_591 VPWR VGND sg13g2_decap_8
XFILLER_45_956 VPWR VGND sg13g2_fill_1
X_13711_ _13711_/Y _13706_/S _13710_/Y _13960_/S1 VPWR VGND sg13g2_a21oi_1
X_22909_ _22909_/Q clkload9/A _22909_/D fanout2816/X VPWR VGND sg13g2_dfrbpq_1
X_14691_ _14691_/Y _14691_/A _14694_/B VPWR VGND sg13g2_nor2_1
XFILLER_57_1910 VPWR VGND sg13g2_fill_2
X_23889_ _23889_/Q _24113_/CLK _23889_/D fanout2666/X VPWR VGND sg13g2_dfrbpq_1
XFILLER_72_764 VPWR VGND sg13g2_decap_8
XFILLER_72_775 VPWR VGND sg13g2_fill_1
X_16430_ _22582_/D _16109_/A _16431_/B _16429_/Y VPWR VGND sg13g2_o21ai_1
X_13642_ _13642_/X _24079_/Q _24143_/Q _13643_/S VPWR VGND sg13g2_mux2_1
XFILLER_71_263 VPWR VGND sg13g2_fill_1
XFILLER_44_488 VPWR VGND sg13g2_fill_2
XFILLER_57_1954 VPWR VGND sg13g2_fill_1
XFILLER_13_831 VPWR VGND sg13g2_fill_2
X_16361_ _16361_/Y _22545_/Q _16425_/B _16357_/Y VPWR VGND sg13g2_a21oi_1
X_13573_ _13573_/X _23854_/Q _23886_/Q _23950_/Q _23982_/Q _13586_/A1 _12050_/C VPWR
+ VGND sg13g2_mux4_1
XFILLER_73_1255 VPWR VGND sg13g2_fill_1
XFILLER_105_1919 VPWR VGND sg13g2_decap_8
XFILLER_34_1228 VPWR VGND sg13g2_decap_8
X_15312_ _15312_/Y _15312_/A _15325_/B VPWR VGND sg13g2_nor2_1
X_12524_ _12524_/X _13296_/A _12520_/Y _12523_/Y VPWR VGND sg13g2_a21o_2
X_19080_ _23076_/D _23076_/Q _19079_/X _19086_/S VPWR VGND sg13g2_mux2_1
XFILLER_8_323 VPWR VGND sg13g2_decap_8
X_16292_ _22531_/D _16292_/A _16293_/B VPWR VGND sg13g2_xnor2_1
XFILLER_51_1542 VPWR VGND sg13g2_decap_8
X_18031_ _18196_/A _18358_/S _18028_/Y _18030_/Y VPWR VGND sg13g2_a21oi_1
X_15243_ _15923_/A _17056_/A VPWR VGND sg13g2_inv_1
X_12455_ _12456_/C _12454_/Y _13681_/S VPWR VGND sg13g2_nand2b_1
XFILLER_8_389 VPWR VGND sg13g2_decap_8
X_11406_ _11407_/B _23926_/Q _23958_/Q _11406_/S VPWR VGND sg13g2_mux2_1
X_14125_ _14125_/Y _11583_/S _11596_/D _11634_/D VPWR VGND sg13g2_a21oi_1
X_11337_ _11337_/X _11332_/X _11333_/X _11926_/S VPWR VGND sg13g2_mux2_1
X_19982_ _19984_/B _20038_/A _19982_/B VPWR VGND sg13g2_nor2_1
XFILLER_64_1903 VPWR VGND sg13g2_fill_1
XFILLER_113_449 VPWR VGND sg13g2_decap_8
X_18933_ _18933_/Y _18955_/A _18933_/B VPWR VGND sg13g2_nand2_1
XFILLER_49_1482 VPWR VGND sg13g2_fill_2
X_14056_ _14056_/X _14056_/A _14056_/B VPWR VGND sg13g2_xor2_1
X_11268_ _11502_/B _11569_/A _14124_/A _11602_/B VPWR VGND sg13g2_nor3_1
XFILLER_64_1947 VPWR VGND sg13g2_decap_8
X_13007_ _13007_/X _13003_/X _13004_/X _13005_/X _13006_/X _12707_/S _12042_/B VPWR
+ VGND sg13g2_mux4_1
XFILLER_67_503 VPWR VGND sg13g2_decap_4
XFILLER_95_823 VPWR VGND sg13g2_fill_1
X_18864_ _23044_/D _18864_/A _18864_/B _18864_/C VPWR VGND sg13g2_nand3_1
X_11199_ _11199_/Y _11243_/B _14240_/A _11243_/D VPWR VGND sg13g2_nor3_1
XFILLER_67_514 VPWR VGND sg13g2_fill_1
XFILLER_79_385 VPWR VGND sg13g2_fill_1
XFILLER_7_1841 VPWR VGND sg13g2_decap_8
X_17815_ _17815_/Y _23186_/Q _17815_/A2 _17815_/B1 _22994_/Q VPWR VGND sg13g2_a22oi_1
XFILLER_95_878 VPWR VGND sg13g2_decap_8
XFILLER_114_1783 VPWR VGND sg13g2_decap_8
X_17746_ _17747_/B _22568_/Q _17754_/C VPWR VGND sg13g2_nand2_1
X_14958_ _14958_/Y _22466_/Q _14874_/B _15103_/B1 _22925_/Q _14957_/X VPWR VGND sg13g2_a221oi_1
XFILLER_82_539 VPWR VGND sg13g2_decap_4
XFILLER_48_794 VPWR VGND sg13g2_fill_2
XFILLER_35_422 VPWR VGND sg13g2_fill_1
X_13909_ _13909_/X _24051_/Q _24083_/Q _24115_/Q _24147_/Q _13919_/S0 _13919_/S1 VPWR
+ VGND sg13g2_mux4_1
XFILLER_97_1767 VPWR VGND sg13g2_fill_1
X_17677_ _17677_/Y _22561_/Q _17694_/C VPWR VGND sg13g2_xnor2_1
X_14889_ _14889_/Y _18636_/A _14888_/Y VPWR VGND sg13g2_nor2b_1
XFILLER_51_904 VPWR VGND sg13g2_decap_8
XFILLER_51_915 VPWR VGND sg13g2_fill_2
XFILLER_62_241 VPWR VGND sg13g2_decap_8
XFILLER_74_1008 VPWR VGND sg13g2_decap_8
X_19416_ _19417_/B _19413_/Y _19415_/Y _19573_/S VPWR VGND sg13g2_mux2_1
X_16628_ _16629_/A _22640_/Q _22639_/Q _22638_/Q _16628_/D VPWR VGND sg13g2_nand4_1
XFILLER_56_1420 VPWR VGND sg13g2_decap_4
XFILLER_62_285 VPWR VGND sg13g2_decap_8
XFILLER_16_691 VPWR VGND sg13g2_fill_2
XFILLER_22_138 VPWR VGND sg13g2_fill_1
XFILLER_71_1918 VPWR VGND sg13g2_fill_1
X_16559_ _16560_/B _22626_/Q _22625_/Q _16559_/C _16564_/D VPWR VGND sg13g2_nand4_1
XFILLER_56_1486 VPWR VGND sg13g2_fill_1
XFILLER_91_1388 VPWR VGND sg13g2_fill_2
XFILLER_87_0 VPWR VGND sg13g2_decap_8
XFILLER_91_1399 VPWR VGND sg13g2_decap_8
XFILLER_108_1598 VPWR VGND sg13g2_decap_4
X_18229_ _18229_/Y _18297_/A _18103_/B _18228_/Y VPWR VGND sg13g2_o21ai_1
XFILLER_34_1773 VPWR VGND sg13g2_decap_8
XFILLER_15_1172 VPWR VGND sg13g2_fill_1
XFILLER_11_1003 VPWR VGND sg13g2_fill_1
X_21240_ _21240_/Y _21240_/A _21247_/B VPWR VGND sg13g2_nand2_1
XFILLER_11_1036 VPWR VGND sg13g2_decap_8
XFILLER_85_1104 VPWR VGND sg13g2_fill_2
X_21171_ _21171_/Y _21171_/A _21175_/B VPWR VGND sg13g2_nand2_1
X_20122_ _20122_/Y _20122_/A _20122_/B _20122_/C VPWR VGND sg13g2_nor3_1
XFILLER_104_449 VPWR VGND sg13g2_decap_4
XFILLER_8_1605 VPWR VGND sg13g2_fill_2
XFILLER_28_1533 VPWR VGND sg13g2_decap_8
XFILLER_28_1544 VPWR VGND sg13g2_decap_8
XFILLER_28_1555 VPWR VGND sg13g2_decap_8
X_20053_ _23234_/D _20052_/B _20049_/Y _20052_/Y VPWR VGND sg13g2_o21ai_1
XFILLER_115_1525 VPWR VGND sg13g2_fill_2
XFILLER_112_460 VPWR VGND sg13g2_decap_8
XFILLER_28_1577 VPWR VGND sg13g2_fill_1
XFILLER_24_1419 VPWR VGND sg13g2_decap_8
XFILLER_115_1547 VPWR VGND sg13g2_fill_1
XFILLER_41_1700 VPWR VGND sg13g2_decap_4
XFILLER_86_856 VPWR VGND sg13g2_decap_8
XFILLER_80_1771 VPWR VGND sg13g2_fill_1
XFILLER_46_709 VPWR VGND sg13g2_fill_2
XFILLER_6_1362 VPWR VGND sg13g2_decap_8
XFILLER_93_19 VPWR VGND sg13g2_fill_1
XFILLER_85_366 VPWR VGND sg13g2_decap_4
XFILLER_113_1260 VPWR VGND sg13g2_decap_8
XFILLER_6_1373 VPWR VGND sg13g2_fill_1
XFILLER_27_912 VPWR VGND sg13g2_decap_8
X_23812_ _23812_/Q clkload40/A _23812_/D fanout2731/X VPWR VGND sg13g2_dfrbpq_1
XFILLER_22_1154 VPWR VGND sg13g2_decap_4
XFILLER_39_783 VPWR VGND sg13g2_decap_8
XFILLER_100_699 VPWR VGND sg13g2_decap_4
XFILLER_38_260 VPWR VGND sg13g2_fill_2
XFILLER_2_1237 VPWR VGND sg13g2_decap_4
XFILLER_26_411 VPWR VGND sg13g2_decap_8
XFILLER_26_433 VPWR VGND sg13g2_fill_2
XFILLER_76_1818 VPWR VGND sg13g2_decap_8
XFILLER_26_444 VPWR VGND sg13g2_decap_4
X_23743_ _23743_/Q _24190_/CLK _23743_/D fanout2774/X VPWR VGND sg13g2_dfrbpq_1
X_20955_ _23522_/D _21323_/A1 _20954_/B _20954_/Y VPWR VGND sg13g2_o21ai_1
XFILLER_54_764 VPWR VGND sg13g2_decap_4
XFILLER_26_79 VPWR VGND sg13g2_decap_8
XFILLER_14_628 VPWR VGND sg13g2_decap_8
X_23674_ _23674_/Q clkload57/A _23674_/D fanout2783/X VPWR VGND sg13g2_dfrbpq_1
XFILLER_81_594 VPWR VGND sg13g2_fill_1
X_20886_ _20886_/Y _23489_/Q _20888_/B VPWR VGND sg13g2_nand2_1
XFILLER_53_296 VPWR VGND sg13g2_fill_2
X_22625_ _22625_/Q clkload24/A _22625_/D fanout2898/X VPWR VGND sg13g2_dfrbpq_1
XFILLER_39_1684 VPWR VGND sg13g2_decap_8
XFILLER_41_458 VPWR VGND sg13g2_fill_2
XFILLER_74_1575 VPWR VGND sg13g2_decap_8
XFILLER_50_981 VPWR VGND sg13g2_decap_8
XFILLER_22_683 VPWR VGND sg13g2_fill_2
X_22556_ _22556_/Q clkload26/A _22556_/D fanout2851/X VPWR VGND sg13g2_dfrbpq_1
XFILLER_10_834 VPWR VGND sg13g2_fill_1
XFILLER_22_694 VPWR VGND sg13g2_fill_2
XFILLER_6_805 VPWR VGND sg13g2_decap_8
X_21507_ _23770_/D _21934_/A1 _21508_/B _21506_/Y VPWR VGND sg13g2_o21ai_1
XFILLER_108_711 VPWR VGND sg13g2_decap_8
XFILLER_10_878 VPWR VGND sg13g2_fill_1
X_22487_ _22487_/Q clkload28/A _22487_/D fanout2855/X VPWR VGND sg13g2_dfrbpq_1
XFILLER_87_1903 VPWR VGND sg13g2_decap_8
XFILLER_13_1857 VPWR VGND sg13g2_decap_8
XFILLER_107_210 VPWR VGND sg13g2_decap_8
X_12240_ _12241_/D _12249_/A1 _12239_/X _12039_/B VPWR VGND sg13g2_o21ai_1
XFILLER_87_1925 VPWR VGND sg13g2_fill_1
X_24226_ _24226_/Q clkload5/A _24226_/D fanout2844/X VPWR VGND sg13g2_dfrbpq_1
X_21438_ _23737_/D _21932_/A1 _21447_/B _21437_/Y VPWR VGND sg13g2_o21ai_1
X_12171_ _12171_/X _23708_/Q _23740_/Q _23772_/Q _23804_/Q _11855_/S _12171_/S1 VPWR
+ VGND sg13g2_mux4_1
X_24157_ _24157_/Q _24190_/CLK _24157_/D fanout2779/X VPWR VGND sg13g2_dfrbpq_1
X_23108_ _23108_/Q _23114_/CLK _23108_/D fanout2906/X VPWR VGND sg13g2_dfrbpq_1
XFILLER_111_909 VPWR VGND sg13g2_fill_1
XFILLER_96_609 VPWR VGND sg13g2_fill_2
XFILLER_85_1682 VPWR VGND sg13g2_fill_1
X_24088_ _24088_/Q clkload46/A _24088_/D fanout2673/X VPWR VGND sg13g2_dfrbpq_1
XFILLER_3_28 VPWR VGND sg13g2_decap_8
Xclkbuf_leaf_54_clk_i _23682_/CLK clkbuf_leaf_55_clk_i/A VPWR VGND sg13g2_buf_16
X_15930_ _15930_/Y _15930_/A _20296_/A VPWR VGND sg13g2_nor2_1
XFILLER_77_812 VPWR VGND sg13g2_decap_8
XFILLER_104_983 VPWR VGND sg13g2_fill_1
X_23039_ _23039_/Q clkload14/A _23039_/D fanout2905/X VPWR VGND sg13g2_dfrbpq_1
XFILLER_49_514 VPWR VGND sg13g2_decap_4
XFILLER_7_1148 VPWR VGND sg13g2_decap_8
XFILLER_76_333 VPWR VGND sg13g2_decap_4
XFILLER_49_558 VPWR VGND sg13g2_fill_2
X_15861_ _15861_/Y _22740_/Q _15901_/A2 _15901_/B1 _22676_/Q VPWR VGND sg13g2_a22oi_1
XFILLER_92_804 VPWR VGND sg13g2_decap_4
XFILLER_97_1008 VPWR VGND sg13g2_decap_8
X_17600_ _22883_/D _17631_/B _17598_/Y _17599_/Y VPWR VGND sg13g2_a21oi_1
XFILLER_77_889 VPWR VGND sg13g2_decap_8
XFILLER_18_912 VPWR VGND sg13g2_decap_8
XFILLER_20_1806 VPWR VGND sg13g2_decap_8
X_14812_ _14812_/Y _14831_/B _14812_/B VPWR VGND sg13g2_nand2_1
XFILLER_36_208 VPWR VGND sg13g2_decap_4
XFILLER_64_517 VPWR VGND sg13g2_decap_8
XFILLER_111_1934 VPWR VGND sg13g2_decap_8
XFILLER_18_923 VPWR VGND sg13g2_fill_2
X_18580_ _18580_/X _18884_/B _18587_/C VPWR VGND sg13g2_or2_1
X_15792_ _15796_/A _22931_/Q _15897_/A2 _15893_/A2 _22503_/Q VPWR VGND sg13g2_a22oi_1
XFILLER_64_539 VPWR VGND sg13g2_fill_2
Xclkbuf_leaf_69_clk_i clkload14/A clkbuf_4_2__f_clk_i/X VPWR VGND sg13g2_buf_16
XFILLER_45_731 VPWR VGND sg13g2_decap_8
XFILLER_79_1453 VPWR VGND sg13g2_decap_8
X_17531_ _22877_/D _17531_/A VPWR VGND sg13g2_inv_1
X_14743_ _14743_/X _14743_/A _22835_/Q VPWR VGND sg13g2_and2_1
XFILLER_45_753 VPWR VGND sg13g2_fill_2
XFILLER_44_241 VPWR VGND sg13g2_decap_8
XFILLER_17_466 VPWR VGND sg13g2_fill_2
XFILLER_2_1771 VPWR VGND sg13g2_decap_8
XFILLER_45_775 VPWR VGND sg13g2_decap_8
XFILLER_17_477 VPWR VGND sg13g2_fill_2
XFILLER_72_572 VPWR VGND sg13g2_decap_4
X_17462_ _17462_/Y _17462_/A _17462_/B VPWR VGND sg13g2_nand2_1
XFILLER_83_96 VPWR VGND sg13g2_decap_8
X_14674_ _14674_/X _14671_/Y _14673_/Y _14729_/S VPWR VGND sg13g2_mux2_1
XFILLER_44_274 VPWR VGND sg13g2_decap_4
XFILLER_57_1740 VPWR VGND sg13g2_decap_8
X_11886_ _11887_/D _14039_/A _12002_/A _11886_/C _19727_/S VPWR VGND sg13g2_nand4_1
XFILLER_32_436 VPWR VGND sg13g2_decap_4
XFILLER_33_959 VPWR VGND sg13g2_decap_8
XFILLER_44_296 VPWR VGND sg13g2_decap_8
X_16413_ _22573_/D _23023_/Q _22573_/Q _16413_/S VPWR VGND sg13g2_mux2_1
X_19201_ _19201_/Y _23160_/Q _19231_/S VPWR VGND sg13g2_nand2_1
XFILLER_57_1762 VPWR VGND sg13g2_fill_1
XFILLER_60_756 VPWR VGND sg13g2_decap_4
XFILLER_109_1841 VPWR VGND sg13g2_decap_8
X_13625_ _13625_/X _13625_/A _13625_/B _13625_/C _13625_/D VPWR VGND sg13g2_or4_1
XFILLER_18_1735 VPWR VGND sg13g2_decap_8
X_17393_ _22818_/D _17389_/Y _22818_/Q _17395_/S VPWR VGND sg13g2_mux2_1
X_19132_ _23109_/D _23109_/Q _17982_/B _19134_/S VPWR VGND sg13g2_mux2_1
X_16344_ _16344_/Y _15482_/A _16341_/Y _16343_/Y VPWR VGND sg13g2_o21ai_1
XFILLER_38_1194 VPWR VGND sg13g2_decap_8
XFILLER_105_1727 VPWR VGND sg13g2_decap_8
XFILLER_80_7 VPWR VGND sg13g2_fill_1
XFILLER_13_683 VPWR VGND sg13g2_fill_2
X_13556_ _13556_/X _13636_/A _13556_/B VPWR VGND sg13g2_or2_1
XFILLER_41_992 VPWR VGND sg13g2_fill_1
Xplace3908 _18238_/A _18451_/B VPWR VGND sg13g2_buf_1
Xplace3919 _18554_/A1 _18476_/A VPWR VGND sg13g2_buf_1
XFILLER_40_491 VPWR VGND sg13g2_fill_1
XFILLER_12_1301 VPWR VGND sg13g2_decap_8
XFILLER_12_193 VPWR VGND sg13g2_fill_2
X_19063_ _23068_/D _23068_/Q _19062_/X _19078_/S VPWR VGND sg13g2_mux2_1
X_12507_ _12507_/Y _12466_/X _12469_/Y _12471_/Y _11681_/Y _12506_/Y VPWR VGND sg13g2_a221oi_1
XFILLER_9_676 VPWR VGND sg13g2_decap_8
X_16275_ _16276_/S _16278_/B _16289_/A VPWR VGND sg13g2_nor2_1
X_13487_ _13487_/Y _13617_/B _24109_/Q _13486_/Y VPWR VGND sg13g2_o21ai_1
X_15226_ _15226_/Y _16782_/B _16871_/A _15225_/Y VPWR VGND sg13g2_o21ai_1
XFILLER_8_186 VPWR VGND sg13g2_decap_8
X_12438_ _12439_/C _12435_/B _12438_/B VPWR VGND sg13g2_nand2b_1
X_15157_ _17234_/A _15393_/B _17034_/C VPWR VGND sg13g2_nor2_1
XFILLER_114_725 VPWR VGND sg13g2_decap_8
X_12369_ _12370_/D _12486_/A _12368_/X _12488_/B1 VPWR VGND sg13g2_o21ai_1
XFILLER_113_224 VPWR VGND sg13g2_decap_8
X_14108_ _14433_/C _14104_/C _14104_/B _14108_/S VPWR VGND sg13g2_mux2_1
XFILLER_87_609 VPWR VGND sg13g2_decap_4
X_19965_ _19965_/Y _19965_/A _19965_/B _19965_/C _19965_/D VPWR VGND sg13g2_nand4_1
X_15088_ _15089_/B _17920_/A1 _15107_/A2 _14918_/B VPWR VGND sg13g2_o21ai_1
XFILLER_29_1853 VPWR VGND sg13g2_decap_8
XFILLER_84_1181 VPWR VGND sg13g2_fill_1
X_14039_ _14041_/C _14039_/A _19727_/S VPWR VGND sg13g2_xnor2_1
X_18916_ _18916_/Y _23049_/Q _18953_/A _18960_/B1 VPWR VGND sg13g2_o21ai_1
XFILLER_25_1717 VPWR VGND sg13g2_fill_2
X_19896_ _19896_/Y _19987_/A _19896_/B VPWR VGND sg13g2_nand2_1
XFILLER_110_942 VPWR VGND sg13g2_decap_8
XFILLER_41_1007 VPWR VGND sg13g2_fill_1
XFILLER_110_953 VPWR VGND sg13g2_fill_2
XFILLER_67_333 VPWR VGND sg13g2_decap_8
X_18847_ _18847_/Y _18016_/S _23042_/Q _18856_/B _17941_/B VPWR VGND sg13g2_a22oi_1
XFILLER_7_1660 VPWR VGND sg13g2_decap_4
XFILLER_94_163 VPWR VGND sg13g2_decap_8
XFILLER_67_377 VPWR VGND sg13g2_fill_1
XFILLER_110_1411 VPWR VGND sg13g2_fill_2
XFILLER_97_1520 VPWR VGND sg13g2_fill_2
XFILLER_83_848 VPWR VGND sg13g2_fill_1
X_18778_ _18778_/Y _18822_/A _18778_/B VPWR VGND sg13g2_nand2_1
XFILLER_3_1546 VPWR VGND sg13g2_decap_4
X_17729_ _22896_/D _17796_/B _17727_/Y _17728_/Y VPWR VGND sg13g2_a21oi_1
XFILLER_24_915 VPWR VGND sg13g2_fill_2
XFILLER_36_775 VPWR VGND sg13g2_decap_8
XFILLER_63_550 VPWR VGND sg13g2_decap_8
X_20740_ _20740_/Y _20740_/A _20742_/B VPWR VGND sg13g2_nand2_1
XFILLER_24_937 VPWR VGND sg13g2_decap_4
XFILLER_35_274 VPWR VGND sg13g2_fill_2
XFILLER_90_391 VPWR VGND sg13g2_fill_1
XFILLER_23_447 VPWR VGND sg13g2_fill_1
XFILLER_91_1130 VPWR VGND sg13g2_decap_4
X_20671_ _20671_/Y _20671_/A _20673_/B VPWR VGND sg13g2_nand2_1
XFILLER_52_1125 VPWR VGND sg13g2_decap_4
XFILLER_36_1879 VPWR VGND sg13g2_fill_1
X_23390_ _23390_/Q _24190_/CLK _23390_/D fanout2775/X VPWR VGND sg13g2_dfrbpq_1
XFILLER_108_1395 VPWR VGND sg13g2_decap_4
XFILLER_12_15 VPWR VGND sg13g2_fill_2
X_22341_ _22341_/Y _22341_/A _22341_/B VPWR VGND sg13g2_nand2_1
XFILLER_30_1412 VPWR VGND sg13g2_decap_8
X_22272_ _24124_/D _22272_/A1 _22276_/B _22271_/Y VPWR VGND sg13g2_o21ai_1
Xoutput4474 data_addr_o[16] _24261_/X VPWR VGND sg13g2_buf_1
Xoutput4485 data_addr_o[27] _24272_/X VPWR VGND sg13g2_buf_1
Xoutput4496 data_addr_o[8] _24253_/X VPWR VGND sg13g2_buf_1
X_24011_ _24011_/Q _24212_/CLK _24011_/D fanout2633/X VPWR VGND sg13g2_dfrbpq_1
X_21223_ _21287_/B _21918_/D _22186_/A _21289_/C VPWR VGND sg13g2_nand3_1
XFILLER_12_1890 VPWR VGND sg13g2_decap_8
X_21154_ _21154_/Y _21154_/A _21154_/B VPWR VGND sg13g2_nand2_1
X_20105_ _23236_/D _20144_/B _21261_/A1 _20104_/Y VPWR VGND sg13g2_o21ai_1
XFILLER_28_1341 VPWR VGND sg13g2_decap_8
XFILLER_77_108 VPWR VGND sg13g2_decap_4
XFILLER_115_1311 VPWR VGND sg13g2_decap_8
XFILLER_99_992 VPWR VGND sg13g2_fill_1
XFILLER_43_1817 VPWR VGND sg13g2_decap_8
X_21085_ _21085_/Y _23572_/Q _21085_/B VPWR VGND sg13g2_nand2_1
XFILLER_43_1828 VPWR VGND sg13g2_fill_1
XFILLER_98_480 VPWR VGND sg13g2_decap_8
XFILLER_58_311 VPWR VGND sg13g2_fill_1
XFILLER_59_845 VPWR VGND sg13g2_decap_8
XFILLER_115_1333 VPWR VGND sg13g2_fill_2
X_20036_ _20036_/Y _20035_/B _20085_/B _20035_/Y VPWR VGND sg13g2_a21oi_1
XFILLER_100_463 VPWR VGND sg13g2_fill_2
XFILLER_46_517 VPWR VGND sg13g2_decap_8
XFILLER_96_1030 VPWR VGND sg13g2_fill_1
XFILLER_96_1041 VPWR VGND sg13g2_decap_8
X_23726_ _23726_/Q clkload49/A _23726_/D fanout2674/X VPWR VGND sg13g2_dfrbpq_1
X_11740_ _11740_/Y _11921_/A _12175_/B VPWR VGND sg13g2_nor2_2
X_20938_ _20938_/Y _20938_/A _20945_/B VPWR VGND sg13g2_nand2_1
XFILLER_57_1036 VPWR VGND sg13g2_decap_8
XFILLER_41_211 VPWR VGND sg13g2_decap_8
XFILLER_53_33 VPWR VGND sg13g2_fill_2
X_23657_ _23657_/Q clkload47/A _23657_/D fanout2680/X VPWR VGND sg13g2_dfrbpq_1
X_11671_ _11671_/Y _14026_/A _11673_/B VPWR VGND sg13g2_nor2b_1
XFILLER_42_778 VPWR VGND sg13g2_decap_4
X_20869_ _23481_/D _21237_/A1 _20879_/B _20868_/Y VPWR VGND sg13g2_o21ai_1
X_13410_ _13410_/X _13607_/A _13410_/B VPWR VGND sg13g2_or2_1
XFILLER_74_1383 VPWR VGND sg13g2_decap_8
X_22608_ _22608_/Q clkload10/A _22608_/D fanout2813/X VPWR VGND sg13g2_dfrbpq_1
X_23588_ _23588_/Q _24196_/CLK _23588_/D fanout2702/X VPWR VGND sg13g2_dfrbpq_1
XFILLER_22_491 VPWR VGND sg13g2_fill_1
X_13341_ _13341_/X _23723_/Q _23755_/Q _23787_/Q _23819_/Q _13701_/S0 _12121_/S VPWR
+ VGND sg13g2_mux4_1
X_22539_ _22539_/Q clkload6/A _22539_/D fanout2832/X VPWR VGND sg13g2_dfrbpq_1
XFILLER_13_1643 VPWR VGND sg13g2_decap_4
X_16060_ _16060_/Y _16060_/A _16060_/B VPWR VGND sg13g2_nand2_1
X_13272_ _13278_/A _13268_/Y _13269_/X _13270_/X _13271_/Y VPWR VGND sg13g2_a22oi_1
XFILLER_108_552 VPWR VGND sg13g2_decap_8
XFILLER_68_1121 VPWR VGND sg13g2_fill_1
X_24209_ _24209_/Q clkload50/A _24209_/D fanout2663/X VPWR VGND sg13g2_dfrbpq_1
XFILLER_5_167 VPWR VGND sg13g2_decap_8
XFILLER_48_1717 VPWR VGND sg13g2_decap_4
XFILLER_48_1739 VPWR VGND sg13g2_fill_2
Xfanout2800 fanout2800/X fanout2810/X VPWR VGND sg13g2_buf_1
X_12154_ _12181_/A _12429_/A _16781_/A VPWR VGND sg13g2_xnor2_1
XFILLER_64_1018 VPWR VGND sg13g2_decap_4
Xfanout2811 fanout2811/X fanout2815/X VPWR VGND sg13g2_buf_1
Xfanout2822 fanout2822/X fanout2831/X VPWR VGND sg13g2_buf_1
XFILLER_46_1430 VPWR VGND sg13g2_fill_1
Xfanout2833 fanout2833/X fanout2834/X VPWR VGND sg13g2_buf_1
Xfanout2844 fanout2844/X fanout2845/X VPWR VGND sg13g2_buf_1
XFILLER_1_351 VPWR VGND sg13g2_fill_1
X_19750_ _19750_/Y _20329_/B2 _19741_/Y _19749_/Y VPWR VGND sg13g2_a21oi_1
Xfanout2855 fanout2855/X fanout2861/X VPWR VGND sg13g2_buf_1
X_12085_ _12085_/Y _12959_/A _14304_/C VPWR VGND sg13g2_nor2_1
XFILLER_49_300 VPWR VGND sg13g2_decap_8
X_16962_ _16962_/Y _22702_/Q _16962_/B VPWR VGND sg13g2_xnor2_1
Xfanout2866 fanout2866/X fanout2867/X VPWR VGND sg13g2_buf_1
Xfanout2877 fanout2877/X fanout2878/X VPWR VGND sg13g2_buf_1
Xfanout2888 fanout2888/X fanout2890/X VPWR VGND sg13g2_buf_1
X_18701_ _18708_/B _23018_/Q _23019_/Q _18711_/D VPWR VGND sg13g2_nand3_1
XFILLER_49_333 VPWR VGND sg13g2_fill_1
Xfanout2899 fanout2899/X fanout2900/X VPWR VGND sg13g2_buf_1
X_15913_ _16185_/A _15911_/Y _15956_/B _15912_/Y VPWR VGND sg13g2_o21ai_1
X_16893_ _16894_/B _16893_/A _16893_/B VPWR VGND sg13g2_nor2_1
X_19681_ _19681_/Y _23207_/Q _19501_/Y _19881_/B1 _23199_/Q _19497_/X VPWR VGND sg13g2_a221oi_1
XFILLER_42_1349 VPWR VGND sg13g2_decap_8
XFILLER_77_664 VPWR VGND sg13g2_decap_8
XFILLER_92_601 VPWR VGND sg13g2_decap_8
X_15844_ _18714_/A _23021_/Q VPWR VGND sg13g2_inv_1
XFILLER_20_1603 VPWR VGND sg13g2_decap_8
X_18632_ _23004_/D _18632_/A _18632_/B VPWR VGND sg13g2_nor2_1
XFILLER_4_1844 VPWR VGND sg13g2_decap_8
XFILLER_92_634 VPWR VGND sg13g2_decap_4
XFILLER_65_859 VPWR VGND sg13g2_fill_1
XFILLER_111_1753 VPWR VGND sg13g2_decap_8
XFILLER_94_84 VPWR VGND sg13g2_decap_8
XFILLER_20_1647 VPWR VGND sg13g2_decap_4
XFILLER_80_818 VPWR VGND sg13g2_fill_1
X_18563_ _18563_/Y _18172_/Y _18561_/Y _18562_/Y VPWR VGND sg13g2_o21ai_1
X_15775_ _17164_/A _16148_/A _15775_/B VPWR VGND sg13g2_nand2b_1
X_12987_ _12987_/X _13636_/A _12987_/B VPWR VGND sg13g2_or2_1
XFILLER_92_689 VPWR VGND sg13g2_decap_4
X_14726_ _14726_/X _14657_/Y _14655_/Y _14726_/S VPWR VGND sg13g2_mux2_1
X_17514_ _22873_/D _17514_/A _17514_/B VPWR VGND sg13g2_and2_1
X_11938_ _11938_/Y _14342_/C _12305_/B VPWR VGND sg13g2_nor2b_1
X_18494_ _18494_/Y _18494_/A _18494_/B VPWR VGND sg13g2_nand2_1
XFILLER_2_1590 VPWR VGND sg13g2_decap_8
XFILLER_33_745 VPWR VGND sg13g2_fill_1
X_17445_ _17445_/Y _17445_/A _17453_/B VPWR VGND sg13g2_nand2_1
X_14657_ _14657_/Y _14697_/A1 _14701_/B _14656_/Y VPWR VGND sg13g2_o21ai_1
X_11869_ _14038_/B _11672_/Y _11674_/Y _11676_/Y VPWR VGND sg13g2_a21oi_1
XFILLER_32_255 VPWR VGND sg13g2_decap_8
XFILLER_109_1660 VPWR VGND sg13g2_fill_2
X_13608_ _13625_/A _13608_/A1 _13605_/X _13607_/X VPWR VGND sg13g2_o21ai_1
X_17376_ _17376_/Y _17388_/B _17376_/B VPWR VGND sg13g2_nand2_1
X_14588_ _19237_/S _23191_/Q _19253_/A _14587_/Y VPWR VGND sg13g2_o21ai_1
XFILLER_53_1456 VPWR VGND sg13g2_fill_1
Xrebuffer5407 _13383_/B _14342_/C VPWR VGND sg13g2_buf_1
XFILLER_18_1576 VPWR VGND sg13g2_decap_8
Xrebuffer5418 _19401_/A _11606_/A VPWR VGND sg13g2_buf_1
Xplace3705 _20318_/B _20286_/B VPWR VGND sg13g2_buf_1
Xrebuffer5429 _12849_/A _12464_/Y VPWR VGND sg13g2_buf_1
Xplace3716 _15447_/B _14358_/B VPWR VGND sg13g2_buf_1
X_19115_ _23093_/D _23093_/Q _19114_/X _19115_/S VPWR VGND sg13g2_mux2_1
XFILLER_9_462 VPWR VGND sg13g2_fill_1
XFILLER_53_1489 VPWR VGND sg13g2_decap_8
X_13539_ _20245_/A _13651_/A _13539_/B _13539_/C VPWR VGND sg13g2_nand3_1
Xplace3727 _19494_/A _14021_/B VPWR VGND sg13g2_buf_1
XFILLER_31_1721 VPWR VGND sg13g2_fill_2
Xplace3738 _19430_/B _19448_/B VPWR VGND sg13g2_buf_1
XFILLER_88_1508 VPWR VGND sg13g2_decap_4
XFILLER_9_473 VPWR VGND sg13g2_decap_8
Xplace3749 _17801_/A2 _17822_/A2 VPWR VGND sg13g2_buf_1
X_19046_ _19046_/Y _19043_/A _19046_/B _19046_/C VPWR VGND sg13g2_nand3b_1
XFILLER_70_1792 VPWR VGND sg13g2_fill_1
X_16258_ _16258_/Y _18648_/A _16273_/C VPWR VGND sg13g2_xnor2_1
XFILLER_51_1180 VPWR VGND sg13g2_decap_4
Xhold5108 _21207_/A _23627_/Q VPWR VGND sg13g2_dlygate4sd3_1
XFILLER_103_1270 VPWR VGND sg13g2_decap_8
Xhold5119 _21130_/A _23590_/Q VPWR VGND sg13g2_dlygate4sd3_1
XFILLER_12_1164 VPWR VGND sg13g2_decap_8
X_16189_ _16189_/Y _16189_/A _16199_/B VPWR VGND sg13g2_nand2_1
XFILLER_114_522 VPWR VGND sg13g2_decap_8
XFILLER_87_428 VPWR VGND sg13g2_decap_8
XFILLER_114_599 VPWR VGND sg13g2_decap_8
XFILLER_9_1766 VPWR VGND sg13g2_decap_8
XFILLER_60_1416 VPWR VGND sg13g2_decap_8
XFILLER_60_1427 VPWR VGND sg13g2_fill_1
XFILLER_114_28 VPWR VGND sg13g2_decap_8
X_19879_ _19880_/C _19325_/X _19866_/Y _19878_/Y _20062_/B VPWR VGND sg13g2_a22oi_1
XFILLER_60_1438 VPWR VGND sg13g2_decap_4
XFILLER_96_984 VPWR VGND sg13g2_decap_8
XFILLER_25_1569 VPWR VGND sg13g2_fill_2
XFILLER_56_815 VPWR VGND sg13g2_decap_4
XFILLER_96_995 VPWR VGND sg13g2_fill_2
XFILLER_67_152 VPWR VGND sg13g2_fill_2
X_21910_ _21910_/Y _23952_/Q _21910_/B VPWR VGND sg13g2_nand2_1
XFILLER_55_314 VPWR VGND sg13g2_decap_8
XFILLER_110_794 VPWR VGND sg13g2_decap_8
XFILLER_28_539 VPWR VGND sg13g2_fill_2
X_22890_ _22890_/Q clkload19/A _22890_/D fanout2870/X VPWR VGND sg13g2_dfrbpq_1
XFILLER_3_1343 VPWR VGND sg13g2_fill_2
XFILLER_23_1293 VPWR VGND sg13g2_decap_8
X_21841_ _23918_/D _22308_/A1 _21843_/B _21840_/Y VPWR VGND sg13g2_o21ai_1
XFILLER_110_1252 VPWR VGND sg13g2_decap_8
XFILLER_77_1935 VPWR VGND sg13g2_fill_2
XFILLER_36_550 VPWR VGND sg13g2_decap_8
XFILLER_77_1946 VPWR VGND sg13g2_decap_8
XFILLER_38_1908 VPWR VGND sg13g2_decap_8
XFILLER_82_188 VPWR VGND sg13g2_decap_8
XFILLER_36_583 VPWR VGND sg13g2_decap_8
XFILLER_58_1345 VPWR VGND sg13g2_decap_4
X_21772_ _23886_/D _21974_/A1 _21771_/B _21771_/Y VPWR VGND sg13g2_o21ai_1
X_23511_ _23511_/Q clkload58/A _23511_/D fanout2767/X VPWR VGND sg13g2_dfrbpq_1
X_20723_ _20723_/Y _20723_/A _20727_/B VPWR VGND sg13g2_nand2_1
XFILLER_11_406 VPWR VGND sg13g2_fill_1
XFILLER_17_1020 VPWR VGND sg13g2_decap_8
X_23442_ _23442_/Q clkload29/A _23442_/D fanout2623/X VPWR VGND sg13g2_dfrbpq_1
X_20654_ _20654_/Y _20654_/A _20712_/S VPWR VGND sg13g2_nand2_1
XFILLER_71_1567 VPWR VGND sg13g2_fill_1
XFILLER_108_1192 VPWR VGND sg13g2_decap_8
XFILLER_36_1698 VPWR VGND sg13g2_decap_8
X_23373_ _23373_/Q clkload32/A _23373_/D fanout2646/X VPWR VGND sg13g2_dfrbpq_1
X_22324_ _22324_/Y _22324_/A _22328_/B VPWR VGND sg13g2_nand2_1
XFILLER_101_1922 VPWR VGND sg13g2_decap_8
XFILLER_10_1816 VPWR VGND sg13g2_decap_8
XFILLER_30_1242 VPWR VGND sg13g2_decap_4
XFILLER_30_1264 VPWR VGND sg13g2_decap_8
XFILLER_105_544 VPWR VGND sg13g2_decap_8
X_21206_ _23626_/D _21606_/A1 _21205_/B _21205_/Y VPWR VGND sg13g2_o21ai_1
Xhold4930 _21184_/A _23616_/Q VPWR VGND sg13g2_dlygate4sd3_1
Xhold4941 _21443_/A _23740_/Q VPWR VGND sg13g2_dlygate4sd3_1
X_22186_ _22229_/B _22186_/A _22252_/B VPWR VGND sg13g2_nand2_1
Xhold4952 _21662_/A _23844_/Q VPWR VGND sg13g2_dlygate4sd3_1
XFILLER_65_1349 VPWR VGND sg13g2_fill_1
Xhold4963 _20850_/A _23474_/Q VPWR VGND sg13g2_dlygate4sd3_1
Xhold4974 _21287_/A _23668_/Q VPWR VGND sg13g2_dlygate4sd3_1
X_21137_ _23593_/D _23593_/Q _22433_/A1 _21153_/S VPWR VGND sg13g2_mux2_1
XFILLER_82_1652 VPWR VGND sg13g2_decap_8
XFILLER_78_428 VPWR VGND sg13g2_decap_8
Xhold4985 _20983_/A _23536_/Q VPWR VGND sg13g2_dlygate4sd3_1
Xhold4996 _19820_/A _23226_/Q VPWR VGND sg13g2_dlygate4sd3_1
XFILLER_24_1002 VPWR VGND sg13g2_decap_8
X_21068_ _23564_/D _22305_/A1 _21071_/B _21067_/Y VPWR VGND sg13g2_o21ai_1
XFILLER_24_1035 VPWR VGND sg13g2_fill_1
XFILLER_115_1152 VPWR VGND sg13g2_decap_8
XFILLER_63_1095 VPWR VGND sg13g2_decap_8
XFILLER_19_517 VPWR VGND sg13g2_decap_8
X_20019_ _20020_/A _20310_/A1 _23209_/Q _23217_/Q _20310_/A2 _20019_/S0 _20072_/S1
+ VPWR VGND sg13g2_mux4_1
X_12910_ _12910_/Y _12909_/B _23845_/Q _12909_/Y VPWR VGND sg13g2_o21ai_1
XFILLER_74_612 VPWR VGND sg13g2_decap_8
XFILLER_101_783 VPWR VGND sg13g2_fill_2
XFILLER_86_483 VPWR VGND sg13g2_decap_8
XFILLER_47_837 VPWR VGND sg13g2_decap_8
X_13890_ _13890_/Y _13640_/S _13888_/Y _13889_/Y VPWR VGND sg13g2_a21oi_1
XFILLER_100_293 VPWR VGND sg13g2_decap_4
XFILLER_21_1945 VPWR VGND sg13g2_decap_8
XFILLER_41_1382 VPWR VGND sg13g2_decap_4
X_12841_ _12841_/Y _12835_/X _12836_/X _12837_/Y _12840_/Y VPWR VGND sg13g2_a22oi_1
X_15560_ _15562_/C _15560_/A _15560_/B VPWR VGND sg13g2_nand2_1
XFILLER_61_328 VPWR VGND sg13g2_decap_8
XFILLER_76_1434 VPWR VGND sg13g2_fill_1
X_12772_ _12772_/Y _12782_/A _12772_/B VPWR VGND sg13g2_nor2_1
XFILLER_15_734 VPWR VGND sg13g2_decap_8
XFILLER_54_380 VPWR VGND sg13g2_fill_2
XFILLER_54_391 VPWR VGND sg13g2_decap_8
XFILLER_64_87 VPWR VGND sg13g2_fill_2
X_14511_ _14513_/C _22602_/Q _23013_/Q VPWR VGND sg13g2_xnor2_1
X_11723_ _11723_/X _23800_/Q _23960_/Q _11723_/S VPWR VGND sg13g2_mux2_1
X_23709_ _23709_/Q clkload59/A _23709_/D fanout2789/X VPWR VGND sg13g2_dfrbpq_1
X_15491_ _15491_/Y _15491_/A _15690_/B VPWR VGND sg13g2_nor2_1
XFILLER_42_553 VPWR VGND sg13g2_decap_8
XFILLER_93_1770 VPWR VGND sg13g2_decap_8
XFILLER_54_1732 VPWR VGND sg13g2_decap_4
XFILLER_14_277 VPWR VGND sg13g2_decap_8
X_17230_ _17230_/Y _22748_/Q _16084_/C _14885_/C VPWR VGND sg13g2_a21oi_1
XFILLER_106_1811 VPWR VGND sg13g2_decap_8
XFILLER_19_1863 VPWR VGND sg13g2_decap_8
XFILLER_30_737 VPWR VGND sg13g2_decap_8
X_14442_ _14442_/Y _14436_/Y _14441_/Y _14434_/Y VPWR VGND sg13g2_o21ai_1
XFILLER_80_42 VPWR VGND sg13g2_fill_1
XFILLER_30_748 VPWR VGND sg13g2_fill_2
XFILLER_35_1131 VPWR VGND sg13g2_fill_2
XFILLER_74_1191 VPWR VGND sg13g2_decap_8
XFILLER_80_53 VPWR VGND sg13g2_fill_1
XFILLER_15_1727 VPWR VGND sg13g2_decap_8
XFILLER_80_64 VPWR VGND sg13g2_decap_8
XFILLER_31_1006 VPWR VGND sg13g2_fill_2
X_14373_ _14377_/B _15165_/C _15307_/A _15159_/B VPWR VGND sg13g2_o21ai_1
XFILLER_35_1186 VPWR VGND sg13g2_fill_2
X_11585_ _14118_/A _14143_/C _14438_/C VPWR VGND sg13g2_nor2_1
XFILLER_106_1888 VPWR VGND sg13g2_decap_8
XFILLER_10_461 VPWR VGND sg13g2_decap_8
X_16112_ _22495_/D _16132_/B _16110_/Y _16111_/Y VPWR VGND sg13g2_o21ai_1
XFILLER_89_1839 VPWR VGND sg13g2_fill_1
X_17092_ _17092_/Y _17092_/A _17092_/B VPWR VGND sg13g2_nor2_1
XFILLER_7_955 VPWR VGND sg13g2_fill_1
XFILLER_6_454 VPWR VGND sg13g2_decap_8
XFILLER_115_308 VPWR VGND sg13g2_decap_8
X_16043_ _16043_/Y _16043_/A _16071_/B VPWR VGND sg13g2_nor2_1
XFILLER_89_40 VPWR VGND sg13g2_decap_8
X_13255_ _13256_/B _13266_/A1 _13250_/Y _13252_/Y _14189_/A _13254_/Y VPWR VGND sg13g2_a221oi_1
XFILLER_100_1476 VPWR VGND sg13g2_decap_8
XFILLER_83_1416 VPWR VGND sg13g2_fill_1
X_12206_ _12209_/C _12788_/B _12206_/B VPWR VGND sg13g2_nor2_1
XFILLER_100_1498 VPWR VGND sg13g2_decap_8
XFILLER_97_704 VPWR VGND sg13g2_fill_1
XFILLER_43_7 VPWR VGND sg13g2_decap_8
X_13186_ _13186_/X _14758_/A _13186_/B _13186_/C _13968_/B VPWR VGND sg13g2_or4_1
X_19802_ _19802_/Y _20162_/A _12104_/B _20038_/A VPWR VGND sg13g2_a21oi_1
XFILLER_2_660 VPWR VGND sg13g2_fill_1
Xfanout2630 fanout2630/X fanout2631/X VPWR VGND sg13g2_buf_1
XFILLER_65_1850 VPWR VGND sg13g2_decap_4
X_12137_ _12137_/Y _23676_/Q _12193_/S VPWR VGND sg13g2_nand2b_1
XFILLER_97_748 VPWR VGND sg13g2_fill_2
Xfanout2641 fanout2641/X fanout2642/X VPWR VGND sg13g2_buf_1
Xfanout2652 fanout2652/X fanout2693/X VPWR VGND sg13g2_buf_1
X_17994_ _17994_/Y _18048_/S _17994_/B VPWR VGND sg13g2_nand2b_1
Xfanout2663 fanout2663/X fanout2668/X VPWR VGND sg13g2_buf_1
XFILLER_78_940 VPWR VGND sg13g2_fill_1
XFILLER_6_1917 VPWR VGND sg13g2_decap_8
Xfanout2674 fanout2674/X fanout2675/X VPWR VGND sg13g2_buf_1
X_19733_ _19733_/Y _19704_/A _19534_/B _19394_/X VPWR VGND sg13g2_a21oi_1
XFILLER_61_1736 VPWR VGND sg13g2_decap_8
XFILLER_113_1815 VPWR VGND sg13g2_decap_8
XFILLER_111_569 VPWR VGND sg13g2_decap_8
Xfanout2685 fanout2685/X fanout2692/X VPWR VGND sg13g2_buf_1
X_16945_ _16945_/Y _16947_/A _16945_/B VPWR VGND sg13g2_xnor2_1
XFILLER_38_804 VPWR VGND sg13g2_decap_4
Xfanout2696 fanout2696/X fanout2706/X VPWR VGND sg13g2_buf_1
XFILLER_61_1758 VPWR VGND sg13g2_decap_4
XFILLER_37_325 VPWR VGND sg13g2_decap_4
XFILLER_92_431 VPWR VGND sg13g2_decap_4
XFILLER_38_859 VPWR VGND sg13g2_decap_8
XFILLER_93_976 VPWR VGND sg13g2_fill_2
XFILLER_4_1663 VPWR VGND sg13g2_fill_2
X_18615_ _23001_/D _18613_/A _18611_/Y _18614_/Y VPWR VGND sg13g2_a21oi_1
X_15827_ _15829_/C _22863_/Q _15966_/B1 _15872_/B1 _22828_/Q VPWR VGND sg13g2_a22oi_1
XFILLER_94_1501 VPWR VGND sg13g2_decap_4
X_19595_ _20335_/B _20082_/A _19569_/Y _19594_/Y VPWR VGND sg13g2_o21ai_1
XFILLER_59_1621 VPWR VGND sg13g2_fill_2
XFILLER_92_475 VPWR VGND sg13g2_decap_8
XFILLER_18_561 VPWR VGND sg13g2_decap_8
XFILLER_0_1527 VPWR VGND sg13g2_fill_2
XFILLER_92_486 VPWR VGND sg13g2_fill_1
XFILLER_59_1632 VPWR VGND sg13g2_decap_8
XFILLER_0_1549 VPWR VGND sg13g2_fill_2
X_15758_ _15758_/X _17158_/A _22470_/Q _15935_/S VPWR VGND sg13g2_mux2_1
X_18546_ _18546_/Y _22993_/Q _18557_/B VPWR VGND sg13g2_nand2_1
XFILLER_94_1545 VPWR VGND sg13g2_decap_8
XFILLER_45_380 VPWR VGND sg13g2_decap_8
XFILLER_61_840 VPWR VGND sg13g2_fill_1
XFILLER_45_391 VPWR VGND sg13g2_fill_2
XFILLER_33_542 VPWR VGND sg13g2_decap_8
X_14709_ _14709_/X _14670_/A _14672_/A _19195_/B VPWR VGND sg13g2_mux2_1
X_18477_ _18531_/A _18144_/A _18415_/B _18476_/Y VPWR VGND sg13g2_o21ai_1
XFILLER_60_350 VPWR VGND sg13g2_fill_2
X_15689_ _20120_/A _15689_/A _15689_/B _15689_/C _15689_/D VPWR VGND sg13g2_nor4_2
XFILLER_21_726 VPWR VGND sg13g2_fill_2
Xplace4203 _13798_/B2 _13900_/S0 VPWR VGND sg13g2_buf_4
X_17428_ _17428_/Y _22834_/Q _17432_/S VPWR VGND sg13g2_nand2_1
Xplace4214 _13133_/A _13635_/S0 VPWR VGND sg13g2_buf_1
Xplace4225 _12050_/B _11774_/A VPWR VGND sg13g2_buf_1
Xplace4236 _12443_/A _22981_/Q VPWR VGND sg13g2_buf_2
XFILLER_72_1887 VPWR VGND sg13g2_decap_4
Xrebuffer5215 _13632_/A _12674_/Y VPWR VGND sg13g2_buf_1
Xrebuffer5226 _11975_/B _11973_/Y VPWR VGND sg13g2_buf_8
Xplace3502 _24266_/A _13306_/Y VPWR VGND sg13g2_buf_2
Xplace4247 _13111_/A _13981_/S1 VPWR VGND sg13g2_buf_1
X_17359_ _22806_/D _16175_/A _17358_/B _17358_/Y VPWR VGND sg13g2_o21ai_1
Xplace3513 _19200_/S _19229_/S VPWR VGND sg13g2_buf_1
Xplace4258 _13006_/S1 _12409_/S1 VPWR VGND sg13g2_buf_1
Xrebuffer5237 _11329_/B _11327_/Y VPWR VGND sg13g2_buf_2
XFILLER_105_1354 VPWR VGND sg13g2_decap_4
Xplace4269 _11538_/S1 _11346_/A VPWR VGND sg13g2_buf_4
Xrebuffer5248 _14463_/B _17934_/C VPWR VGND sg13g2_buf_1
Xplace3524 _15964_/A2 _15317_/Y VPWR VGND sg13g2_buf_1
Xplace3535 _19185_/S _19181_/S VPWR VGND sg13g2_buf_1
Xrebuffer5259 _14718_/A _13404_/B VPWR VGND sg13g2_buf_1
Xplace3546 _16005_/B _15561_/B VPWR VGND sg13g2_buf_1
XFILLER_107_809 VPWR VGND sg13g2_fill_2
Xplace3557 _17835_/A _15194_/Y VPWR VGND sg13g2_buf_1
XFILLER_109_28 VPWR VGND sg13g2_decap_8
Xplace3568 _13086_/A _13526_/A VPWR VGND sg13g2_buf_1
XFILLER_106_308 VPWR VGND sg13g2_fill_2
Xplace3579 _14060_/A _13099_/Y VPWR VGND sg13g2_buf_2
Xclkload40 clkload40/X clkload40/A VPWR VGND sg13g2_buf_16
Xclkload51 clkload51/Y clkload51/A VPWR VGND sg13g2_inv_2
X_19029_ _19030_/C _19047_/A _23092_/Q VPWR VGND sg13g2_nand2_1
XFILLER_115_831 VPWR VGND sg13g2_decap_8
XFILLER_66_1614 VPWR VGND sg13g2_fill_2
X_22040_ _24014_/D _22308_/A1 _22048_/B _22039_/Y VPWR VGND sg13g2_o21ai_1
XFILLER_114_330 VPWR VGND sg13g2_decap_8
XFILLER_83_1950 VPWR VGND sg13g2_decap_4
XFILLER_102_547 VPWR VGND sg13g2_decap_8
XFILLER_9_1563 VPWR VGND sg13g2_fill_1
XFILLER_87_258 VPWR VGND sg13g2_fill_1
XFILLER_5_1405 VPWR VGND sg13g2_fill_1
XFILLER_64_1382 VPWR VGND sg13g2_decap_8
XFILLER_69_962 VPWR VGND sg13g2_decap_4
X_23991_ _23991_/Q clkload46/A _23991_/D fanout2687/X VPWR VGND sg13g2_dfrbpq_1
XFILLER_9_1585 VPWR VGND sg13g2_fill_1
XFILLER_69_984 VPWR VGND sg13g2_decap_8
XFILLER_112_1314 VPWR VGND sg13g2_decap_8
XFILLER_5_1427 VPWR VGND sg13g2_decap_8
XFILLER_25_1366 VPWR VGND sg13g2_decap_8
XFILLER_18_14 VPWR VGND sg13g2_decap_8
X_22942_ _22942_/Q clkload26/A _22942_/D fanout2855/X VPWR VGND sg13g2_dfrbpq_1
XFILLER_55_111 VPWR VGND sg13g2_fill_1
XFILLER_56_634 VPWR VGND sg13g2_decap_8
XFILLER_25_1399 VPWR VGND sg13g2_decap_4
XFILLER_29_859 VPWR VGND sg13g2_decap_8
XFILLER_84_965 VPWR VGND sg13g2_decap_8
XFILLER_44_807 VPWR VGND sg13g2_fill_1
XFILLER_3_1140 VPWR VGND sg13g2_fill_1
XFILLER_3_1151 VPWR VGND sg13g2_decap_8
XFILLER_55_155 VPWR VGND sg13g2_fill_2
X_22873_ _22873_/Q clkload19/A _22873_/D fanout2870/X VPWR VGND sg13g2_dfrbpq_1
XFILLER_83_475 VPWR VGND sg13g2_fill_1
XFILLER_77_1732 VPWR VGND sg13g2_decap_4
XFILLER_83_497 VPWR VGND sg13g2_decap_8
X_21824_ _21824_/Y _23909_/Q _21826_/B VPWR VGND sg13g2_nand2_1
XFILLER_97_1191 VPWR VGND sg13g2_decap_8
XFILLER_38_1727 VPWR VGND sg13g2_fill_2
XFILLER_52_840 VPWR VGND sg13g2_fill_2
XFILLER_38_1738 VPWR VGND sg13g2_fill_1
XFILLER_93_1055 VPWR VGND sg13g2_fill_1
X_21755_ _23879_/D _21962_/A1 _21779_/B _21754_/Y VPWR VGND sg13g2_o21ai_1
XFILLER_52_884 VPWR VGND sg13g2_fill_2
XFILLER_11_203 VPWR VGND sg13g2_fill_2
XFILLER_54_1039 VPWR VGND sg13g2_fill_1
X_20706_ _23407_/D _22177_/A1 _23407_/Q _20706_/S VPWR VGND sg13g2_mux2_1
XFILLER_71_1320 VPWR VGND sg13g2_decap_8
XFILLER_51_1905 VPWR VGND sg13g2_decap_8
X_21686_ _23857_/D _23857_/Q _21978_/A0 _21689_/S VPWR VGND sg13g2_mux2_1
XFILLER_71_1353 VPWR VGND sg13g2_fill_1
X_23425_ _23425_/Q _23682_/CLK _23425_/D fanout2725/X VPWR VGND sg13g2_dfrbpq_1
Xclkload1 clkload1/X clkload1/A VPWR VGND sg13g2_buf_16
X_20637_ _23373_/D _20251_/Y _23373_/Q _20640_/S VPWR VGND sg13g2_mux2_1
XFILLER_50_45 VPWR VGND sg13g2_fill_1
X_23356_ _23356_/Q clkload55/A _23356_/D fanout2772/X VPWR VGND sg13g2_dfrbpq_1
X_11370_ _11370_/X _12443_/A _11861_/B _11556_/A _14196_/B VPWR VGND sg13g2_and4_1
X_20568_ _23339_/D _20700_/A1 _20581_/B _20567_/Y VPWR VGND sg13g2_o21ai_1
XFILLER_109_168 VPWR VGND sg13g2_decap_8
X_22307_ _22307_/Y _22307_/A _22310_/B VPWR VGND sg13g2_nand2_1
XFILLER_49_1801 VPWR VGND sg13g2_decap_4
X_23287_ _23287_/Q clkload57/A _23287_/D fanout2747/X VPWR VGND sg13g2_dfrbpq_1
X_20499_ _23309_/D _23309_/Q _20251_/Y _20511_/S VPWR VGND sg13g2_mux2_1
XFILLER_3_435 VPWR VGND sg13g2_decap_8
XFILLER_4_969 VPWR VGND sg13g2_decap_4
X_13040_ _13040_/Y _23559_/Q _13975_/A2 _13039_/X _13582_/A VPWR VGND sg13g2_a22oi_1
XFILLER_105_330 VPWR VGND sg13g2_decap_4
X_22238_ _22238_/Y _24108_/Q _22241_/B VPWR VGND sg13g2_nand2_1
XFILLER_69_1282 VPWR VGND sg13g2_decap_8
XFILLER_105_341 VPWR VGND sg13g2_decap_4
Xhold4760 _20781_/A _23442_/Q VPWR VGND sg13g2_dlygate4sd3_1
XFILLER_59_54 VPWR VGND sg13g2_decap_8
XFILLER_79_737 VPWR VGND sg13g2_fill_2
Xhold4771 _22078_/A _24031_/Q VPWR VGND sg13g2_dlygate4sd3_1
XFILLER_26_1119 VPWR VGND sg13g2_decap_8
X_22169_ _24074_/D _20202_/X _22168_/B _22168_/Y VPWR VGND sg13g2_o21ai_1
XFILLER_43_1400 VPWR VGND sg13g2_fill_2
Xhold4782 _22271_/A _24124_/Q VPWR VGND sg13g2_dlygate4sd3_1
Xhold4793 _21234_/A _23640_/Q VPWR VGND sg13g2_dlygate4sd3_1
XFILLER_78_269 VPWR VGND sg13g2_decap_8
X_14991_ _16322_/A _18688_/A _16287_/B VPWR VGND sg13g2_nand2_2
XFILLER_43_1444 VPWR VGND sg13g2_fill_1
XFILLER_47_612 VPWR VGND sg13g2_decap_4
XFILLER_75_921 VPWR VGND sg13g2_decap_8
X_13942_ _13942_/Y _14030_/A _20324_/A VPWR VGND sg13g2_nor2_1
XFILLER_21_1720 VPWR VGND sg13g2_decap_8
X_16661_ _16662_/B _22647_/Q _16671_/D VPWR VGND sg13g2_xor2_1
XFILLER_75_976 VPWR VGND sg13g2_decap_8
X_13873_ _13877_/C _13541_/Y _13546_/B _13872_/Y VPWR VGND sg13g2_a21o_1
XFILLER_75_987 VPWR VGND sg13g2_fill_1
XFILLER_1_1825 VPWR VGND sg13g2_decap_8
X_18400_ _18401_/A _18406_/A _18064_/C _18403_/B _18290_/A VPWR VGND sg13g2_a22oi_1
X_15612_ _16107_/A _20034_/A _15785_/B VPWR VGND sg13g2_nand2_1
XFILLER_21_1786 VPWR VGND sg13g2_decap_8
X_12824_ _12824_/Y _23171_/Q _12640_/B _12824_/B1 _12823_/X VPWR VGND sg13g2_a22oi_1
XFILLER_76_1220 VPWR VGND sg13g2_fill_1
X_16592_ _22633_/D _16109_/A _16666_/S _16591_/Y VPWR VGND sg13g2_a21oi_1
XFILLER_27_391 VPWR VGND sg13g2_decap_8
X_18331_ _18331_/Y _18331_/A _18331_/B VPWR VGND sg13g2_nand2_1
X_15543_ _15543_/Y _22460_/Q _15694_/S VPWR VGND sg13g2_nand2b_1
X_12755_ _12761_/A _12751_/Y _12852_/A _20039_/A VPWR VGND sg13g2_nand3b_1
XFILLER_42_361 VPWR VGND sg13g2_fill_2
XFILLER_108_1939 VPWR VGND sg13g2_decap_8
XFILLER_91_74 VPWR VGND sg13g2_decap_4
XFILLER_72_1128 VPWR VGND sg13g2_decap_4
X_11706_ _11707_/B _23448_/Q _23512_/Q _11706_/S VPWR VGND sg13g2_mux2_1
XFILLER_15_597 VPWR VGND sg13g2_fill_2
X_18262_ _22972_/D _18261_/Y _22972_/Q _18432_/B VPWR VGND sg13g2_mux2_1
XFILLER_70_681 VPWR VGND sg13g2_decap_4
X_15474_ _15474_/Y _22723_/Q _15487_/A2 _15487_/B1 _22659_/Q VPWR VGND sg13g2_a22oi_1
X_12686_ _12691_/B _12730_/S _12686_/B _12686_/C VPWR VGND sg13g2_nor3_1
X_17213_ _17214_/B _17218_/A _17218_/B _17213_/C VPWR VGND sg13g2_nor3_1
X_14425_ _16860_/A _17041_/B _17041_/A _14574_/B VPWR VGND sg13g2_o21ai_1
X_18193_ _18194_/C _18399_/A _18193_/B VPWR VGND sg13g2_nor2_1
X_11637_ _11983_/A _19320_/B _13538_/B _11636_/Y VPWR VGND sg13g2_a21oi_2
XFILLER_102_1505 VPWR VGND sg13g2_decap_4
X_17144_ _17145_/B _17149_/A _17144_/B _17173_/B _17149_/B VPWR VGND sg13g2_nor4_1
X_11568_ _14152_/B _14434_/A _15216_/A VPWR VGND sg13g2_nor2_1
XFILLER_115_105 VPWR VGND sg13g2_decap_8
X_17075_ _17075_/Y _17080_/B _17316_/A1 VPWR VGND sg13g2_nor2b_1
X_11499_ _19346_/A _19605_/A VPWR VGND sg13g2_inv_1
X_16026_ _22482_/D _16025_/A _16021_/Y _16025_/Y VPWR VGND sg13g2_a21oi_1
X_13238_ _13246_/D _14129_/A _13234_/Y _13235_/X _12643_/B _13237_/Y VPWR VGND sg13g2_a221oi_1
XFILLER_48_1344 VPWR VGND sg13g2_fill_1
X_13169_ _13179_/C _12048_/A _13158_/X _13165_/Y _13168_/Y VPWR VGND sg13g2_a22oi_1
XFILLER_112_845 VPWR VGND sg13g2_decap_8
XFILLER_97_534 VPWR VGND sg13g2_decap_8
XFILLER_69_225 VPWR VGND sg13g2_decap_4
XFILLER_26_1620 VPWR VGND sg13g2_decap_4
XFILLER_61_1511 VPWR VGND sg13g2_decap_8
XFILLER_6_1714 VPWR VGND sg13g2_decap_8
XFILLER_27_2 VPWR VGND sg13g2_fill_1
XFILLER_69_269 VPWR VGND sg13g2_fill_1
X_17977_ _18187_/B _17977_/A _18530_/A _18517_/A VPWR VGND sg13g2_nor3_1
X_19716_ _19986_/B _19760_/A _19872_/B _19715_/Y VPWR VGND sg13g2_o21ai_1
XFILLER_38_623 VPWR VGND sg13g2_decap_8
X_16928_ _16933_/B _16954_/A _16954_/B _16954_/C VPWR VGND sg13g2_nor3_1
XFILLER_22_1528 VPWR VGND sg13g2_fill_1
XFILLER_96_1607 VPWR VGND sg13g2_fill_2
XFILLER_96_1618 VPWR VGND sg13g2_fill_2
X_19647_ _19828_/B _19638_/S _19433_/B _19646_/Y VPWR VGND sg13g2_a21oi_1
XFILLER_65_453 VPWR VGND sg13g2_decap_8
X_16859_ _17227_/B _17056_/C _16859_/B VPWR VGND sg13g2_nand2_1
XFILLER_4_1460 VPWR VGND sg13g2_decap_8
XFILLER_81_924 VPWR VGND sg13g2_fill_2
XFILLER_37_177 VPWR VGND sg13g2_decap_8
XFILLER_65_486 VPWR VGND sg13g2_decap_8
XFILLER_19_892 VPWR VGND sg13g2_decap_4
X_19578_ _19694_/B _20085_/A _19577_/B _19577_/Y VPWR VGND sg13g2_o21ai_1
XFILLER_80_434 VPWR VGND sg13g2_fill_1
XFILLER_18_380 VPWR VGND sg13g2_fill_2
XFILLER_37_199 VPWR VGND sg13g2_decap_4
XFILLER_53_648 VPWR VGND sg13g2_decap_8
XFILLER_52_136 VPWR VGND sg13g2_fill_1
XFILLER_59_1451 VPWR VGND sg13g2_fill_1
XFILLER_0_1357 VPWR VGND sg13g2_decap_4
X_18529_ _18531_/C _18541_/A1 _18527_/X _18479_/X VPWR VGND sg13g2_o21ai_1
XFILLER_80_478 VPWR VGND sg13g2_decap_8
XFILLER_59_1495 VPWR VGND sg13g2_decap_8
XFILLER_61_670 VPWR VGND sg13g2_fill_2
X_21540_ _23786_/D _21606_/A1 _21539_/B _21539_/Y VPWR VGND sg13g2_o21ai_1
XFILLER_107_1449 VPWR VGND sg13g2_fill_1
Xplace4000 _13674_/A _11414_/A VPWR VGND sg13g2_buf_4
Xplace4011 _13244_/S _13681_/S VPWR VGND sg13g2_buf_2
Xplace4022 _13706_/S _12889_/A VPWR VGND sg13g2_buf_2
Xplace4033 _11571_/B _11205_/A VPWR VGND sg13g2_buf_1
X_21471_ _23752_/D _23752_/Q _21898_/A0 _21488_/S VPWR VGND sg13g2_mux2_1
Xplace4044 _19098_/S _19085_/S VPWR VGND sg13g2_buf_1
XFILLER_33_1635 VPWR VGND sg13g2_fill_1
Xplace3310 _22262_/A1 _19688_/Y VPWR VGND sg13g2_buf_1
XFILLER_21_589 VPWR VGND sg13g2_decap_8
XFILLER_14_1034 VPWR VGND sg13g2_decap_8
Xplace4055 _18890_/B _18446_/S VPWR VGND sg13g2_buf_1
XFILLER_14_1045 VPWR VGND sg13g2_fill_1
X_23210_ _23210_/Q clkload35/A _23210_/D fanout2932/X VPWR VGND sg13g2_dfrbpq_1
Xplace4066 _18922_/A _18015_/S VPWR VGND sg13g2_buf_1
Xplace3321 _21616_/A1 _21977_/A1 VPWR VGND sg13g2_buf_1
Xplace4077 _20071_/A _24214_/Q VPWR VGND sg13g2_buf_1
X_20422_ _23275_/D _20700_/A1 _20435_/B _20421_/Y VPWR VGND sg13g2_o21ai_1
Xplace3332 _21677_/A1 _21969_/A1 VPWR VGND sg13g2_buf_1
Xplace4088 _20019_/S0 _20343_/S1 VPWR VGND sg13g2_buf_1
Xplace3343 _20685_/A1 _20075_/Y VPWR VGND sg13g2_buf_1
X_24190_ _24190_/Q _24190_/CLK _24190_/D fanout2776/X VPWR VGND sg13g2_dfrbpq_1
Xplace3354 _21941_/A1 _21178_/A1 VPWR VGND sg13g2_buf_1
Xplace4099 _18538_/S _18358_/S VPWR VGND sg13g2_buf_1
Xplace3365 _21932_/A1 _21303_/A1 VPWR VGND sg13g2_buf_1
XFILLER_106_105 VPWR VGND sg13g2_decap_8
XFILLER_11_1944 VPWR VGND sg13g2_decap_8
X_23141_ _23141_/Q clkload5/A _23141_/D fanout2841/X VPWR VGND sg13g2_dfrbpq_1
Xplace3376 _22430_/B _22385_/B VPWR VGND sg13g2_buf_1
XFILLER_107_639 VPWR VGND sg13g2_decap_8
Xplace3387 _16067_/A _15470_/A VPWR VGND sg13g2_buf_1
X_20353_ _20361_/A _20305_/A _16017_/C _19311_/A VPWR VGND sg13g2_o21ai_1
Xplace3398 _17425_/B _17437_/B VPWR VGND sg13g2_buf_1
X_23072_ _23072_/Q _23114_/CLK _23072_/D fanout2904/X VPWR VGND sg13g2_dfrbpq_1
X_20284_ _20284_/X _20284_/A0 _20284_/A1 _20284_/A2 _20284_/A3 _20310_/S0 _19912_/S
+ VPWR VGND sg13g2_mux4_1
XFILLER_0_405 VPWR VGND sg13g2_decap_4
X_22023_ _22023_/Y _22023_/A _22025_/B VPWR VGND sg13g2_nand2_1
XFILLER_27_1428 VPWR VGND sg13g2_fill_2
XFILLER_114_182 VPWR VGND sg13g2_decap_8
XFILLER_88_556 VPWR VGND sg13g2_decap_8
XFILLER_29_35 VPWR VGND sg13g2_decap_8
XFILLER_88_578 VPWR VGND sg13g2_fill_1
XFILLER_75_206 VPWR VGND sg13g2_decap_8
XFILLER_29_634 VPWR VGND sg13g2_fill_2
X_23974_ _23974_/Q clkload41/A _23974_/D fanout2724/X VPWR VGND sg13g2_dfrbpq_1
XFILLER_40_1639 VPWR VGND sg13g2_decap_8
XFILLER_99_1242 VPWR VGND sg13g2_fill_2
XFILLER_79_1816 VPWR VGND sg13g2_decap_8
XFILLER_21_1027 VPWR VGND sg13g2_decap_8
X_22925_ _22925_/Q _23029_/CLK _22925_/D fanout2823/X VPWR VGND sg13g2_dfrbpq_1
XFILLER_84_784 VPWR VGND sg13g2_decap_8
XFILLER_71_423 VPWR VGND sg13g2_fill_1
XFILLER_28_199 VPWR VGND sg13g2_decap_8
X_22856_ _22856_/Q clkload10/A _22856_/D fanout2812/X VPWR VGND sg13g2_dfrbpq_1
XFILLER_77_1551 VPWR VGND sg13g2_decap_8
XFILLER_72_968 VPWR VGND sg13g2_fill_1
XFILLER_72_979 VPWR VGND sg13g2_decap_8
XFILLER_25_862 VPWR VGND sg13g2_fill_1
X_21807_ _21807_/Y _23901_/Q _21833_/B VPWR VGND sg13g2_nand2_1
XFILLER_73_1404 VPWR VGND sg13g2_decap_4
X_22787_ _22787_/Q clkload25/A _22787_/D fanout2900/X VPWR VGND sg13g2_dfrbpq_1
XFILLER_40_821 VPWR VGND sg13g2_decap_8
XFILLER_24_383 VPWR VGND sg13g2_decap_8
X_12540_ _12544_/B _12531_/A _12531_/B _12539_/Y VPWR VGND sg13g2_o21ai_1
XFILLER_16_1800 VPWR VGND sg13g2_decap_8
X_21738_ _21738_/Y _21738_/A _21738_/B VPWR VGND sg13g2_nand2_1
XFILLER_101_84 VPWR VGND sg13g2_decap_8
XFILLER_90_1740 VPWR VGND sg13g2_decap_8
XFILLER_24_394 VPWR VGND sg13g2_decap_8
XFILLER_32_1112 VPWR VGND sg13g2_decap_8
X_12471_ _12471_/Y _14758_/A _12471_/B VPWR VGND sg13g2_nor2_1
X_21669_ _23847_/D _21962_/A1 _21674_/B _21668_/Y VPWR VGND sg13g2_o21ai_1
XFILLER_51_1746 VPWR VGND sg13g2_decap_8
XFILLER_16_1877 VPWR VGND sg13g2_decap_8
XFILLER_8_549 VPWR VGND sg13g2_decap_8
X_14210_ _14213_/A _14210_/A _14210_/B VPWR VGND sg13g2_and2_1
X_11422_ _11433_/A _13674_/A _11422_/B VPWR VGND sg13g2_nor2_1
X_23408_ _23408_/Q _24214_/CLK _23408_/D fanout2626/X VPWR VGND sg13g2_dfrbpq_1
XFILLER_51_1768 VPWR VGND sg13g2_decap_4
XFILLER_103_1847 VPWR VGND sg13g2_decap_8
XFILLER_6_39 VPWR VGND sg13g2_decap_4
X_14141_ _14189_/C _14441_/A _18432_/A _14141_/C _22993_/Q VPWR VGND sg13g2_nor4_1
XFILLER_4_711 VPWR VGND sg13g2_decap_8
X_23339_ _23339_/Q _24214_/CLK _23339_/D fanout2626/X VPWR VGND sg13g2_dfrbpq_1
X_11353_ _11418_/A _22982_/Q VPWR VGND sg13g2_inv_2
XFILLER_10_1432 VPWR VGND sg13g2_fill_2
XFILLER_84_1522 VPWR VGND sg13g2_decap_4
X_14072_ _19835_/A _19608_/A _19480_/B VPWR VGND sg13g2_nand2_1
XFILLER_106_650 VPWR VGND sg13g2_fill_2
XFILLER_10_1487 VPWR VGND sg13g2_decap_8
XFILLER_112_119 VPWR VGND sg13g2_decap_8
XFILLER_79_512 VPWR VGND sg13g2_decap_8
X_17900_ _17901_/A _17900_/A1 _17918_/A2 _17923_/B _22931_/Q _17899_/Y VPWR VGND sg13g2_a221oi_1
X_13023_ _13024_/B _23303_/Q _23335_/Q _23367_/Q _23399_/Q _13555_/S0 _13270_/S1 VPWR
+ VGND sg13g2_mux4_1
XFILLER_80_1408 VPWR VGND sg13g2_fill_1
X_18880_ _18880_/Y _18926_/A _23078_/Q _18880_/C VPWR VGND sg13g2_nand3_1
XFILLER_3_287 VPWR VGND sg13g2_decap_8
XFILLER_105_182 VPWR VGND sg13g2_decap_4
XFILLER_94_504 VPWR VGND sg13g2_fill_2
XFILLER_23_1804 VPWR VGND sg13g2_fill_1
XFILLER_43_1230 VPWR VGND sg13g2_decap_8
XFILLER_0_983 VPWR VGND sg13g2_fill_1
XFILLER_94_537 VPWR VGND sg13g2_decap_4
XFILLER_43_1252 VPWR VGND sg13g2_decap_4
XFILLER_48_932 VPWR VGND sg13g2_decap_8
X_17762_ _17777_/C _17762_/A _17762_/B VPWR VGND sg13g2_nor2_1
XFILLER_48_943 VPWR VGND sg13g2_fill_1
X_14974_ _14976_/A _22499_/Q _15113_/B _14885_/Y _22927_/Q VPWR VGND sg13g2_a22oi_1
X_19501_ _19501_/Y _19501_/A _19512_/A VPWR VGND sg13g2_nor2_1
X_16713_ _16714_/B _22657_/Q _16717_/C VPWR VGND sg13g2_nand2_1
XFILLER_35_604 VPWR VGND sg13g2_decap_8
XFILLER_47_464 VPWR VGND sg13g2_decap_8
X_13925_ _13929_/A _13925_/A1 _13922_/Y _13924_/Y VPWR VGND sg13g2_a21o_1
Xwire1183 wire1183/X wire1183/A VPWR VGND sg13g2_buf_8
X_17693_ _22892_/D _17702_/B _17691_/Y _17692_/Y VPWR VGND sg13g2_a21oi_1
XFILLER_21_1550 VPWR VGND sg13g2_decap_4
XFILLER_62_401 VPWR VGND sg13g2_fill_1
XFILLER_5_1791 VPWR VGND sg13g2_decap_8
XFILLER_34_103 VPWR VGND sg13g2_decap_8
XFILLER_47_486 VPWR VGND sg13g2_fill_1
X_19432_ _19433_/B _19429_/Y _19431_/Y _19563_/B VPWR VGND sg13g2_mux2_1
XFILLER_78_1348 VPWR VGND sg13g2_decap_8
XFILLER_63_946 VPWR VGND sg13g2_decap_8
X_16644_ _16645_/B _22643_/Q _16654_/B _16648_/C VPWR VGND sg13g2_nand3_1
X_13856_ _13856_/Y _13856_/A _13856_/B _13877_/B _13856_/D VPWR VGND sg13g2_nand4_1
XFILLER_74_283 VPWR VGND sg13g2_fill_2
XFILLER_90_754 VPWR VGND sg13g2_decap_4
XFILLER_16_851 VPWR VGND sg13g2_decap_8
XFILLER_16_862 VPWR VGND sg13g2_fill_2
X_12807_ _12807_/X _12809_/A _23684_/Q VPWR VGND sg13g2_and2_1
X_13787_ _13787_/Y _13794_/S _13784_/X _13786_/X VPWR VGND sg13g2_a21oi_1
X_16575_ _16576_/B _22629_/Q _22628_/Q _16575_/C VPWR VGND sg13g2_nand3_1
XFILLER_1_1699 VPWR VGND sg13g2_decap_8
XFILLER_43_670 VPWR VGND sg13g2_fill_1
X_18314_ _22977_/D _14629_/A _18457_/S _18313_/Y VPWR VGND sg13g2_a21o_1
X_12738_ _12745_/B _12983_/A _12738_/B _12738_/C VPWR VGND sg13g2_nor3_1
X_15526_ _15526_/Y _22791_/Q _15945_/B1 _15698_/A2 _22491_/Q _15525_/X VPWR VGND sg13g2_a221oi_1
X_19294_ _23211_/D _23211_/Q _20343_/A3 _19299_/S VPWR VGND sg13g2_mux2_1
XFILLER_34_1900 VPWR VGND sg13g2_fill_2
XFILLER_37_1078 VPWR VGND sg13g2_decap_8
X_18245_ _18245_/Y _18464_/A _18245_/B VPWR VGND sg13g2_nand2_1
X_12669_ _12672_/A _23714_/Q _23746_/Q _23778_/Q _23810_/Q _12978_/S0 _12478_/S VPWR
+ VGND sg13g2_mux4_1
XFILLER_31_898 VPWR VGND sg13g2_decap_4
XFILLER_54_1381 VPWR VGND sg13g2_decap_8
XFILLER_89_1400 VPWR VGND sg13g2_decap_4
XFILLER_15_1365 VPWR VGND sg13g2_decap_8
X_15388_ _15388_/Y _22720_/Q _15487_/A2 _15487_/B1 _22656_/Q VPWR VGND sg13g2_a22oi_1
X_18176_ _18331_/B _18458_/B _18458_/A VPWR VGND sg13g2_nor2b_1
XFILLER_102_1357 VPWR VGND sg13g2_decap_4
X_17127_ _17133_/D _22729_/Q _22728_/Q VPWR VGND sg13g2_nand2_1
XFILLER_67_1742 VPWR VGND sg13g2_fill_2
X_16009_ _16010_/B _22715_/Q _16013_/A2 _16013_/B1 _22651_/Q VPWR VGND sg13g2_a22oi_1
XFILLER_44_1005 VPWR VGND sg13g2_decap_4
XFILLER_32_0 VPWR VGND sg13g2_decap_8
XFILLER_115_1707 VPWR VGND sg13g2_decap_8
XFILLER_112_642 VPWR VGND sg13g2_decap_8
XFILLER_98_876 VPWR VGND sg13g2_decap_8
XFILLER_97_353 VPWR VGND sg13g2_decap_8
XFILLER_39_910 VPWR VGND sg13g2_decap_4
XFILLER_57_206 VPWR VGND sg13g2_decap_8
XFILLER_39_921 VPWR VGND sg13g2_fill_1
XFILLER_85_537 VPWR VGND sg13g2_fill_1
XFILLER_61_1352 VPWR VGND sg13g2_fill_1
XFILLER_41_1926 VPWR VGND sg13g2_fill_2
XFILLER_111_196 VPWR VGND sg13g2_decap_8
XFILLER_66_740 VPWR VGND sg13g2_fill_2
XFILLER_61_1385 VPWR VGND sg13g2_decap_4
XFILLER_54_902 VPWR VGND sg13g2_decap_8
XFILLER_39_987 VPWR VGND sg13g2_decap_8
X_20971_ _20971_/Y _23530_/Q _20971_/B VPWR VGND sg13g2_nand2_1
XFILLER_38_464 VPWR VGND sg13g2_decap_4
XFILLER_53_401 VPWR VGND sg13g2_fill_1
XFILLER_66_795 VPWR VGND sg13g2_decap_4
X_22710_ _22710_/Q clkload19/A _22710_/D fanout2862/X VPWR VGND sg13g2_dfrbpq_1
XFILLER_53_423 VPWR VGND sg13g2_decap_8
XFILLER_65_283 VPWR VGND sg13g2_decap_8
XFILLER_4_1290 VPWR VGND sg13g2_fill_2
X_23690_ _23690_/Q clkload45/A _23690_/D fanout2729/X VPWR VGND sg13g2_dfrbpq_1
XFILLER_20_1071 VPWR VGND sg13g2_decap_8
XFILLER_80_253 VPWR VGND sg13g2_fill_2
X_22641_ _22641_/Q clkload19/A _22641_/D fanout2863/X VPWR VGND sg13g2_dfrbpq_1
XFILLER_53_478 VPWR VGND sg13g2_fill_2
XFILLER_34_692 VPWR VGND sg13g2_decap_8
XFILLER_16_1107 VPWR VGND sg13g2_decap_8
X_22572_ _22572_/Q clkload11/A _22572_/D fanout2836/X VPWR VGND sg13g2_dfrbpq_1
XFILLER_33_180 VPWR VGND sg13g2_fill_1
XFILLER_107_1235 VPWR VGND sg13g2_fill_2
X_21523_ _23777_/D _21950_/A1 _21530_/B _21522_/Y VPWR VGND sg13g2_o21ai_1
XFILLER_37_1590 VPWR VGND sg13g2_fill_2
X_24242_ _24242_/Q clkload15/A _24242_/D fanout2859/X VPWR VGND sg13g2_dfrbpq_1
X_21454_ _21454_/Y _23745_/Q _21456_/B VPWR VGND sg13g2_nand2_1
Xplace3140 _20874_/B _20902_/S VPWR VGND sg13g2_buf_1
Xplace3151 _20818_/B _20827_/B VPWR VGND sg13g2_buf_1
Xplace3162 _20690_/B _20704_/B VPWR VGND sg13g2_buf_1
X_20405_ _23266_/D _22418_/A1 _20404_/B _20404_/Y VPWR VGND sg13g2_o21ai_1
XFILLER_110_7 VPWR VGND sg13g2_decap_8
Xplace3173 _20607_/B _20600_/B VPWR VGND sg13g2_buf_1
X_24173_ _24173_/Q _24205_/CLK _24173_/D fanout2645/X VPWR VGND sg13g2_dfrbpq_1
X_21385_ _21385_/Y _21385_/A _21389_/B VPWR VGND sg13g2_nand2_1
Xplace3184 _20464_/B _20458_/B VPWR VGND sg13g2_buf_1
Xplace3195 _20404_/B _20412_/B VPWR VGND sg13g2_buf_1
XFILLER_68_1539 VPWR VGND sg13g2_decap_8
X_23124_ _23124_/Q _23215_/CLK _23124_/D fanout2924/X VPWR VGND sg13g2_dfrbpq_1
XFILLER_102_1891 VPWR VGND sg13g2_decap_8
X_20336_ _20336_/Y _20355_/A _20338_/B VPWR VGND sg13g2_nand2_1
XFILLER_85_1853 VPWR VGND sg13g2_decap_4
XFILLER_85_1875 VPWR VGND sg13g2_decap_8
X_23055_ _23055_/Q _23215_/CLK _23055_/D fanout2926/X VPWR VGND sg13g2_dfrbpq_1
XFILLER_66_1252 VPWR VGND sg13g2_decap_8
XFILLER_103_653 VPWR VGND sg13g2_fill_2
X_22006_ _22006_/Y _23997_/Q _22008_/B VPWR VGND sg13g2_nand2_1
XFILLER_103_664 VPWR VGND sg13g2_decap_4
XFILLER_102_130 VPWR VGND sg13g2_decap_8
X_20198_ _20198_/Y _20356_/B _20196_/Y _20197_/Y _20233_/A2 _15799_/C VPWR VGND sg13g2_a221oi_1
XFILLER_114_1228 VPWR VGND sg13g2_fill_2
XFILLER_48_217 VPWR VGND sg13g2_decap_8
X_23957_ _23957_/Q clkload52/A _23957_/D fanout2756/X VPWR VGND sg13g2_dfrbpq_1
X_11971_ _11972_/B _11967_/X _11968_/X _11969_/X _11970_/X _13193_/S0 _11517_/S VPWR
+ VGND sg13g2_mux4_1
XFILLER_63_209 VPWR VGND sg13g2_decap_8
XFILLER_5_1076 VPWR VGND sg13g2_decap_8
X_13710_ _13710_/Y _23920_/Q _14147_/C _13709_/X _13962_/S0 VPWR VGND sg13g2_a22oi_1
XFILLER_2_1953 VPWR VGND sg13g2_fill_2
X_22908_ _22908_/Q clkload9/A _22908_/D fanout2816/X VPWR VGND sg13g2_dfrbpq_1
X_14690_ _14690_/Y _14690_/A1 _14686_/B _14689_/Y VPWR VGND sg13g2_o21ai_1
X_23888_ _23888_/Q clkload49/A _23888_/D fanout2636/X VPWR VGND sg13g2_dfrbpq_1
XFILLER_16_147 VPWR VGND sg13g2_decap_8
X_13641_ _13648_/C _13641_/A _13641_/B VPWR VGND sg13g2_nor2_1
XFILLER_16_158 VPWR VGND sg13g2_fill_2
XFILLER_16_169 VPWR VGND sg13g2_fill_1
X_22839_ _22839_/Q clkload18/A _22839_/D fanout2828/X VPWR VGND sg13g2_dfrbpq_1
XFILLER_60_927 VPWR VGND sg13g2_decap_8
XFILLER_32_629 VPWR VGND sg13g2_fill_1
XFILLER_13_810 VPWR VGND sg13g2_decap_8
XFILLER_31_117 VPWR VGND sg13g2_fill_1
X_16360_ _22544_/D _16364_/B _16358_/Y _16359_/Y VPWR VGND sg13g2_o21ai_1
XFILLER_18_1939 VPWR VGND sg13g2_decap_8
XFILLER_73_1245 VPWR VGND sg13g2_decap_4
XFILLER_13_854 VPWR VGND sg13g2_decap_8
XFILLER_24_180 VPWR VGND sg13g2_fill_2
XFILLER_34_1207 VPWR VGND sg13g2_decap_8
X_15311_ _15322_/B _22816_/Q _15308_/Y _15309_/Y _22484_/Q VPWR VGND sg13g2_a22oi_1
X_12523_ _12523_/Y _12327_/A _12327_/B _12521_/Y _16090_/S _13296_/A VPWR VGND sg13g2_a221oi_1
XFILLER_12_353 VPWR VGND sg13g2_decap_4
XFILLER_8_302 VPWR VGND sg13g2_decap_8
X_16291_ _16293_/B _16322_/A _16298_/C VPWR VGND sg13g2_and2_1
X_18030_ _18030_/Y _18030_/A _18030_/B VPWR VGND sg13g2_nor2_1
X_12454_ _12454_/Y _23552_/Q _12998_/A2 _12453_/X _13242_/S1 VPWR VGND sg13g2_a22oi_1
X_15173_ _15625_/B _15319_/A _15178_/B _16789_/A VPWR VGND sg13g2_o21ai_1
X_12385_ _12385_/X _12385_/A _12385_/B _12385_/C _12385_/D VPWR VGND sg13g2_or4_2
XFILLER_99_607 VPWR VGND sg13g2_decap_4
XFILLER_4_530 VPWR VGND sg13g2_decap_8
X_14124_ _14591_/B _14124_/A _14461_/B _14614_/B VPWR VGND sg13g2_nor3_1
XFILLER_4_541 VPWR VGND sg13g2_fill_1
X_19981_ _19982_/B _19980_/B _19979_/Y _19980_/Y VPWR VGND sg13g2_a21oi_1
XFILLER_113_428 VPWR VGND sg13g2_decap_8
XFILLER_49_1461 VPWR VGND sg13g2_decap_8
X_18932_ _18933_/B _18931_/Y _23051_/Q _18956_/B VPWR VGND sg13g2_mux2_1
X_14055_ _14055_/X _14055_/A _14055_/B VPWR VGND sg13g2_or2_1
XFILLER_49_1472 VPWR VGND sg13g2_fill_1
X_13006_ _13006_/X _23718_/Q _23750_/Q _23782_/Q _23814_/Q _13006_/S0 _13006_/S1 VPWR
+ VGND sg13g2_mux4_1
XFILLER_97_84 VPWR VGND sg13g2_decap_8
XFILLER_95_802 VPWR VGND sg13g2_decap_8
X_18863_ _18864_/C _23076_/Q _18869_/B VPWR VGND sg13g2_nand2_1
XFILLER_7_1820 VPWR VGND sg13g2_decap_8
X_11198_ _11243_/D _11311_/B _11569_/A _14124_/A _11602_/B VPWR VGND sg13g2_nor4_2
XFILLER_79_375 VPWR VGND sg13g2_fill_1
XFILLER_67_526 VPWR VGND sg13g2_decap_8
X_17814_ _17814_/X _22578_/Q _17814_/B VPWR VGND sg13g2_xor2_1
X_18794_ _23033_/D _18794_/A _18794_/B _18794_/C VPWR VGND sg13g2_nand3_1
XFILLER_7_1897 VPWR VGND sg13g2_decap_8
XFILLER_36_902 VPWR VGND sg13g2_decap_8
XFILLER_78_1101 VPWR VGND sg13g2_decap_8
XFILLER_23_1667 VPWR VGND sg13g2_fill_2
X_17745_ _22898_/D _17796_/B _17743_/Y _17744_/Y VPWR VGND sg13g2_a21oi_1
XFILLER_23_1678 VPWR VGND sg13g2_fill_2
X_14957_ _14957_/X _22497_/Q _14912_/B _14936_/B VPWR VGND sg13g2_a21o_1
XFILLER_78_1112 VPWR VGND sg13g2_fill_1
XFILLER_48_784 VPWR VGND sg13g2_decap_4
XFILLER_63_721 VPWR VGND sg13g2_fill_1
XFILLER_78_1134 VPWR VGND sg13g2_decap_8
XFILLER_75_592 VPWR VGND sg13g2_decap_8
X_13908_ _13937_/B _14030_/A _20338_/B VPWR VGND sg13g2_xnor2_1
XFILLER_35_445 VPWR VGND sg13g2_fill_2
X_14888_ _14888_/Y _14882_/Y _14883_/Y _14887_/Y VPWR VGND sg13g2_o21ai_1
XFILLER_63_754 VPWR VGND sg13g2_fill_1
X_19415_ _19415_/Y _20034_/A _19430_/B _19414_/Y VPWR VGND sg13g2_a21oi_1
XFILLER_39_1129 VPWR VGND sg13g2_decap_4
XFILLER_63_787 VPWR VGND sg13g2_decap_4
X_16627_ _22640_/D _16150_/A _16626_/A _16626_/Y VPWR VGND sg13g2_a21oi_1
X_13839_ _13839_/X _23602_/Q _23634_/Q _23666_/Q _23698_/Q _13961_/S0 _13964_/S1 VPWR
+ VGND sg13g2_mux4_1
XFILLER_90_595 VPWR VGND sg13g2_decap_8
XFILLER_16_681 VPWR VGND sg13g2_fill_2
XFILLER_95_1492 VPWR VGND sg13g2_fill_2
X_19346_ _19634_/B _19346_/A _19379_/B VPWR VGND sg13g2_xnor2_1
X_16558_ _22626_/D _16067_/A _16561_/A _16557_/Y VPWR VGND sg13g2_a21oi_1
XFILLER_91_1345 VPWR VGND sg13g2_fill_1
XFILLER_31_651 VPWR VGND sg13g2_decap_8
X_15509_ _15509_/Y _15509_/A _15509_/B _15509_/C VPWR VGND sg13g2_nor3_1
XFILLER_31_662 VPWR VGND sg13g2_fill_1
XFILLER_108_1577 VPWR VGND sg13g2_fill_1
XFILLER_30_172 VPWR VGND sg13g2_decap_8
XFILLER_15_1151 VPWR VGND sg13g2_decap_8
X_18228_ _18228_/Y _18172_/Y _18224_/Y _18227_/Y VPWR VGND sg13g2_o21ai_1
XFILLER_15_1184 VPWR VGND sg13g2_decap_8
XFILLER_15_1195 VPWR VGND sg13g2_fill_2
X_21170_ _23609_/D _21237_/A1 _21179_/B _21169_/Y VPWR VGND sg13g2_o21ai_1
X_20121_ _20122_/C _20294_/A _20121_/B VPWR VGND sg13g2_nor2_1
XFILLER_89_139 VPWR VGND sg13g2_decap_8
XFILLER_115_1504 VPWR VGND sg13g2_decap_8
XFILLER_98_662 VPWR VGND sg13g2_decap_8
XFILLER_86_802 VPWR VGND sg13g2_fill_1
X_20052_ _20052_/Y _20052_/A _20052_/B VPWR VGND sg13g2_nand2_1
XFILLER_63_1447 VPWR VGND sg13g2_fill_2
XFILLER_63_1458 VPWR VGND sg13g2_fill_1
XFILLER_86_824 VPWR VGND sg13g2_decap_8
XFILLER_98_695 VPWR VGND sg13g2_fill_1
XFILLER_97_183 VPWR VGND sg13g2_decap_8
XFILLER_58_559 VPWR VGND sg13g2_decap_4
XFILLER_6_1341 VPWR VGND sg13g2_fill_1
X_23811_ _23811_/Q clkload39/A _23811_/D fanout2737/X VPWR VGND sg13g2_dfrbpq_1
XFILLER_100_678 VPWR VGND sg13g2_decap_8
XFILLER_39_762 VPWR VGND sg13g2_decap_8
XFILLER_39_773 VPWR VGND sg13g2_fill_2
XFILLER_61_1193 VPWR VGND sg13g2_decap_8
XFILLER_85_389 VPWR VGND sg13g2_fill_1
XFILLER_39_795 VPWR VGND sg13g2_decap_8
X_23742_ _23742_/Q clkload59/A _23742_/D fanout2784/X VPWR VGND sg13g2_dfrbpq_1
XFILLER_66_592 VPWR VGND sg13g2_decap_8
X_20954_ _20954_/Y _23522_/Q _20954_/B VPWR VGND sg13g2_nand2_1
XFILLER_54_754 VPWR VGND sg13g2_decap_4
XFILLER_57_1207 VPWR VGND sg13g2_fill_1
X_23673_ _23673_/Q clkload59/A _23673_/D fanout2782/X VPWR VGND sg13g2_dfrbpq_1
X_20885_ _23488_/D _21587_/A1 _20888_/B _20884_/Y VPWR VGND sg13g2_o21ai_1
XFILLER_53_275 VPWR VGND sg13g2_decap_8
X_22624_ _22624_/Q clkload24/A _22624_/D fanout2899/X VPWR VGND sg13g2_dfrbpq_1
XFILLER_22_651 VPWR VGND sg13g2_decap_8
XFILLER_35_1549 VPWR VGND sg13g2_fill_1
XFILLER_10_813 VPWR VGND sg13g2_fill_2
X_22555_ _22555_/Q clkload26/A _22555_/D fanout2852/X VPWR VGND sg13g2_dfrbpq_1
XFILLER_21_172 VPWR VGND sg13g2_fill_2
X_21506_ _21506_/Y _21506_/A _21508_/B VPWR VGND sg13g2_nand2_1
XFILLER_21_183 VPWR VGND sg13g2_fill_2
X_22486_ _22486_/Q clkload28/A _22486_/D fanout2855/X VPWR VGND sg13g2_dfrbpq_1
XFILLER_13_1836 VPWR VGND sg13g2_decap_8
XFILLER_52_1885 VPWR VGND sg13g2_decap_4
X_24225_ _24225_/Q clkload14/A _24225_/D fanout2905/X VPWR VGND sg13g2_dfrbpq_1
X_21437_ _21437_/Y _21437_/A _21447_/B VPWR VGND sg13g2_nand2_1
X_12170_ _12170_/X _23836_/Q _23868_/Q _23932_/Q _23964_/Q _11855_/S _12171_/S1 VPWR
+ VGND sg13g2_mux4_1
X_24156_ _24156_/Q clkload55/A _24156_/D fanout2771/X VPWR VGND sg13g2_dfrbpq_1
X_21368_ _23704_/D _21930_/A1 _21367_/B _21367_/Y VPWR VGND sg13g2_o21ai_1
XFILLER_68_1358 VPWR VGND sg13g2_decap_8
XFILLER_107_288 VPWR VGND sg13g2_fill_1
XFILLER_85_1650 VPWR VGND sg13g2_decap_4
X_23107_ _23107_/Q _23114_/CLK _23107_/D fanout2904/X VPWR VGND sg13g2_dfrbpq_1
X_20319_ _20319_/Y _20324_/A _20319_/B VPWR VGND sg13g2_nand2_1
X_24087_ _24087_/Q clkload48/A _24087_/D fanout2687/X VPWR VGND sg13g2_dfrbpq_1
XFILLER_27_1000 VPWR VGND sg13g2_fill_2
X_21299_ _23671_/D _21299_/A1 _21349_/S _21298_/Y VPWR VGND sg13g2_o21ai_1
XFILLER_110_409 VPWR VGND sg13g2_decap_4
XFILLER_89_662 VPWR VGND sg13g2_decap_8
X_23038_ _23038_/Q clkload13/A _23038_/D fanout2914/X VPWR VGND sg13g2_dfrbpq_1
XFILLER_89_673 VPWR VGND sg13g2_fill_2
XFILLER_88_150 VPWR VGND sg13g2_fill_1
XFILLER_89_684 VPWR VGND sg13g2_fill_2
XFILLER_76_301 VPWR VGND sg13g2_decap_8
XFILLER_7_1127 VPWR VGND sg13g2_decap_8
XFILLER_27_1066 VPWR VGND sg13g2_fill_2
XFILLER_77_846 VPWR VGND sg13g2_decap_8
X_15860_ _15864_/C _22475_/Q _15900_/A2 _15992_/B1 _22806_/Q VPWR VGND sg13g2_a22oi_1
XFILLER_40_1200 VPWR VGND sg13g2_fill_2
XFILLER_77_868 VPWR VGND sg13g2_fill_2
XFILLER_24_1954 VPWR VGND sg13g2_fill_1
XFILLER_40_1211 VPWR VGND sg13g2_fill_2
XFILLER_111_1913 VPWR VGND sg13g2_decap_8
X_14811_ _14812_/B _14831_/A _14811_/B VPWR VGND sg13g2_nand2_1
X_15791_ _15791_/Y _15791_/A VPWR VGND sg13g2_inv_1
XFILLER_92_849 VPWR VGND sg13g2_decap_8
XFILLER_17_412 VPWR VGND sg13g2_fill_1
XFILLER_29_272 VPWR VGND sg13g2_decap_8
XFILLER_57_581 VPWR VGND sg13g2_fill_1
X_17530_ _17531_/A _22876_/Q _17527_/A _17518_/A _17529_/Y VPWR VGND sg13g2_a22oi_1
X_14742_ _16029_/A _14861_/A _14742_/B VPWR VGND sg13g2_nand2b_1
X_11954_ _11954_/Y _12567_/A _11465_/A VPWR VGND sg13g2_nor2b_1
XFILLER_2_1750 VPWR VGND sg13g2_decap_8
XFILLER_33_916 VPWR VGND sg13g2_fill_1
XFILLER_83_75 VPWR VGND sg13g2_decap_8
X_17461_ _22848_/D _17098_/A _17462_/B _17460_/Y VPWR VGND sg13g2_o21ai_1
X_14673_ _14673_/Y _14673_/A1 _14701_/B _14672_/Y VPWR VGND sg13g2_o21ai_1
XFILLER_96_1790 VPWR VGND sg13g2_decap_4
XFILLER_33_949 VPWR VGND sg13g2_decap_4
XFILLER_109_1820 VPWR VGND sg13g2_decap_8
X_19200_ _23159_/D _24248_/A _23159_/Q _19200_/S VPWR VGND sg13g2_mux2_1
XFILLER_92_1643 VPWR VGND sg13g2_decap_4
X_13624_ _13625_/D _13624_/A _13624_/B VPWR VGND sg13g2_nor2_1
X_16412_ _22572_/D _18723_/A _18697_/A _16411_/Y VPWR VGND sg13g2_o21ai_1
XFILLER_38_1140 VPWR VGND sg13g2_decap_8
X_17392_ _17395_/S _17373_/A _17391_/Y _16031_/Y VPWR VGND sg13g2_a21oi_1
XFILLER_34_1004 VPWR VGND sg13g2_fill_2
XFILLER_105_1706 VPWR VGND sg13g2_fill_1
X_19131_ _23108_/D _23108_/Q _17994_/B _19134_/S VPWR VGND sg13g2_mux2_1
XFILLER_34_1015 VPWR VGND sg13g2_fill_2
XFILLER_53_1638 VPWR VGND sg13g2_decap_4
X_13555_ _13556_/B _23310_/Q _23342_/Q _23374_/Q _23406_/Q _13555_/S0 _13016_/S VPWR
+ VGND sg13g2_mux4_1
X_16343_ _16343_/Y _22878_/Q _15182_/X _17835_/A _16342_/Y VPWR VGND sg13g2_a22oi_1
XFILLER_109_1897 VPWR VGND sg13g2_decap_8
XFILLER_8_110 VPWR VGND sg13g2_fill_2
XFILLER_13_695 VPWR VGND sg13g2_fill_1
Xplace3909 _18361_/B _18498_/B VPWR VGND sg13g2_buf_1
X_12506_ _12506_/Y _13280_/B _12506_/B VPWR VGND sg13g2_nor2_1
X_19062_ _19062_/X _19122_/A1 _23100_/Q _19077_/S VPWR VGND sg13g2_mux2_1
X_13486_ _13486_/Y _24141_/Q _13617_/B VPWR VGND sg13g2_nand2b_1
XFILLER_8_143 VPWR VGND sg13g2_decap_8
XFILLER_73_7 VPWR VGND sg13g2_fill_2
X_15225_ _15225_/Y _17034_/A _16779_/A VPWR VGND sg13g2_nand2_1
X_12437_ _12440_/B _12439_/A _12531_/B _12436_/Y VPWR VGND sg13g2_o21ai_1
XFILLER_12_1368 VPWR VGND sg13g2_decap_4
XFILLER_114_704 VPWR VGND sg13g2_decap_8
X_12368_ _12368_/X _23807_/Q _23967_/Q _12485_/S VPWR VGND sg13g2_mux2_1
XFILLER_113_203 VPWR VGND sg13g2_decap_8
X_14107_ _14108_/S _14107_/A _19480_/C _14107_/C VPWR VGND sg13g2_nand3_1
XFILLER_4_371 VPWR VGND sg13g2_fill_1
X_11319_ _11329_/A _15216_/B _11319_/A2 _11861_/B VPWR VGND sg13g2_o21ai_1
X_15087_ _15089_/A _24273_/A _15025_/B _15086_/Y VPWR VGND sg13g2_a21oi_1
X_19964_ _19965_/D _24255_/A _20091_/B VPWR VGND sg13g2_nand2_1
XFILLER_64_1712 VPWR VGND sg13g2_decap_8
X_12299_ _12300_/D _13608_/A1 _12296_/X _12298_/X VPWR VGND sg13g2_o21ai_1
XFILLER_10_1092 VPWR VGND sg13g2_fill_1
XFILLER_64_1723 VPWR VGND sg13g2_fill_2
XFILLER_80_1002 VPWR VGND sg13g2_fill_2
XFILLER_101_409 VPWR VGND sg13g2_fill_1
X_14038_ _14038_/Y _14038_/A _14038_/B VPWR VGND sg13g2_nor2_1
X_18915_ _18915_/Y _19023_/B _23081_/Q _18959_/C VPWR VGND sg13g2_nand3_1
XFILLER_9_1948 VPWR VGND sg13g2_decap_8
X_19895_ _23228_/D _19950_/B _22405_/A1 _19894_/Y VPWR VGND sg13g2_o21ai_1
XFILLER_67_312 VPWR VGND sg13g2_decap_8
XFILLER_99_1808 VPWR VGND sg13g2_fill_1
X_18846_ _18846_/Y _18866_/A _18846_/B VPWR VGND sg13g2_nand2_1
XFILLER_41_1019 VPWR VGND sg13g2_decap_4
XFILLER_110_965 VPWR VGND sg13g2_decap_8
XFILLER_95_665 VPWR VGND sg13g2_decap_8
XFILLER_83_805 VPWR VGND sg13g2_decap_8
XFILLER_83_816 VPWR VGND sg13g2_fill_1
XFILLER_7_1683 VPWR VGND sg13g2_decap_8
XFILLER_3_1525 VPWR VGND sg13g2_decap_8
X_18777_ _18782_/A _23031_/Q _18821_/B _18821_/C VPWR VGND sg13g2_nand3_1
X_15989_ _15993_/A _22870_/Q _15989_/A2 _15684_/B _22908_/Q VPWR VGND sg13g2_a22oi_1
XFILLER_110_1423 VPWR VGND sg13g2_fill_2
XFILLER_48_581 VPWR VGND sg13g2_decap_8
X_17728_ _17728_/Y _17728_/A _17796_/B VPWR VGND sg13g2_nor2_1
XFILLER_36_754 VPWR VGND sg13g2_decap_8
XFILLER_91_882 VPWR VGND sg13g2_decap_8
X_17659_ _17659_/Y _17113_/A _17388_/B _17670_/B1 _17658_/Y VPWR VGND sg13g2_a22oi_1
XFILLER_23_426 VPWR VGND sg13g2_decap_8
XFILLER_63_595 VPWR VGND sg13g2_decap_8
XFILLER_50_223 VPWR VGND sg13g2_decap_4
XFILLER_50_245 VPWR VGND sg13g2_fill_1
XFILLER_17_1213 VPWR VGND sg13g2_decap_8
X_19329_ _19329_/Y _20147_/B _19412_/B VPWR VGND sg13g2_nor2_1
XFILLER_52_1115 VPWR VGND sg13g2_decap_4
X_22340_ _24157_/D _22407_/A1 _22341_/B _22339_/Y VPWR VGND sg13g2_o21ai_1
XFILLER_12_49 VPWR VGND sg13g2_decap_8
XFILLER_69_1612 VPWR VGND sg13g2_decap_4
X_22271_ _22271_/Y _22271_/A _22276_/B VPWR VGND sg13g2_nand2_1
Xoutput4475 data_addr_o[17] _24262_/X VPWR VGND sg13g2_buf_1
Xoutput4486 data_addr_o[28] _24273_/X VPWR VGND sg13g2_buf_1
X_24010_ _24010_/Q clkload45/A _24010_/D fanout2711/X VPWR VGND sg13g2_dfrbpq_1
Xoutput4497 data_addr_o[9] _24254_/X VPWR VGND sg13g2_buf_1
X_21222_ _23636_/D _21622_/A1 _21221_/B _21221_/Y VPWR VGND sg13g2_o21ai_1
XFILLER_105_704 VPWR VGND sg13g2_decap_8
XFILLER_89_1093 VPWR VGND sg13g2_decap_8
X_21153_ _23603_/D _23603_/Q _21781_/A1 _21153_/S VPWR VGND sg13g2_mux2_1
XFILLER_105_759 VPWR VGND sg13g2_decap_4
XFILLER_47_1954 VPWR VGND sg13g2_fill_1
XFILLER_8_1403 VPWR VGND sg13g2_fill_1
X_20104_ _20104_/Y _23236_/Q _20144_/B VPWR VGND sg13g2_nand2_1
XFILLER_8_1425 VPWR VGND sg13g2_decap_8
XFILLER_8_1436 VPWR VGND sg13g2_fill_2
XFILLER_82_1878 VPWR VGND sg13g2_decap_8
XFILLER_113_792 VPWR VGND sg13g2_decap_8
XFILLER_100_420 VPWR VGND sg13g2_decap_8
XFILLER_63_1277 VPWR VGND sg13g2_decap_8
X_20035_ _20035_/Y _20229_/A _20035_/B VPWR VGND sg13g2_nor2_1
XFILLER_112_291 VPWR VGND sg13g2_decap_8
XFILLER_115_1367 VPWR VGND sg13g2_fill_1
XFILLER_98_1307 VPWR VGND sg13g2_fill_1
XFILLER_59_879 VPWR VGND sg13g2_decap_8
XFILLER_98_1329 VPWR VGND sg13g2_decap_4
XFILLER_86_687 VPWR VGND sg13g2_decap_4
XFILLER_85_186 VPWR VGND sg13g2_decap_8
XFILLER_39_581 VPWR VGND sg13g2_decap_8
XFILLER_100_497 VPWR VGND sg13g2_decap_8
XFILLER_2_1035 VPWR VGND sg13g2_decap_8
XFILLER_41_1597 VPWR VGND sg13g2_decap_8
XFILLER_54_540 VPWR VGND sg13g2_fill_1
XFILLER_76_1616 VPWR VGND sg13g2_fill_1
XFILLER_57_1004 VPWR VGND sg13g2_decap_8
X_23725_ _23725_/Q clkload30/A _23725_/D fanout2656/X VPWR VGND sg13g2_dfrbpq_1
XFILLER_57_1015 VPWR VGND sg13g2_fill_1
X_20937_ _23514_/D _21305_/A1 _20936_/B _20936_/Y VPWR VGND sg13g2_o21ai_1
XFILLER_14_404 VPWR VGND sg13g2_decap_4
XFILLER_96_1086 VPWR VGND sg13g2_fill_1
XFILLER_54_595 VPWR VGND sg13g2_decap_4
XFILLER_93_1941 VPWR VGND sg13g2_decap_8
XFILLER_81_392 VPWR VGND sg13g2_decap_8
X_23656_ _23656_/Q clkload31/A _23656_/D fanout2655/X VPWR VGND sg13g2_dfrbpq_1
XFILLER_53_56 VPWR VGND sg13g2_decap_8
X_20868_ _20868_/Y _20868_/A _20879_/B VPWR VGND sg13g2_nand2_1
XFILLER_53_67 VPWR VGND sg13g2_fill_1
X_22607_ _22607_/Q clkload8/A _22607_/D fanout2798/X VPWR VGND sg13g2_dfrbpq_1
XFILLER_41_267 VPWR VGND sg13g2_decap_4
XFILLER_70_1215 VPWR VGND sg13g2_fill_2
X_23587_ _23587_/Q clkload42/A _23587_/D fanout2705/X VPWR VGND sg13g2_dfrbpq_1
XFILLER_35_1346 VPWR VGND sg13g2_decap_4
XFILLER_41_289 VPWR VGND sg13g2_decap_8
X_20799_ _20799_/Y _20799_/A _20801_/B VPWR VGND sg13g2_nand2_1
X_13340_ _13340_/X _23851_/Q _23883_/Q _23947_/Q _23979_/Q _13551_/S0 _11493_/A VPWR
+ VGND sg13g2_mux4_1
X_22538_ _22538_/Q clkload6/A _22538_/D fanout2832/X VPWR VGND sg13g2_dfrbpq_1
XFILLER_33_1070 VPWR VGND sg13g2_fill_1
X_13271_ _13271_/Y _13271_/A VPWR VGND sg13g2_inv_1
X_22469_ _22469_/Q clkload8/A _22469_/D fanout2806/X VPWR VGND sg13g2_dfrbpq_1
XFILLER_108_531 VPWR VGND sg13g2_decap_8
X_15010_ _16295_/A _15010_/A _15010_/B VPWR VGND sg13g2_or2_1
X_12222_ _12341_/B _14342_/C _12305_/B _14321_/A VPWR VGND sg13g2_nand3b_1
XFILLER_5_146 VPWR VGND sg13g2_decap_8
X_24208_ _24208_/Q _24214_/CLK _24208_/D fanout2631/X VPWR VGND sg13g2_dfrbpq_1
XFILLER_100_1669 VPWR VGND sg13g2_fill_1
XFILLER_48_1729 VPWR VGND sg13g2_fill_1
X_24139_ _24139_/Q _24212_/CLK _24139_/D fanout2634/X VPWR VGND sg13g2_dfrbpq_1
XFILLER_68_1177 VPWR VGND sg13g2_fill_1
Xfanout2801 fanout2801/X fanout2802/X VPWR VGND sg13g2_buf_1
XFILLER_29_1139 VPWR VGND sg13g2_fill_2
Xfanout2812 fanout2812/X fanout2815/X VPWR VGND sg13g2_buf_1
Xfanout2823 fanout2823/X fanout2826/X VPWR VGND sg13g2_buf_1
XFILLER_81_1322 VPWR VGND sg13g2_decap_8
Xfanout2834 fanout2834/X fanout2835/X VPWR VGND sg13g2_buf_1
X_12084_ _12091_/C _12959_/A _19804_/A _12084_/C _12084_/D VPWR VGND sg13g2_nand4_1
XFILLER_81_1333 VPWR VGND sg13g2_fill_2
Xfanout2845 fanout2845/X fanout2849/X VPWR VGND sg13g2_buf_1
X_16961_ _16962_/B _17004_/B _16975_/A VPWR VGND sg13g2_nor2b_1
XFILLER_89_470 VPWR VGND sg13g2_decap_8
Xfanout2856 fanout2856/X fanout2861/X VPWR VGND sg13g2_buf_1
XFILLER_110_217 VPWR VGND sg13g2_decap_8
Xfanout2867 fanout2867/X fanout2869/X VPWR VGND sg13g2_buf_1
X_18700_ _18711_/D _18700_/A VPWR VGND sg13g2_inv_1
Xfanout2878 fanout2878/X fanout2901/X VPWR VGND sg13g2_buf_1
X_15912_ _15912_/Y _22574_/Q _15956_/B VPWR VGND sg13g2_nand2_1
XFILLER_46_1486 VPWR VGND sg13g2_fill_2
Xfanout2889 fanout2889/X fanout2890/X VPWR VGND sg13g2_buf_1
X_19680_ _19680_/Y _20278_/A3 _19881_/A2 _19881_/B1 _20278_/A1 VPWR VGND sg13g2_a22oi_1
XFILLER_42_1328 VPWR VGND sg13g2_decap_8
XFILLER_77_643 VPWR VGND sg13g2_decap_8
X_16892_ _16893_/B _22688_/Q _22687_/Q _16907_/C VPWR VGND sg13g2_nand3_1
XFILLER_65_805 VPWR VGND sg13g2_decap_4
XFILLER_24_1740 VPWR VGND sg13g2_fill_2
XFILLER_4_1823 VPWR VGND sg13g2_decap_8
X_18631_ _18632_/B _14244_/Y _18633_/B _16243_/A VPWR VGND sg13g2_a21oi_1
XFILLER_94_41 VPWR VGND sg13g2_decap_8
X_15843_ _15843_/Y _15935_/S _17182_/A _15842_/Y VPWR VGND sg13g2_o21ai_1
XFILLER_49_378 VPWR VGND sg13g2_decap_8
XFILLER_49_389 VPWR VGND sg13g2_fill_1
XFILLER_65_838 VPWR VGND sg13g2_fill_1
XFILLER_76_175 VPWR VGND sg13g2_decap_8
XFILLER_76_186 VPWR VGND sg13g2_fill_2
XFILLER_64_337 VPWR VGND sg13g2_decap_8
X_18562_ _18562_/Y _18562_/A _18562_/B _18562_/C VPWR VGND sg13g2_nand3_1
XFILLER_0_1709 VPWR VGND sg13g2_decap_4
X_12986_ _12987_/B _23302_/Q _23334_/Q _23366_/Q _23398_/Q _12983_/A _12986_/S1 VPWR
+ VGND sg13g2_mux4_1
XFILLER_59_1825 VPWR VGND sg13g2_decap_8
X_15774_ _15775_/B _20179_/A _15996_/A _15774_/C VPWR VGND sg13g2_nand3_1
XFILLER_91_156 VPWR VGND sg13g2_decap_8
XFILLER_17_242 VPWR VGND sg13g2_decap_8
XFILLER_111_1787 VPWR VGND sg13g2_decap_8
XFILLER_45_562 VPWR VGND sg13g2_decap_8
X_17513_ _17514_/B _22875_/Q _22874_/Q _17527_/A VPWR VGND sg13g2_o21ai_1
XFILLER_91_178 VPWR VGND sg13g2_fill_2
XFILLER_18_787 VPWR VGND sg13g2_decap_8
X_14725_ _14725_/X _14651_/X _14650_/Y _14726_/S VPWR VGND sg13g2_mux2_1
XFILLER_73_882 VPWR VGND sg13g2_decap_8
X_11937_ _12305_/B _12668_/A _14342_/B VPWR VGND sg13g2_nor2_1
XFILLER_32_201 VPWR VGND sg13g2_fill_2
XFILLER_45_595 VPWR VGND sg13g2_decap_8
XFILLER_32_223 VPWR VGND sg13g2_fill_1
XFILLER_72_392 VPWR VGND sg13g2_decap_4
X_17444_ _22840_/D _17444_/A1 _17453_/B _17443_/Y VPWR VGND sg13g2_o21ai_1
X_14656_ _14656_/Y _14694_/A _14701_/B VPWR VGND sg13g2_nand2_1
X_13607_ _13607_/X _13607_/A _13607_/B VPWR VGND sg13g2_or2_1
XFILLER_53_1435 VPWR VGND sg13g2_decap_8
X_17375_ _17376_/B _22814_/Q _16357_/C _17385_/S VPWR VGND sg13g2_mux2_1
X_11799_ _11800_/B _23577_/Q _23641_/Q _12191_/S VPWR VGND sg13g2_mux2_1
XFILLER_92_1495 VPWR VGND sg13g2_fill_2
X_14587_ _14587_/Y _19268_/A _19257_/B VPWR VGND sg13g2_nor2b_1
Xrebuffer5408 _13187_/A1 _14342_/C VPWR VGND sg13g2_buf_1
X_19114_ _19114_/X _19039_/A _23125_/Q _19114_/S VPWR VGND sg13g2_mux2_1
Xrebuffer5419 _11258_/B _11606_/A VPWR VGND sg13g2_buf_1
X_16326_ _16331_/C _16326_/A _16326_/B VPWR VGND sg13g2_and2_1
Xplace3706 _19977_/B _20091_/B VPWR VGND sg13g2_buf_1
X_13538_ _13538_/Y _19320_/B _13538_/B VPWR VGND sg13g2_nand2_1
Xplace3717 _14358_/B _19983_/B VPWR VGND sg13g2_buf_1
Xplace3728 _14021_/B place3728/A VPWR VGND sg13g2_buf_1
Xplace3739 _19448_/B _19351_/B VPWR VGND sg13g2_buf_1
X_19045_ _19046_/C _23061_/Q _19045_/B _19045_/C VPWR VGND sg13g2_or3_1
X_13469_ _13469_/Y _13469_/A _13469_/B _13469_/C _13469_/D VPWR VGND sg13g2_nor4_2
X_16257_ _18648_/A _16257_/A _16257_/B VPWR VGND sg13g2_nor2_1
XFILLER_12_1132 VPWR VGND sg13g2_decap_8
XFILLER_12_1143 VPWR VGND sg13g2_fill_1
Xhold5109 _20713_/A _23412_/Q VPWR VGND sg13g2_dlygate4sd3_1
XFILLER_31_1777 VPWR VGND sg13g2_decap_4
XFILLER_86_1222 VPWR VGND sg13g2_fill_2
X_15208_ _16161_/A _16439_/A _15210_/B VPWR VGND sg13g2_and2_1
XFILLER_114_501 VPWR VGND sg13g2_decap_8
X_16188_ _16188_/Y _22509_/Q _16187_/B _16187_/Y VPWR VGND sg13g2_a21oi_1
XFILLER_99_212 VPWR VGND sg13g2_decap_8
XFILLER_47_1206 VPWR VGND sg13g2_decap_8
XFILLER_47_1217 VPWR VGND sg13g2_fill_1
XFILLER_64_1520 VPWR VGND sg13g2_fill_2
XFILLER_114_578 VPWR VGND sg13g2_decap_8
XFILLER_99_267 VPWR VGND sg13g2_decap_8
XFILLER_102_729 VPWR VGND sg13g2_decap_4
X_19947_ _19947_/Y _20329_/B2 _19941_/Y _19946_/Y VPWR VGND sg13g2_a21oi_1
XFILLER_9_1745 VPWR VGND sg13g2_decap_4
XFILLER_5_1609 VPWR VGND sg13g2_decap_4
X_19878_ _19878_/Y _20031_/A _19871_/X _19877_/X VPWR VGND sg13g2_a21oi_1
XFILLER_68_654 VPWR VGND sg13g2_decap_4
XFILLER_25_1559 VPWR VGND sg13g2_decap_4
XFILLER_110_773 VPWR VGND sg13g2_decap_8
X_18829_ _18829_/Y _24225_/Q _23039_/Q _18856_/B _19126_/A1 VPWR VGND sg13g2_a22oi_1
XFILLER_3_1300 VPWR VGND sg13g2_decap_8
XFILLER_83_624 VPWR VGND sg13g2_decap_8
XFILLER_23_1272 VPWR VGND sg13g2_decap_4
XFILLER_77_1903 VPWR VGND sg13g2_decap_8
X_21840_ _21840_/Y _23918_/Q _21843_/B VPWR VGND sg13g2_nand2_1
XFILLER_83_679 VPWR VGND sg13g2_decap_8
XFILLER_82_167 VPWR VGND sg13g2_decap_8
X_21771_ _21771_/Y _21771_/A _21771_/B VPWR VGND sg13g2_nand2_1
XFILLER_93_1226 VPWR VGND sg13g2_decap_4
XFILLER_24_735 VPWR VGND sg13g2_decap_8
X_23510_ _23510_/Q clkload53/A _23510_/D fanout2781/X VPWR VGND sg13g2_dfrbpq_1
XFILLER_93_1259 VPWR VGND sg13g2_decap_8
XFILLER_63_392 VPWR VGND sg13g2_fill_1
XFILLER_51_565 VPWR VGND sg13g2_decap_8
XFILLER_71_1502 VPWR VGND sg13g2_decap_8
XFILLER_51_576 VPWR VGND sg13g2_fill_1
XFILLER_71_1513 VPWR VGND sg13g2_decap_8
X_23441_ _23441_/Q _24113_/CLK _23441_/D fanout2682/X VPWR VGND sg13g2_dfrbpq_1
Xclkbuf_leaf_53_clk_i _24196_/CLK clkbuf_4_9__f_clk_i/X VPWR VGND sg13g2_buf_16
XFILLER_71_1546 VPWR VGND sg13g2_fill_2
XFILLER_17_1054 VPWR VGND sg13g2_decap_8
XFILLER_104_1024 VPWR VGND sg13g2_decap_4
X_23372_ _23372_/Q _24214_/CLK _23372_/D fanout2629/X VPWR VGND sg13g2_dfrbpq_1
Xclkbuf_4_11__f_clk_i clkload2/A clkbuf_3_5_0_clk_i/X VPWR VGND sg13g2_buf_8
XFILLER_109_328 VPWR VGND sg13g2_decap_8
XFILLER_14_1942 VPWR VGND sg13g2_decap_8
XFILLER_20_985 VPWR VGND sg13g2_decap_4
XFILLER_101_1901 VPWR VGND sg13g2_decap_8
X_22323_ _24149_/D _22390_/A1 _22383_/B _22322_/Y VPWR VGND sg13g2_o21ai_1
XFILLER_14_1953 VPWR VGND sg13g2_fill_2
Xclkbuf_leaf_68_clk_i _23114_/CLK clkbuf_4_2__f_clk_i/X VPWR VGND sg13g2_buf_16
XFILLER_84_1918 VPWR VGND sg13g2_fill_2
XFILLER_105_523 VPWR VGND sg13g2_decap_8
Xhold4920 _20668_/A _23388_/Q VPWR VGND sg13g2_dlygate4sd3_1
X_21205_ _21205_/Y _23626_/Q _21205_/B VPWR VGND sg13g2_nand2_1
Xhold4931 _22134_/A _24058_/Q VPWR VGND sg13g2_dlygate4sd3_1
XFILLER_3_7 VPWR VGND sg13g2_decap_8
X_22185_ _24084_/D _22317_/A1 _22184_/B _22184_/Y VPWR VGND sg13g2_o21ai_1
XFILLER_79_919 VPWR VGND sg13g2_decap_8
Xhold4942 _22371_/A _24172_/Q VPWR VGND sg13g2_dlygate4sd3_1
Xhold4953 _22056_/A _24021_/Q VPWR VGND sg13g2_dlygate4sd3_1
Xhold4964 _21895_/A _23943_/Q VPWR VGND sg13g2_dlygate4sd3_1
XFILLER_47_1740 VPWR VGND sg13g2_fill_2
X_21136_ _23592_/D _23592_/Q _21335_/A0 _21153_/S VPWR VGND sg13g2_mux2_1
Xhold4975 _20938_/A _23515_/Q VPWR VGND sg13g2_dlygate4sd3_1
XFILLER_28_1150 VPWR VGND sg13g2_decap_8
Xhold4986 _21816_/A _23905_/Q VPWR VGND sg13g2_dlygate4sd3_1
XFILLER_99_790 VPWR VGND sg13g2_decap_4
Xhold4997 _21408_/A _23723_/Q VPWR VGND sg13g2_dlygate4sd3_1
XFILLER_115_1131 VPWR VGND sg13g2_decap_8
XFILLER_87_952 VPWR VGND sg13g2_fill_1
X_21067_ _21067_/Y _23564_/Q _21085_/B VPWR VGND sg13g2_nand2_1
XFILLER_87_963 VPWR VGND sg13g2_fill_1
XFILLER_24_1025 VPWR VGND sg13g2_fill_1
XFILLER_101_751 VPWR VGND sg13g2_decap_8
X_20018_ _20018_/Y _20071_/A _20018_/B VPWR VGND sg13g2_nand2_1
XFILLER_98_1126 VPWR VGND sg13g2_decap_8
XFILLER_59_698 VPWR VGND sg13g2_decap_8
XFILLER_100_272 VPWR VGND sg13g2_fill_1
XFILLER_21_1924 VPWR VGND sg13g2_decap_8
X_12840_ _12840_/Y _20063_/A _20064_/B VPWR VGND sg13g2_nand2_1
XFILLER_46_359 VPWR VGND sg13g2_fill_1
XFILLER_74_668 VPWR VGND sg13g2_fill_2
XFILLER_104_84 VPWR VGND sg13g2_decap_8
XFILLER_73_156 VPWR VGND sg13g2_decap_8
XFILLER_73_167 VPWR VGND sg13g2_fill_2
XFILLER_27_573 VPWR VGND sg13g2_decap_4
X_12771_ _12771_/X _23236_/Q _23364_/Q _13019_/A VPWR VGND sg13g2_mux2_1
X_21969_ _23979_/D _21969_/A1 _21982_/B _21968_/Y VPWR VGND sg13g2_o21ai_1
XFILLER_70_830 VPWR VGND sg13g2_decap_8
X_11722_ _11725_/C _13208_/A _11722_/B VPWR VGND sg13g2_nor2_1
X_14510_ _14513_/B _22603_/Q _23014_/Q VPWR VGND sg13g2_xnor2_1
X_23708_ _23708_/Q _23966_/CLK _23708_/D fanout2764/X VPWR VGND sg13g2_dfrbpq_1
X_15490_ _15490_/Y _15577_/A _15474_/Y _15489_/Y VPWR VGND sg13g2_o21ai_1
XFILLER_19_1820 VPWR VGND sg13g2_decap_8
XFILLER_15_779 VPWR VGND sg13g2_fill_1
XFILLER_35_1110 VPWR VGND sg13g2_decap_8
XFILLER_70_885 VPWR VGND sg13g2_decap_4
X_23639_ _23639_/Q clkload58/A _23639_/D fanout2758/X VPWR VGND sg13g2_dfrbpq_1
X_11653_ _11653_/Y _19346_/A _11641_/Y _11645_/X _14039_/A VPWR VGND sg13g2_a22oi_1
XFILLER_39_1290 VPWR VGND sg13g2_decap_8
X_14441_ _14441_/Y _14441_/A _14441_/B VPWR VGND sg13g2_nor2_1
X_14372_ _15159_/B _15447_/A _15447_/B _14372_/C _14372_/D VPWR VGND sg13g2_and4_1
X_17160_ _17171_/B _22735_/Q _22734_/Q _22733_/Q _17160_/D VPWR VGND sg13g2_nand4_1
XFILLER_106_1867 VPWR VGND sg13g2_decap_8
X_11584_ _14080_/A _14434_/A _11583_/X _11579_/Y VPWR VGND sg13g2_o21ai_1
X_16111_ _16111_/Y _16111_/A _16205_/B VPWR VGND sg13g2_nand2_1
X_17091_ _17091_/Y _22723_/Q _17091_/B VPWR VGND sg13g2_xnor2_1
XFILLER_10_495 VPWR VGND sg13g2_fill_1
X_13254_ _13254_/Y _23914_/Q _14147_/C _13253_/X _13551_/S0 _13559_/S1 VPWR VGND sg13g2_a221oi_1
XFILLER_100_1444 VPWR VGND sg13g2_decap_8
XFILLER_13_1496 VPWR VGND sg13g2_decap_8
XFILLER_89_63 VPWR VGND sg13g2_decap_8
X_12205_ _12206_/B _23293_/Q _23357_/Q _12216_/S VPWR VGND sg13g2_mux2_1
X_19801_ _19801_/Y _19801_/A _19803_/B _20038_/A VPWR VGND sg13g2_nor3_1
XFILLER_97_727 VPWR VGND sg13g2_decap_8
X_12136_ _12136_/Y _11953_/A _12131_/Y _12133_/Y _13266_/A1 _12135_/Y VPWR VGND sg13g2_a221oi_1
XFILLER_26_1802 VPWR VGND sg13g2_decap_8
Xfanout2631 fanout2631/X fanout2632/X VPWR VGND sg13g2_buf_1
X_17993_ _17993_/Y _18048_/S _23044_/Q VPWR VGND sg13g2_nand2_1
XFILLER_36_7 VPWR VGND sg13g2_fill_1
Xfanout2642 fanout2642/X fanout2643/X VPWR VGND sg13g2_buf_1
XFILLER_65_1873 VPWR VGND sg13g2_decap_4
Xfanout2653 fanout2653/X fanout2655/X VPWR VGND sg13g2_buf_1
XFILLER_111_548 VPWR VGND sg13g2_decap_8
Xfanout2664 fanout2664/X fanout2665/X VPWR VGND sg13g2_buf_1
X_19732_ _19740_/B _19732_/A _19732_/B VPWR VGND sg13g2_nand2_1
X_16944_ _16945_/B _17024_/A _16947_/C _16947_/D VPWR VGND sg13g2_nor3_2
X_12067_ _19446_/A _12099_/A _12099_/B VPWR VGND sg13g2_nand2_2
Xfanout2675 fanout2675/X fanout2678/X VPWR VGND sg13g2_buf_1
Xfanout2686 fanout2686/X fanout2687/X VPWR VGND sg13g2_buf_1
XFILLER_49_131 VPWR VGND sg13g2_decap_4
Xfanout2697 fanout2697/X fanout2698/X VPWR VGND sg13g2_buf_1
XFILLER_77_451 VPWR VGND sg13g2_decap_8
XFILLER_65_602 VPWR VGND sg13g2_fill_1
X_19663_ _19663_/X _19663_/A _19735_/B VPWR VGND sg13g2_and2_1
XFILLER_42_1158 VPWR VGND sg13g2_decap_8
XFILLER_65_613 VPWR VGND sg13g2_fill_1
XFILLER_37_315 VPWR VGND sg13g2_fill_2
XFILLER_4_1642 VPWR VGND sg13g2_decap_4
XFILLER_64_112 VPWR VGND sg13g2_decap_8
XFILLER_93_955 VPWR VGND sg13g2_decap_8
X_18614_ _18614_/Y _18757_/A _18613_/Y _23001_/Q VPWR VGND sg13g2_a21oi_1
X_15826_ _15829_/B _22505_/Q _15893_/A2 _15893_/B1 _15826_/B2 VPWR VGND sg13g2_a22oi_1
XFILLER_64_134 VPWR VGND sg13g2_fill_2
X_19594_ _19594_/Y _20082_/A _19594_/B VPWR VGND sg13g2_nand2_1
XFILLER_92_454 VPWR VGND sg13g2_decap_8
XFILLER_65_679 VPWR VGND sg13g2_decap_8
XFILLER_98_1682 VPWR VGND sg13g2_fill_1
XFILLER_4_1697 VPWR VGND sg13g2_decap_8
XFILLER_46_871 VPWR VGND sg13g2_decap_8
XFILLER_79_1070 VPWR VGND sg13g2_fill_2
X_18545_ _18545_/Y _18380_/A _18538_/X _18542_/Y _18514_/A _18544_/Y VPWR VGND sg13g2_a221oi_1
XFILLER_80_649 VPWR VGND sg13g2_decap_4
XFILLER_20_1489 VPWR VGND sg13g2_fill_1
XFILLER_33_510 VPWR VGND sg13g2_decap_8
X_12969_ _12969_/Y _12942_/X _12947_/B _12968_/X _12956_/Y VPWR VGND sg13g2_a22oi_1
XFILLER_79_1092 VPWR VGND sg13g2_decap_8
X_14708_ _14708_/X _14705_/Y _14707_/Y _14739_/S VPWR VGND sg13g2_mux2_1
XFILLER_61_852 VPWR VGND sg13g2_decap_4
X_18476_ _18476_/Y _18476_/A _18476_/B VPWR VGND sg13g2_nand2_1
X_15688_ _15689_/D _15688_/A _15688_/B _15688_/C _15688_/D VPWR VGND sg13g2_nand4_1
XFILLER_33_576 VPWR VGND sg13g2_fill_1
X_17427_ _22833_/D _17920_/B2 _22833_/Q _17432_/S VPWR VGND sg13g2_mux2_1
XFILLER_20_204 VPWR VGND sg13g2_fill_2
XFILLER_61_896 VPWR VGND sg13g2_fill_1
X_14639_ _14639_/Y _23190_/Q _19238_/B VPWR VGND sg13g2_nand2b_1
Xplace4204 _13900_/S0 _13193_/S0 VPWR VGND sg13g2_buf_4
XFILLER_72_1866 VPWR VGND sg13g2_decap_8
Xplace4215 _13635_/S0 _14852_/A VPWR VGND sg13g2_buf_2
Xplace4226 _11921_/A _12042_/B VPWR VGND sg13g2_buf_1
XFILLER_18_1363 VPWR VGND sg13g2_decap_4
Xrebuffer5216 _19807_/A1 _14049_/A VPWR VGND sg13g2_buf_1
Xplace4237 _13115_/A _13774_/A VPWR VGND sg13g2_buf_1
XFILLER_105_1333 VPWR VGND sg13g2_decap_4
XFILLER_18_1385 VPWR VGND sg13g2_decap_8
Xplace3503 _24265_/A _15009_/B2 VPWR VGND sg13g2_buf_1
X_17358_ _17358_/Y _17358_/A _17358_/B VPWR VGND sg13g2_nand2_1
Xplace4248 _13686_/A _12050_/C VPWR VGND sg13g2_buf_1
Xrebuffer5227 _13093_/B place3712/A VPWR VGND sg13g2_buf_1
Xplace3514 _19232_/B _19229_/S VPWR VGND sg13g2_buf_1
Xrebuffer5238 _13087_/B _13057_/B VPWR VGND sg13g2_buf_1
Xplace4259 _12651_/S1 _12457_/S1 VPWR VGND sg13g2_buf_4
Xrebuffer5249 _14614_/C _17934_/C VPWR VGND sg13g2_buf_1
Xplace3525 _15700_/B _15991_/A2 VPWR VGND sg13g2_buf_1
Xplace3536 _19181_/S _19176_/B VPWR VGND sg13g2_buf_1
X_16309_ _22535_/D _18712_/A _16303_/Y _16311_/B VPWR VGND sg13g2_a21oi_1
XFILLER_88_1317 VPWR VGND sg13g2_fill_2
Xplace3547 _15698_/A2 _15309_/Y VPWR VGND sg13g2_buf_1
Xplace3558 _14631_/B _19611_/A VPWR VGND sg13g2_buf_1
XFILLER_9_293 VPWR VGND sg13g2_decap_8
X_17289_ _17289_/Y _17289_/A _17293_/B VPWR VGND sg13g2_nand2_1
XFILLER_31_1552 VPWR VGND sg13g2_decap_8
Xclkload30 clkload30/X clkload30/A VPWR VGND sg13g2_buf_16
Xplace3569 _19735_/B _19536_/B VPWR VGND sg13g2_buf_1
XFILLER_62_0 VPWR VGND sg13g2_fill_1
X_19028_ _19030_/B _19028_/A _19039_/B VPWR VGND sg13g2_nand2_1
Xclkload41 clkload41/Y clkload41/A VPWR VGND sg13g2_inv_8
XFILLER_115_810 VPWR VGND sg13g2_decap_8
Xclkload52 clkload52/Y clkload52/A VPWR VGND sg13g2_inv_4
XFILLER_47_1025 VPWR VGND sg13g2_decap_8
XFILLER_115_887 VPWR VGND sg13g2_decap_8
XFILLER_86_1096 VPWR VGND sg13g2_decap_8
XFILLER_114_364 VPWR VGND sg13g2_decap_4
XFILLER_102_526 VPWR VGND sg13g2_decap_8
XFILLER_29_1492 VPWR VGND sg13g2_fill_1
X_23990_ _23990_/Q clkload46/A _23990_/D fanout2677/X VPWR VGND sg13g2_dfrbpq_1
XFILLER_60_1214 VPWR VGND sg13g2_decap_4
XFILLER_9_1575 VPWR VGND sg13g2_fill_1
XFILLER_99_1413 VPWR VGND sg13g2_decap_8
X_22941_ _22941_/Q _22941_/CLK _22941_/D fanout2802/X VPWR VGND sg13g2_dfrbpq_1
XFILLER_28_304 VPWR VGND sg13g2_decap_8
XFILLER_56_613 VPWR VGND sg13g2_decap_8
XFILLER_60_1258 VPWR VGND sg13g2_decap_8
XFILLER_83_410 VPWR VGND sg13g2_fill_2
XFILLER_110_592 VPWR VGND sg13g2_decap_8
XFILLER_28_337 VPWR VGND sg13g2_decap_8
X_22872_ _22872_/Q clkload18/A _22872_/D fanout2827/X VPWR VGND sg13g2_dfrbpq_1
XFILLER_55_145 VPWR VGND sg13g2_decap_4
XFILLER_43_318 VPWR VGND sg13g2_fill_1
X_21823_ _23908_/D _22356_/A1 _21826_/B _21822_/Y VPWR VGND sg13g2_o21ai_1
XFILLER_38_1706 VPWR VGND sg13g2_decap_8
XFILLER_38_1717 VPWR VGND sg13g2_fill_2
XFILLER_77_1777 VPWR VGND sg13g2_decap_4
XFILLER_70_148 VPWR VGND sg13g2_decap_8
X_21754_ _21754_/Y _23879_/Q _21754_/B VPWR VGND sg13g2_nand2_1
XFILLER_77_1799 VPWR VGND sg13g2_fill_1
XFILLER_12_705 VPWR VGND sg13g2_decap_8
XFILLER_54_1018 VPWR VGND sg13g2_fill_1
XFILLER_12_716 VPWR VGND sg13g2_fill_1
XFILLER_24_576 VPWR VGND sg13g2_decap_8
X_20705_ _23406_/D _22442_/A1 _20704_/B _20704_/Y VPWR VGND sg13g2_o21ai_1
XFILLER_106_1108 VPWR VGND sg13g2_decap_8
X_21685_ _23856_/D _21977_/A1 _21635_/B _21684_/Y VPWR VGND sg13g2_o21ai_1
XFILLER_8_709 VPWR VGND sg13g2_fill_2
X_23424_ _23424_/Q clkload40/A _23424_/D fanout2736/X VPWR VGND sg13g2_dfrbpq_1
X_20636_ _23372_/D _20702_/A1 _20647_/B _20635_/Y VPWR VGND sg13g2_o21ai_1
XFILLER_32_1316 VPWR VGND sg13g2_decap_8
Xclkload2 clkload2/X clkload2/A VPWR VGND sg13g2_buf_16
XFILLER_71_1365 VPWR VGND sg13g2_decap_8
XFILLER_71_1376 VPWR VGND sg13g2_fill_1
XFILLER_50_35 VPWR VGND sg13g2_fill_2
X_23355_ _23355_/Q clkload54/A _23355_/D fanout2771/X VPWR VGND sg13g2_dfrbpq_1
X_20567_ _20567_/Y _23339_/Q _20581_/B VPWR VGND sg13g2_nand2_1
XFILLER_109_147 VPWR VGND sg13g2_decap_8
XFILLER_50_68 VPWR VGND sg13g2_fill_2
X_22306_ _24141_/D _22373_/A1 _24141_/Q _22315_/S VPWR VGND sg13g2_mux2_1
XFILLER_30_1051 VPWR VGND sg13g2_decap_8
X_23286_ _23286_/Q clkload44/A _23286_/D fanout2751/X VPWR VGND sg13g2_dfrbpq_1
XFILLER_4_937 VPWR VGND sg13g2_decap_8
XFILLER_101_1764 VPWR VGND sg13g2_decap_8
XFILLER_106_843 VPWR VGND sg13g2_decap_8
X_22237_ _24107_/D _20217_/Y _22250_/B _22236_/Y VPWR VGND sg13g2_o21ai_1
XFILLER_84_1737 VPWR VGND sg13g2_fill_1
XFILLER_59_44 VPWR VGND sg13g2_fill_1
Xhold4750 _17467_/A _22851_/Q VPWR VGND sg13g2_dlygate4sd3_1
X_22168_ _22168_/Y _22168_/A _22168_/B VPWR VGND sg13g2_nand2_1
Xhold4761 _21775_/A _23888_/Q VPWR VGND sg13g2_dlygate4sd3_1
Xhold4772 _22003_/A _23996_/Q VPWR VGND sg13g2_dlygate4sd3_1
XFILLER_78_226 VPWR VGND sg13g2_fill_2
Xhold4783 _22398_/A _24185_/Q VPWR VGND sg13g2_dlygate4sd3_1
Xhold4794 _21097_/A _23575_/Q VPWR VGND sg13g2_dlygate4sd3_1
XFILLER_82_1461 VPWR VGND sg13g2_decap_8
X_21119_ _21119_/Y _21119_/A _21121_/B VPWR VGND sg13g2_nand2_1
XFILLER_82_1472 VPWR VGND sg13g2_fill_2
X_14990_ _16287_/B _22530_/Q _14990_/B VPWR VGND sg13g2_nand2_1
X_22099_ _24040_/D _24040_/Q _22298_/A0 _22116_/S VPWR VGND sg13g2_mux2_1
XFILLER_93_218 VPWR VGND sg13g2_fill_1
X_13941_ _13941_/Y _13940_/X _20324_/A _14030_/A VPWR VGND sg13g2_nand3b_1
XFILLER_75_933 VPWR VGND sg13g2_decap_8
XFILLER_86_281 VPWR VGND sg13g2_fill_2
X_16660_ _16671_/D _16676_/A _16683_/B VPWR VGND sg13g2_nor2_1
XFILLER_1_1804 VPWR VGND sg13g2_decap_8
XFILLER_74_443 VPWR VGND sg13g2_fill_2
XFILLER_95_1800 VPWR VGND sg13g2_fill_2
X_13872_ _13872_/Y _20260_/A _20271_/A VPWR VGND sg13g2_nand2_1
XFILLER_21_1754 VPWR VGND sg13g2_decap_4
XFILLER_112_1882 VPWR VGND sg13g2_decap_8
X_15611_ _22463_/D _16105_/A _15610_/X _15695_/S VPWR VGND sg13g2_mux2_1
X_12823_ _12823_/X _22563_/Q _13181_/B VPWR VGND sg13g2_or2_1
XFILLER_74_487 VPWR VGND sg13g2_decap_8
XFILLER_76_1210 VPWR VGND sg13g2_fill_2
X_16591_ _16591_/Y _16591_/A _16591_/B VPWR VGND sg13g2_nor2_1
XFILLER_27_370 VPWR VGND sg13g2_decap_8
XFILLER_28_893 VPWR VGND sg13g2_decap_4
XFILLER_74_498 VPWR VGND sg13g2_decap_8
XFILLER_43_830 VPWR VGND sg13g2_decap_4
XFILLER_76_1232 VPWR VGND sg13g2_fill_1
X_18330_ _18330_/Y _18302_/B _18332_/A _18451_/A VPWR VGND sg13g2_o21ai_1
X_12754_ _20039_/A _12843_/A _12757_/B VPWR VGND sg13g2_nand2_1
XFILLER_108_1918 VPWR VGND sg13g2_decap_8
XFILLER_95_1899 VPWR VGND sg13g2_decap_4
XFILLER_70_660 VPWR VGND sg13g2_fill_1
X_11705_ _11716_/A _11705_/A _11705_/B VPWR VGND sg13g2_nor2_1
X_18261_ _18261_/Y _18071_/A _18256_/Y _18260_/Y VPWR VGND sg13g2_a21oi_1
X_15473_ _16073_/A _23005_/Q _22555_/Q _15591_/S VPWR VGND sg13g2_mux2_1
X_12685_ _12686_/C _24034_/Q _24066_/Q _24098_/Q _24130_/Q _11465_/A _12570_/S VPWR
+ VGND sg13g2_mux4_1
XFILLER_106_1631 VPWR VGND sg13g2_decap_4
X_17212_ _17213_/C _17217_/B VPWR VGND sg13g2_inv_1
XFILLER_15_1514 VPWR VGND sg13g2_fill_1
XFILLER_30_546 VPWR VGND sg13g2_decap_8
X_14424_ _14574_/B _19545_/A _17039_/A _17039_/B VPWR VGND sg13g2_nor3_1
XFILLER_54_1574 VPWR VGND sg13g2_decap_8
X_11636_ _11636_/Y _14090_/A _11636_/B _13537_/B VPWR VGND sg13g2_nand3b_1
X_18192_ _18193_/B _18318_/A _18406_/A _18191_/Y VPWR VGND sg13g2_a21oi_1
XFILLER_89_1604 VPWR VGND sg13g2_decap_4
XFILLER_50_1427 VPWR VGND sg13g2_decap_8
X_17143_ _17149_/A _22732_/Q VPWR VGND sg13g2_inv_1
X_11567_ _11567_/Y _11569_/A _14117_/B _11566_/Y VPWR VGND sg13g2_o21ai_1
XFILLER_7_742 VPWR VGND sg13g2_decap_8
XFILLER_89_1659 VPWR VGND sg13g2_decap_4
X_13306_ _13306_/Y _13306_/A _13306_/B VPWR VGND sg13g2_xnor2_1
X_17074_ _17074_/Y _22720_/Q _17074_/B VPWR VGND sg13g2_xnor2_1
X_14286_ _14286_/Y _15300_/A _15165_/C _19401_/B VPWR VGND sg13g2_nor3_1
XFILLER_109_692 VPWR VGND sg13g2_decap_8
XFILLER_48_1301 VPWR VGND sg13g2_decap_8
X_16025_ _16025_/Y _16025_/A _16209_/A VPWR VGND sg13g2_nor2_1
X_13237_ _13237_/Y _13611_/A _13236_/X VPWR VGND sg13g2_nor2b_1
XFILLER_112_824 VPWR VGND sg13g2_decap_8
X_13168_ _13168_/Y _13675_/A1 _13167_/Y _13616_/A VPWR VGND sg13g2_a21oi_1
XFILLER_69_204 VPWR VGND sg13g2_fill_1
X_12119_ _12119_/Y _12119_/A _12119_/B _12119_/C VPWR VGND sg13g2_nand3_1
XFILLER_2_480 VPWR VGND sg13g2_decap_8
X_13099_ _13099_/Y _13087_/Y _13091_/X _13096_/Y _13097_/X _13098_/X VPWR VGND sg13g2_a221oi_1
XFILLER_46_1091 VPWR VGND sg13g2_fill_1
X_19715_ _19715_/Y _19760_/A _19867_/B VPWR VGND sg13g2_nand2_1
X_16927_ _22695_/D _16926_/Y _17113_/A _16927_/S VPWR VGND sg13g2_mux2_1
XFILLER_78_782 VPWR VGND sg13g2_decap_8
XFILLER_26_1676 VPWR VGND sg13g2_decap_4
XFILLER_61_1556 VPWR VGND sg13g2_fill_2
XFILLER_93_730 VPWR VGND sg13g2_decap_8
XFILLER_38_646 VPWR VGND sg13g2_fill_1
X_19646_ _19646_/Y _19714_/S _19646_/B VPWR VGND sg13g2_nor2_1
XFILLER_37_134 VPWR VGND sg13g2_decap_8
XFILLER_37_145 VPWR VGND sg13g2_fill_1
X_16858_ _16860_/C _16858_/A _17044_/A _17044_/B _16858_/D VPWR VGND sg13g2_nor4_1
XFILLER_66_999 VPWR VGND sg13g2_decap_8
XFILLER_20_1253 VPWR VGND sg13g2_fill_1
X_15809_ _15810_/B _22706_/Q _15898_/A2 _15898_/B1 _22642_/Q VPWR VGND sg13g2_a22oi_1
X_19577_ _19577_/Y _20117_/B _19577_/B VPWR VGND sg13g2_nand2_1
XFILLER_94_1310 VPWR VGND sg13g2_decap_4
XFILLER_0_1325 VPWR VGND sg13g2_decap_4
XFILLER_52_115 VPWR VGND sg13g2_decap_8
X_16789_ _16871_/B _16789_/A _16789_/B _16789_/C _17042_/C VPWR VGND sg13g2_nand4_1
XFILLER_18_370 VPWR VGND sg13g2_decap_8
XFILLER_59_1441 VPWR VGND sg13g2_decap_4
XFILLER_20_1275 VPWR VGND sg13g2_fill_2
XFILLER_74_1906 VPWR VGND sg13g2_fill_1
XFILLER_80_457 VPWR VGND sg13g2_decap_8
X_18528_ _18531_/B _18366_/A _18259_/B _18236_/Y VPWR VGND sg13g2_a21oi_1
XFILLER_59_1474 VPWR VGND sg13g2_decap_8
XFILLER_94_1376 VPWR VGND sg13g2_decap_8
XFILLER_61_660 VPWR VGND sg13g2_fill_1
XFILLER_61_693 VPWR VGND sg13g2_decap_8
XFILLER_60_181 VPWR VGND sg13g2_decap_8
Xplace4001 _14129_/C _11386_/Y VPWR VGND sg13g2_buf_1
XFILLER_33_1603 VPWR VGND sg13g2_fill_2
XFILLER_37_1772 VPWR VGND sg13g2_fill_2
XFILLER_60_192 VPWR VGND sg13g2_fill_1
Xplace4012 _13681_/S _12707_/S VPWR VGND sg13g2_buf_4
Xplace4023 _13794_/S _12119_/A VPWR VGND sg13g2_buf_1
XFILLER_21_568 VPWR VGND sg13g2_decap_8
Xplace4034 _14098_/B _11602_/B VPWR VGND sg13g2_buf_1
Xplace4045 _19085_/S _19054_/S VPWR VGND sg13g2_buf_1
Xplace3300 _22412_/A1 _19972_/Y VPWR VGND sg13g2_buf_1
Xplace3311 _20931_/A1 _21299_/A1 VPWR VGND sg13g2_buf_1
Xplace4056 _18462_/S _18446_/S VPWR VGND sg13g2_buf_1
Xplace4067 _18955_/A _18015_/S VPWR VGND sg13g2_buf_1
X_20421_ _20421_/Y _23275_/Q _20429_/B VPWR VGND sg13g2_nand2_1
Xplace3322 _21977_/A1 _20297_/Y VPWR VGND sg13g2_buf_1
Xplace3333 _21969_/A1 _22437_/A1 VPWR VGND sg13g2_buf_1
XFILLER_101_1005 VPWR VGND sg13g2_decap_8
Xplace4078 _19886_/A1 _24213_/Q VPWR VGND sg13g2_buf_1
XFILLER_101_1016 VPWR VGND sg13g2_fill_2
Xplace4089 _20343_/S1 _19884_/A VPWR VGND sg13g2_buf_1
Xplace3344 _22414_/A1 _19997_/Y VPWR VGND sg13g2_buf_1
Xplace3355 _21178_/A1 _19921_/Y VPWR VGND sg13g2_buf_1
XFILLER_107_618 VPWR VGND sg13g2_decap_8
XFILLER_11_1923 VPWR VGND sg13g2_decap_8
X_23140_ _23140_/Q clkload5/A _23140_/D fanout2841/X VPWR VGND sg13g2_dfrbpq_1
Xplace3366 _21303_/A1 _19788_/Y VPWR VGND sg13g2_buf_1
X_20352_ _20352_/Y _20352_/A _20352_/B VPWR VGND sg13g2_nand2_1
Xplace3377 _17923_/B _17930_/B VPWR VGND sg13g2_buf_1
Xplace3388 _17453_/B _17439_/Y VPWR VGND sg13g2_buf_1
XFILLER_88_1169 VPWR VGND sg13g2_decap_8
Xplace3399 _17412_/B _17432_/S VPWR VGND sg13g2_buf_1
X_23071_ _23071_/Q _23114_/CLK _23071_/D fanout2903/X VPWR VGND sg13g2_dfrbpq_1
X_20283_ _23247_/D _20280_/Y _23247_/Q _20283_/S VPWR VGND sg13g2_mux2_1
X_22022_ _24004_/D _22356_/A1 _22025_/B _22021_/Y VPWR VGND sg13g2_o21ai_1
XFILLER_115_684 VPWR VGND sg13g2_decap_8
XFILLER_114_161 VPWR VGND sg13g2_decap_8
XFILLER_88_524 VPWR VGND sg13g2_decap_8
XFILLER_102_323 VPWR VGND sg13g2_decap_8
XFILLER_29_14 VPWR VGND sg13g2_decap_8
XFILLER_102_334 VPWR VGND sg13g2_fill_2
XFILLER_76_708 VPWR VGND sg13g2_fill_2
XFILLER_102_356 VPWR VGND sg13g2_fill_2
XFILLER_5_1203 VPWR VGND sg13g2_decap_8
XFILLER_60_1011 VPWR VGND sg13g2_decap_8
XFILLER_112_1101 VPWR VGND sg13g2_decap_8
XFILLER_102_389 VPWR VGND sg13g2_decap_4
XFILLER_9_1394 VPWR VGND sg13g2_decap_8
XFILLER_40_1618 VPWR VGND sg13g2_decap_8
X_23973_ _23973_/Q clkload39/A _23973_/D fanout2732/X VPWR VGND sg13g2_dfrbpq_1
XFILLER_21_1006 VPWR VGND sg13g2_fill_1
XFILLER_57_944 VPWR VGND sg13g2_fill_2
XFILLER_25_1186 VPWR VGND sg13g2_fill_2
XFILLER_56_432 VPWR VGND sg13g2_decap_8
X_22924_ _22924_/Q clkload9/A _22924_/D fanout2824/X VPWR VGND sg13g2_dfrbpq_1
XFILLER_16_307 VPWR VGND sg13g2_decap_4
XFILLER_71_402 VPWR VGND sg13g2_decap_8
XFILLER_16_318 VPWR VGND sg13g2_decap_8
XFILLER_45_35 VPWR VGND sg13g2_decap_8
XFILLER_83_273 VPWR VGND sg13g2_decap_8
XFILLER_16_329 VPWR VGND sg13g2_fill_1
X_22855_ _22855_/Q clkload18/A _22855_/D fanout2820/X VPWR VGND sg13g2_dfrbpq_1
X_22786_ _22786_/Q clkload25/A _22786_/D fanout2886/X VPWR VGND sg13g2_dfrbpq_1
XFILLER_40_811 VPWR VGND sg13g2_fill_2
XFILLER_101_63 VPWR VGND sg13g2_decap_8
XFILLER_61_34 VPWR VGND sg13g2_decap_4
XFILLER_90_1752 VPWR VGND sg13g2_decap_8
XFILLER_107_1951 VPWR VGND sg13g2_decap_4
XFILLER_8_517 VPWR VGND sg13g2_decap_8
XFILLER_36_1271 VPWR VGND sg13g2_decap_4
X_21668_ _21668_/Y _23847_/Q _21674_/B VPWR VGND sg13g2_nand2_1
XFILLER_61_56 VPWR VGND sg13g2_fill_1
XFILLER_71_1151 VPWR VGND sg13g2_fill_1
XFILLER_16_1856 VPWR VGND sg13g2_decap_8
X_11421_ _11422_/B _24150_/Q _24182_/Q _11762_/B VPWR VGND sg13g2_mux2_1
XFILLER_36_1293 VPWR VGND sg13g2_decap_4
XFILLER_103_1826 VPWR VGND sg13g2_decap_8
X_23407_ _23407_/Q _24205_/CLK _23407_/D fanout2645/X VPWR VGND sg13g2_dfrbpq_1
X_20619_ _23363_/D _20685_/A1 _20638_/B _20618_/Y VPWR VGND sg13g2_o21ai_1
X_21599_ _23814_/D _21960_/A1 _21605_/B _21598_/Y VPWR VGND sg13g2_o21ai_1
X_14140_ _14141_/C _22992_/Q VPWR VGND sg13g2_inv_1
X_11352_ _11355_/A _11352_/A VPWR VGND sg13g2_inv_1
X_23338_ _23338_/Q clkload34/A _23338_/D fanout2696/X VPWR VGND sg13g2_dfrbpq_1
XFILLER_4_723 VPWR VGND sg13g2_decap_8
X_23269_ _23269_/Q clkload33/A _23269_/D fanout2699/X VPWR VGND sg13g2_dfrbpq_1
XFILLER_3_233 VPWR VGND sg13g2_decap_4
XFILLER_3_244 VPWR VGND sg13g2_decap_8
XFILLER_49_1654 VPWR VGND sg13g2_fill_1
X_13022_ _13022_/X _24167_/Q _24199_/Q _23239_/Q _23271_/Q _13555_/S0 _13270_/S1 VPWR
+ VGND sg13g2_mux4_1
XFILLER_106_673 VPWR VGND sg13g2_decap_8
XFILLER_3_266 VPWR VGND sg13g2_decap_8
XFILLER_106_684 VPWR VGND sg13g2_fill_1
XFILLER_106_695 VPWR VGND sg13g2_decap_8
XFILLER_105_161 VPWR VGND sg13g2_decap_8
XFILLER_79_535 VPWR VGND sg13g2_fill_1
XFILLER_79_557 VPWR VGND sg13g2_fill_1
X_17830_ _17855_/A _17838_/A _17838_/B _17932_/B VPWR VGND sg13g2_and3_1
XFILLER_86_31 VPWR VGND sg13g2_fill_1
XFILLER_86_64 VPWR VGND sg13g2_fill_1
XFILLER_86_75 VPWR VGND sg13g2_decap_8
X_17761_ _22900_/D _17789_/B _17759_/Y _17760_/Y VPWR VGND sg13g2_a21oi_1
XFILLER_114_1944 VPWR VGND sg13g2_decap_8
X_14973_ _14973_/Y _14973_/A1 _24228_/Q _14972_/Y VPWR VGND sg13g2_o21ai_1
XFILLER_19_112 VPWR VGND sg13g2_decap_4
XFILLER_59_281 VPWR VGND sg13g2_decap_4
X_16712_ _22657_/D _16063_/A _16711_/A _16711_/Y VPWR VGND sg13g2_a21oi_1
X_13924_ _13924_/Y _23186_/Q _13924_/A2 _13924_/B1 _13923_/X VPWR VGND sg13g2_a22oi_1
XFILLER_47_443 VPWR VGND sg13g2_decap_8
X_17692_ _17692_/Y _17692_/A _17702_/B VPWR VGND sg13g2_nor2_1
XFILLER_48_977 VPWR VGND sg13g2_decap_8
XFILLER_97_1939 VPWR VGND sg13g2_decap_8
XFILLER_19_91 VPWR VGND sg13g2_decap_8
XFILLER_5_1770 VPWR VGND sg13g2_decap_8
XFILLER_19_167 VPWR VGND sg13g2_decap_4
X_19431_ _19431_/Y _13440_/B _19448_/B _19430_/Y VPWR VGND sg13g2_o21ai_1
XFILLER_74_262 VPWR VGND sg13g2_decap_4
X_16643_ _22643_/D _16169_/A _16656_/A _16642_/Y VPWR VGND sg13g2_a21oi_1
XFILLER_90_733 VPWR VGND sg13g2_decap_8
XFILLER_47_498 VPWR VGND sg13g2_fill_1
X_13855_ _13946_/B _13855_/A _13855_/B VPWR VGND sg13g2_nand2_1
XFILLER_34_137 VPWR VGND sg13g2_fill_2
XFILLER_56_1603 VPWR VGND sg13g2_decap_8
X_12806_ _12806_/X _23428_/Q _23460_/Q _23588_/Q _23620_/Q _12809_/A _12906_/A VPWR
+ VGND sg13g2_mux4_1
XFILLER_76_1051 VPWR VGND sg13g2_fill_2
X_13786_ _13786_/X _13796_/B _13786_/B VPWR VGND sg13g2_and2_1
XFILLER_16_874 VPWR VGND sg13g2_decap_8
X_18313_ _18313_/Y _18403_/A _18279_/Y _18312_/X _18279_/A _18443_/A VPWR VGND sg13g2_a221oi_1
X_15525_ _15525_/X _22919_/Q _15552_/B VPWR VGND sg13g2_and2_1
XFILLER_56_1658 VPWR VGND sg13g2_fill_2
X_12737_ _12738_/C _23427_/Q _23491_/Q _23587_/Q _23651_/Q _12733_/S _12982_/S1 VPWR
+ VGND sg13g2_mux4_1
X_19293_ _23210_/D _23210_/Q _20316_/A3 _19303_/S VPWR VGND sg13g2_mux2_1
XFILLER_56_1669 VPWR VGND sg13g2_fill_2
XFILLER_42_170 VPWR VGND sg13g2_fill_2
XFILLER_30_321 VPWR VGND sg13g2_fill_1
XFILLER_34_1912 VPWR VGND sg13g2_decap_4
XFILLER_108_1759 VPWR VGND sg13g2_fill_1
X_18244_ _18244_/X _18406_/A _18144_/A _18385_/A VPWR VGND sg13g2_a21o_1
XFILLER_31_877 VPWR VGND sg13g2_fill_1
XFILLER_54_1360 VPWR VGND sg13g2_decap_8
X_12668_ _12668_/Y _12668_/A _12668_/B _13383_/C VPWR VGND sg13g2_nor3_1
XFILLER_106_1450 VPWR VGND sg13g2_decap_8
XFILLER_30_1809 VPWR VGND sg13g2_fill_2
X_14407_ _14407_/X _14407_/A _14407_/B VPWR VGND sg13g2_or2_2
XFILLER_30_398 VPWR VGND sg13g2_decap_8
X_11619_ _11619_/Y _11634_/A _22978_/Q VPWR VGND sg13g2_nand2_1
XFILLER_102_1325 VPWR VGND sg13g2_fill_2
X_12599_ _12599_/X _24033_/Q _24065_/Q _12813_/S VPWR VGND sg13g2_mux2_1
X_14338_ _15393_/A _19673_/A _19728_/A _15193_/C VPWR VGND sg13g2_nand3_1
XFILLER_7_561 VPWR VGND sg13g2_decap_8
X_14269_ _14270_/B _16856_/A _16856_/B _16856_/C VPWR VGND sg13g2_nor3_1
X_16008_ _16011_/A _16008_/A _16008_/B _16008_/C _16008_/D VPWR VGND sg13g2_nand4_1
XFILLER_98_822 VPWR VGND sg13g2_fill_2
XFILLER_98_833 VPWR VGND sg13g2_fill_2
XFILLER_112_621 VPWR VGND sg13g2_decap_8
XFILLER_98_855 VPWR VGND sg13g2_decap_4
XFILLER_97_332 VPWR VGND sg13g2_decap_8
XFILLER_44_1028 VPWR VGND sg13g2_decap_8
XFILLER_6_1501 VPWR VGND sg13g2_decap_8
XFILLER_26_1440 VPWR VGND sg13g2_fill_1
XFILLER_100_827 VPWR VGND sg13g2_decap_8
XFILLER_25_0 VPWR VGND sg13g2_decap_8
XFILLER_112_698 VPWR VGND sg13g2_decap_8
XFILLER_6_1534 VPWR VGND sg13g2_fill_2
XFILLER_111_175 VPWR VGND sg13g2_decap_8
X_17959_ _17959_/Y _17987_/B _19118_/A1 VPWR VGND sg13g2_nor2b_1
XFILLER_85_549 VPWR VGND sg13g2_decap_8
XFILLER_6_1545 VPWR VGND sg13g2_decap_8
X_20970_ _23529_/D _21336_/A0 _23529_/Q _20990_/B VPWR VGND sg13g2_mux2_1
XFILLER_81_700 VPWR VGND sg13g2_decap_8
XFILLER_93_582 VPWR VGND sg13g2_decap_8
XFILLER_54_936 VPWR VGND sg13g2_fill_2
XFILLER_81_733 VPWR VGND sg13g2_decap_8
XFILLER_20_1050 VPWR VGND sg13g2_fill_2
XFILLER_26_649 VPWR VGND sg13g2_decap_8
XFILLER_78_1861 VPWR VGND sg13g2_fill_1
XFILLER_78_1872 VPWR VGND sg13g2_decap_8
XFILLER_39_1823 VPWR VGND sg13g2_decap_8
X_22640_ _22640_/Q clkload20/A _22640_/D fanout2863/X VPWR VGND sg13g2_dfrbpq_1
XFILLER_78_1883 VPWR VGND sg13g2_fill_2
XFILLER_41_608 VPWR VGND sg13g2_decap_8
XFILLER_74_1714 VPWR VGND sg13g2_decap_8
XFILLER_39_1845 VPWR VGND sg13g2_decap_4
XFILLER_55_1124 VPWR VGND sg13g2_decap_8
XFILLER_80_287 VPWR VGND sg13g2_decap_8
XFILLER_80_298 VPWR VGND sg13g2_fill_2
X_22571_ _22571_/Q _23029_/CLK _22571_/D fanout2836/X VPWR VGND sg13g2_dfrbpq_1
XFILLER_55_1135 VPWR VGND sg13g2_fill_2
XFILLER_21_310 VPWR VGND sg13g2_decap_8
XFILLER_21_343 VPWR VGND sg13g2_decap_8
X_21522_ _21522_/Y _23777_/Q _21530_/B VPWR VGND sg13g2_nand2_1
XFILLER_55_1179 VPWR VGND sg13g2_decap_8
XFILLER_22_877 VPWR VGND sg13g2_decap_8
XFILLER_33_1411 VPWR VGND sg13g2_decap_8
XFILLER_72_1460 VPWR VGND sg13g2_fill_2
XFILLER_21_365 VPWR VGND sg13g2_decap_8
XFILLER_21_387 VPWR VGND sg13g2_decap_8
X_24241_ _24241_/Q clkload27/A _24241_/D fanout2859/X VPWR VGND sg13g2_dfrbpq_1
X_21453_ _23744_/D _21587_/A1 _21456_/B _21452_/Y VPWR VGND sg13g2_o21ai_1
XFILLER_108_905 VPWR VGND sg13g2_fill_2
Xplace3130 _20945_/B _20936_/B VPWR VGND sg13g2_buf_1
Xplace3141 _20918_/S _20902_/S VPWR VGND sg13g2_buf_1
X_20404_ _20404_/Y _23266_/Q _20404_/B VPWR VGND sg13g2_nand2_1
Xplace3152 _20827_/B _20841_/B VPWR VGND sg13g2_buf_1
X_24172_ _24172_/Q _24214_/CLK _24172_/D fanout2629/X VPWR VGND sg13g2_dfrbpq_1
XFILLER_11_1731 VPWR VGND sg13g2_decap_4
Xplace3163 _20704_/B _20713_/B VPWR VGND sg13g2_buf_1
X_21384_ _23711_/D _21946_/A1 _21389_/B _21383_/Y VPWR VGND sg13g2_o21ai_1
XFILLER_107_426 VPWR VGND sg13g2_fill_1
Xplace3174 _20600_/B _20646_/S VPWR VGND sg13g2_buf_1
Xplace3185 _20458_/B _20451_/B VPWR VGND sg13g2_buf_1
XFILLER_102_1870 VPWR VGND sg13g2_decap_8
X_23123_ _23123_/Q _23215_/CLK _23123_/D fanout2911/X VPWR VGND sg13g2_dfrbpq_1
Xplace3196 _20412_/B _20426_/B VPWR VGND sg13g2_buf_1
X_20335_ _20342_/B _20335_/A _20335_/B VPWR VGND sg13g2_nor2_1
XFILLER_11_1764 VPWR VGND sg13g2_fill_1
XFILLER_103_7 VPWR VGND sg13g2_decap_8
XFILLER_1_704 VPWR VGND sg13g2_decap_4
XFILLER_11_1797 VPWR VGND sg13g2_decap_8
X_23054_ _23054_/Q _23215_/CLK _23054_/D fanout2926/X VPWR VGND sg13g2_dfrbpq_1
X_20266_ _20266_/Y _20266_/A1 _20256_/Y _20265_/Y _20266_/B2 VPWR VGND sg13g2_a22oi_1
XFILLER_115_481 VPWR VGND sg13g2_decap_8
XFILLER_1_737 VPWR VGND sg13g2_fill_1
XFILLER_103_632 VPWR VGND sg13g2_decap_8
XFILLER_89_855 VPWR VGND sg13g2_fill_1
XFILLER_81_1729 VPWR VGND sg13g2_fill_1
X_20197_ _20197_/Y _20197_/A _20197_/B VPWR VGND sg13g2_nor2_1
XFILLER_44_1540 VPWR VGND sg13g2_decap_8
XFILLER_103_687 VPWR VGND sg13g2_decap_8
XFILLER_88_387 VPWR VGND sg13g2_fill_2
XFILLER_88_398 VPWR VGND sg13g2_fill_1
XFILLER_29_410 VPWR VGND sg13g2_fill_1
XFILLER_40_1404 VPWR VGND sg13g2_fill_2
XFILLER_102_197 VPWR VGND sg13g2_decap_8
XFILLER_9_1191 VPWR VGND sg13g2_decap_8
XFILLER_44_1584 VPWR VGND sg13g2_decap_8
XFILLER_57_752 VPWR VGND sg13g2_fill_2
XFILLER_5_1055 VPWR VGND sg13g2_decap_8
X_11970_ _11970_/X _23546_/Q _23994_/Q _12004_/S VPWR VGND sg13g2_mux2_1
X_23956_ _23956_/Q _24210_/CLK _23956_/D fanout2624/X VPWR VGND sg13g2_dfrbpq_1
XFILLER_99_1062 VPWR VGND sg13g2_decap_4
XFILLER_2_1932 VPWR VGND sg13g2_decap_8
XFILLER_22_1871 VPWR VGND sg13g2_decap_8
XFILLER_17_638 VPWR VGND sg13g2_fill_2
X_22907_ _22907_/Q clkload9/A _22907_/D fanout2810/X VPWR VGND sg13g2_dfrbpq_1
XFILLER_72_733 VPWR VGND sg13g2_fill_2
X_23887_ _23887_/Q clkload30/A _23887_/D fanout2656/X VPWR VGND sg13g2_dfrbpq_1
XFILLER_60_906 VPWR VGND sg13g2_decap_4
X_13640_ _13641_/B _13638_/X _13639_/X _13640_/S VPWR VGND sg13g2_mux2_1
XFILLER_32_608 VPWR VGND sg13g2_decap_8
XFILLER_57_1923 VPWR VGND sg13g2_decap_8
X_22838_ _22838_/Q _22917_/CLK _22838_/D fanout2872/X VPWR VGND sg13g2_dfrbpq_1
XFILLER_112_84 VPWR VGND sg13g2_decap_8
XFILLER_92_1836 VPWR VGND sg13g2_fill_2
XFILLER_53_980 VPWR VGND sg13g2_fill_2
XFILLER_60_939 VPWR VGND sg13g2_decap_8
XFILLER_92_1847 VPWR VGND sg13g2_decap_8
XFILLER_18_1918 VPWR VGND sg13g2_decap_8
XFILLER_38_1344 VPWR VGND sg13g2_fill_1
XFILLER_25_693 VPWR VGND sg13g2_decap_8
X_13571_ _13602_/A _13651_/A _13571_/B _13571_/C VPWR VGND sg13g2_nand3_1
XFILLER_71_298 VPWR VGND sg13g2_fill_2
XFILLER_12_321 VPWR VGND sg13g2_fill_2
X_22769_ _22769_/Q _22893_/CLK _22769_/D fanout2818/X VPWR VGND sg13g2_dfrbpq_1
XFILLER_12_332 VPWR VGND sg13g2_decap_8
XFILLER_9_815 VPWR VGND sg13g2_fill_1
XFILLER_72_99 VPWR VGND sg13g2_fill_2
X_16290_ _22530_/D _16290_/A _16298_/C VPWR VGND sg13g2_xnor2_1
XFILLER_55_1680 VPWR VGND sg13g2_fill_2
XFILLER_40_685 VPWR VGND sg13g2_decap_8
X_15241_ _17056_/A _15452_/A _15452_/B _15252_/B VPWR VGND sg13g2_and3_1
XFILLER_16_1675 VPWR VGND sg13g2_decap_8
X_12453_ _12453_/X _23904_/Q _24000_/Q _12453_/S VPWR VGND sg13g2_mux2_1
XFILLER_16_1686 VPWR VGND sg13g2_fill_1
X_11404_ _11407_/A _12039_/A _11427_/B VPWR VGND sg13g2_nand2_2
X_15172_ _16774_/A _15172_/A _15172_/B VPWR VGND sg13g2_and2_1
XFILLER_51_1599 VPWR VGND sg13g2_decap_8
X_12384_ _12385_/D _12381_/Y _12383_/Y _13028_/B VPWR VGND sg13g2_a21oi_1
X_14123_ _14127_/B _14120_/Y _14121_/Y _14122_/Y VPWR VGND sg13g2_a21o_1
X_19980_ _19980_/Y _19983_/A _19980_/B _20085_/B VPWR VGND sg13g2_nor3_1
XFILLER_113_407 VPWR VGND sg13g2_decap_8
XFILLER_4_553 VPWR VGND sg13g2_decap_8
XFILLER_49_1440 VPWR VGND sg13g2_decap_8
X_18931_ _18931_/Y _19041_/A _18931_/B _18931_/C VPWR VGND sg13g2_nand3_1
XFILLER_10_1285 VPWR VGND sg13g2_fill_1
XFILLER_4_586 VPWR VGND sg13g2_fill_2
X_14054_ _14055_/B _14056_/A _14054_/B VPWR VGND sg13g2_xnor2_1
XFILLER_84_1353 VPWR VGND sg13g2_fill_2
XFILLER_84_1364 VPWR VGND sg13g2_decap_8
XFILLER_97_63 VPWR VGND sg13g2_decap_8
X_13005_ _13005_/X _23846_/Q _23878_/Q _23942_/Q _23974_/Q _12809_/A _13243_/S1 VPWR
+ VGND sg13g2_mux4_1
XFILLER_84_1386 VPWR VGND sg13g2_fill_1
XFILLER_80_1217 VPWR VGND sg13g2_decap_8
X_18862_ _18864_/B _18860_/Y _18861_/Y _18868_/S VPWR VGND sg13g2_mux2_1
XFILLER_45_1337 VPWR VGND sg13g2_decap_8
XFILLER_84_1397 VPWR VGND sg13g2_decap_4
XFILLER_45_1348 VPWR VGND sg13g2_decap_8
X_17813_ _17814_/B _22577_/Q _17820_/C VPWR VGND sg13g2_nand2_1
X_18793_ _18794_/C _23065_/Q _18793_/B VPWR VGND sg13g2_nand2_1
XFILLER_94_346 VPWR VGND sg13g2_fill_2
XFILLER_43_1061 VPWR VGND sg13g2_decap_8
XFILLER_7_1876 VPWR VGND sg13g2_decap_8
XFILLER_23_1646 VPWR VGND sg13g2_decap_8
XFILLER_110_1605 VPWR VGND sg13g2_decap_8
XFILLER_82_508 VPWR VGND sg13g2_decap_4
X_17744_ _17744_/Y _22898_/Q _17811_/B VPWR VGND sg13g2_nor2_1
XFILLER_3_1729 VPWR VGND sg13g2_decap_8
XFILLER_48_763 VPWR VGND sg13g2_decap_8
X_14956_ _14956_/Y _14956_/A _14956_/B _14956_/C VPWR VGND sg13g2_nand3_1
XFILLER_97_1725 VPWR VGND sg13g2_fill_2
XFILLER_78_1124 VPWR VGND sg13g2_fill_2
XFILLER_47_262 VPWR VGND sg13g2_decap_4
XFILLER_36_947 VPWR VGND sg13g2_fill_2
X_17675_ _17694_/C _22560_/Q _17675_/B VPWR VGND sg13g2_and2_1
X_14887_ _14887_/Y _22490_/Q _14912_/B _15103_/B1 _22918_/Q VPWR VGND sg13g2_a22oi_1
XFILLER_36_969 VPWR VGND sg13g2_decap_8
X_19414_ _19414_/Y _20147_/B _19430_/B VPWR VGND sg13g2_nor2_1
XFILLER_1_1453 VPWR VGND sg13g2_fill_1
XFILLER_1_1464 VPWR VGND sg13g2_fill_1
X_16626_ _16626_/Y _16626_/A _16626_/B VPWR VGND sg13g2_nor2_1
XFILLER_90_563 VPWR VGND sg13g2_decap_4
X_13838_ _13838_/X _13832_/X _13835_/Y _13836_/X _13837_/X _18444_/A1 _13960_/S1 VPWR
+ VGND sg13g2_mux4_1
XFILLER_22_107 VPWR VGND sg13g2_decap_8
XFILLER_51_939 VPWR VGND sg13g2_fill_2
XFILLER_90_585 VPWR VGND sg13g2_fill_1
XFILLER_16_671 VPWR VGND sg13g2_fill_1
X_19345_ _19379_/B _19360_/A _19582_/A VPWR VGND sg13g2_nor2_1
XFILLER_91_1324 VPWR VGND sg13g2_decap_8
X_16557_ _16557_/Y _16561_/A _16557_/B VPWR VGND sg13g2_nor2_1
XFILLER_22_129 VPWR VGND sg13g2_decap_8
XFILLER_56_1455 VPWR VGND sg13g2_decap_4
XFILLER_108_1523 VPWR VGND sg13g2_fill_1
X_13769_ _13770_/B _24049_/Q _24081_/Q _24113_/Q _24145_/Q _13773_/S0 _13911_/B2 VPWR
+ VGND sg13g2_mux4_1
XFILLER_56_1477 VPWR VGND sg13g2_decap_8
X_15508_ _15509_/C _16852_/B _15508_/B VPWR VGND sg13g2_nor2_1
X_19276_ _19300_/S _23189_/Q _19276_/B VPWR VGND sg13g2_nor2_1
X_16488_ _22606_/D _16142_/A _16512_/B _16487_/Y VPWR VGND sg13g2_o21ai_1
XFILLER_73_1780 VPWR VGND sg13g2_decap_8
XFILLER_50_1010 VPWR VGND sg13g2_decap_4
X_18227_ _18227_/Y _18297_/A _18225_/Y _18226_/Y VPWR VGND sg13g2_o21ai_1
X_15439_ _17080_/A _17394_/A VPWR VGND sg13g2_inv_1
XFILLER_30_1617 VPWR VGND sg13g2_fill_2
XFILLER_34_1786 VPWR VGND sg13g2_decap_8
XFILLER_89_1231 VPWR VGND sg13g2_decap_8
XFILLER_8_870 VPWR VGND sg13g2_decap_8
XFILLER_69_1805 VPWR VGND sg13g2_decap_4
X_18158_ _18162_/A _18560_/S _17939_/X _17942_/Y VPWR VGND sg13g2_a21o_1
XFILLER_8_881 VPWR VGND sg13g2_fill_1
XFILLER_50_1098 VPWR VGND sg13g2_decap_8
XFILLER_69_1838 VPWR VGND sg13g2_fill_2
X_17109_ _17110_/A _22726_/Q VPWR VGND sg13g2_inv_1
XFILLER_7_94 VPWR VGND sg13g2_fill_2
XFILLER_89_1297 VPWR VGND sg13g2_fill_1
X_18089_ _18089_/Y _18030_/A _18088_/X _14470_/B VPWR VGND sg13g2_a21oi_1
X_20120_ _20122_/B _20120_/A _20120_/B VPWR VGND sg13g2_nand2_1
XFILLER_104_429 VPWR VGND sg13g2_fill_1
XFILLER_98_630 VPWR VGND sg13g2_decap_8
XFILLER_98_652 VPWR VGND sg13g2_fill_2
XFILLER_113_985 VPWR VGND sg13g2_decap_8
XFILLER_100_602 VPWR VGND sg13g2_decap_8
XFILLER_115_1538 VPWR VGND sg13g2_decap_8
XFILLER_97_162 VPWR VGND sg13g2_decap_8
XFILLER_86_847 VPWR VGND sg13g2_fill_1
XFILLER_6_1320 VPWR VGND sg13g2_fill_2
XFILLER_112_495 VPWR VGND sg13g2_decap_8
XFILLER_100_646 VPWR VGND sg13g2_fill_2
XFILLER_85_346 VPWR VGND sg13g2_fill_2
XFILLER_39_730 VPWR VGND sg13g2_fill_1
XFILLER_26_1281 VPWR VGND sg13g2_decap_8
XFILLER_22_1123 VPWR VGND sg13g2_decap_8
X_23810_ _23810_/Q clkload39/A _23810_/D fanout2740/X VPWR VGND sg13g2_dfrbpq_1
XFILLER_6_1386 VPWR VGND sg13g2_decap_8
XFILLER_54_700 VPWR VGND sg13g2_fill_1
XFILLER_113_1273 VPWR VGND sg13g2_fill_2
XFILLER_6_1397 VPWR VGND sg13g2_decap_8
XFILLER_38_262 VPWR VGND sg13g2_fill_1
X_23741_ _23741_/Q clkload59/A _23741_/D fanout2789/X VPWR VGND sg13g2_dfrbpq_1
XFILLER_22_1178 VPWR VGND sg13g2_decap_8
X_20953_ _23521_/D _21321_/A1 _20954_/B _20952_/Y VPWR VGND sg13g2_o21ai_1
XFILLER_27_947 VPWR VGND sg13g2_decap_8
XFILLER_26_435 VPWR VGND sg13g2_fill_1
XFILLER_38_295 VPWR VGND sg13g2_decap_4
XFILLER_26_48 VPWR VGND sg13g2_decap_8
XFILLER_26_59 VPWR VGND sg13g2_fill_1
XFILLER_53_243 VPWR VGND sg13g2_decap_8
XFILLER_26_468 VPWR VGND sg13g2_fill_1
XFILLER_39_1620 VPWR VGND sg13g2_fill_1
X_23672_ _23672_/Q clkload57/A _23672_/D fanout2764/X VPWR VGND sg13g2_dfrbpq_1
X_20884_ _20884_/Y _23488_/Q _20888_/B VPWR VGND sg13g2_nand2_1
X_22623_ _22623_/Q clkload24/A _22623_/D fanout2899/X VPWR VGND sg13g2_dfrbpq_1
XFILLER_53_298 VPWR VGND sg13g2_fill_1
XFILLER_107_1022 VPWR VGND sg13g2_decap_8
XFILLER_35_1528 VPWR VGND sg13g2_decap_8
XFILLER_107_1033 VPWR VGND sg13g2_fill_2
X_22554_ _22554_/Q clkload26/A _22554_/D fanout2852/X VPWR VGND sg13g2_dfrbpq_1
XFILLER_42_36 VPWR VGND sg13g2_decap_8
XFILLER_74_1599 VPWR VGND sg13g2_decap_4
XFILLER_42_58 VPWR VGND sg13g2_fill_2
X_21505_ _23769_/D _21932_/A1 _21515_/B _21504_/Y VPWR VGND sg13g2_o21ai_1
XFILLER_13_1815 VPWR VGND sg13g2_decap_8
X_22485_ _22485_/Q clkload18/A _22485_/D fanout2830/X VPWR VGND sg13g2_dfrbpq_1
XFILLER_104_1943 VPWR VGND sg13g2_decap_8
XFILLER_104_1954 VPWR VGND sg13g2_fill_1
XFILLER_33_1274 VPWR VGND sg13g2_fill_2
X_24224_ _24224_/Q clkload15/A _24224_/D fanout2852/X VPWR VGND sg13g2_dfrbpq_1
XFILLER_108_735 VPWR VGND sg13g2_decap_8
XFILLER_100_1818 VPWR VGND sg13g2_decap_4
X_24155_ _24155_/Q clkload44/A _24155_/D fanout2753/X VPWR VGND sg13g2_dfrbpq_1
X_21367_ _21367_/Y _21367_/A _21367_/B VPWR VGND sg13g2_nand2_1
X_23106_ _23106_/Q _23114_/CLK _23106_/D fanout2906/X VPWR VGND sg13g2_dfrbpq_1
X_20318_ _20328_/A _24274_/A _20318_/B VPWR VGND sg13g2_nand2_1
X_24086_ _24086_/Q clkload46/A _24086_/D fanout2676/X VPWR VGND sg13g2_dfrbpq_1
X_21298_ _21298_/Y _21298_/A _21349_/S VPWR VGND sg13g2_nand2_1
XFILLER_89_630 VPWR VGND sg13g2_decap_8
X_23037_ _23037_/Q clkload13/A _23037_/D fanout2908/X VPWR VGND sg13g2_dfrbpq_1
X_20249_ _20249_/X _20249_/A0 _20249_/A1 _20249_/A2 _20249_/A3 _19505_/A _19501_/A
+ VPWR VGND sg13g2_mux4_1
XFILLER_67_11 VPWR VGND sg13g2_fill_1
XFILLER_104_974 VPWR VGND sg13g2_fill_1
XFILLER_7_1106 VPWR VGND sg13g2_decap_8
XFILLER_107_84 VPWR VGND sg13g2_decap_8
XFILLER_103_462 VPWR VGND sg13g2_decap_4
XFILLER_88_162 VPWR VGND sg13g2_decap_4
XFILLER_67_33 VPWR VGND sg13g2_decap_8
XFILLER_88_173 VPWR VGND sg13g2_fill_2
XFILLER_49_538 VPWR VGND sg13g2_fill_2
XFILLER_67_55 VPWR VGND sg13g2_decap_8
XFILLER_24_1933 VPWR VGND sg13g2_decap_8
XFILLER_27_1089 VPWR VGND sg13g2_fill_2
X_14810_ _14811_/B _14809_/Y _14213_/A _14207_/B VPWR VGND sg13g2_o21ai_1
X_15790_ _15791_/A _22705_/Q _15946_/A2 _15946_/B1 _22641_/Q VPWR VGND sg13g2_a22oi_1
XFILLER_91_305 VPWR VGND sg13g2_decap_8
XFILLER_85_891 VPWR VGND sg13g2_fill_2
X_11953_ _11963_/A _11953_/A _11953_/B VPWR VGND sg13g2_nand2_1
XFILLER_91_349 VPWR VGND sg13g2_decap_8
X_23939_ _23939_/Q clkload40/A _23939_/D fanout2731/X VPWR VGND sg13g2_dfrbpq_1
XFILLER_83_43 VPWR VGND sg13g2_decap_8
XFILLER_18_969 VPWR VGND sg13g2_fill_1
XFILLER_83_54 VPWR VGND sg13g2_fill_2
X_17460_ _17460_/Y _17460_/A _17462_/B VPWR VGND sg13g2_nand2_1
XFILLER_17_468 VPWR VGND sg13g2_fill_1
X_14672_ _14672_/Y _14672_/A _14701_/B VPWR VGND sg13g2_nand2_1
X_11884_ _11887_/C _14038_/A _14038_/B _11883_/Y VPWR VGND sg13g2_o21ai_1
XFILLER_17_479 VPWR VGND sg13g2_fill_1
XFILLER_32_405 VPWR VGND sg13g2_decap_4
XFILLER_60_714 VPWR VGND sg13g2_fill_2
X_16411_ _16411_/Y _22572_/Q _18697_/A VPWR VGND sg13g2_nand2_1
X_13623_ _13624_/B _13675_/A1 _13618_/Y _13620_/Y _13675_/B2 _13622_/Y VPWR VGND sg13g2_a221oi_1
XFILLER_57_1753 VPWR VGND sg13g2_decap_8
X_17391_ _17391_/Y _17391_/A _17391_/B _17391_/C VPWR VGND sg13g2_nor3_1
XFILLER_41_950 VPWR VGND sg13g2_decap_4
X_19130_ _23107_/D _23107_/Q _18856_/A _19130_/S VPWR VGND sg13g2_mux2_1
X_16342_ _16342_/Y _22910_/Q VPWR VGND sg13g2_inv_1
XFILLER_109_1876 VPWR VGND sg13g2_decap_8
XFILLER_92_1688 VPWR VGND sg13g2_fill_2
X_13554_ _13554_/X _24174_/Q _24206_/Q _23246_/Q _23278_/Q _13555_/S0 _13016_/S VPWR
+ VGND sg13g2_mux4_1
XFILLER_13_685 VPWR VGND sg13g2_fill_1
XFILLER_34_1049 VPWR VGND sg13g2_decap_8
X_19061_ _23067_/D _23067_/Q _19060_/X _19061_/S VPWR VGND sg13g2_mux2_1
XFILLER_40_482 VPWR VGND sg13g2_decap_8
X_12505_ _12505_/Y _12505_/A _12505_/B _12505_/C _12505_/D VPWR VGND sg13g2_nor4_2
X_16273_ _16289_/A _16320_/A _16320_/B _16273_/C _16273_/D VPWR VGND sg13g2_nand4_1
XFILLER_90_1390 VPWR VGND sg13g2_decap_4
X_13485_ _13494_/C _13616_/A _13485_/B VPWR VGND sg13g2_nor2_1
XFILLER_51_1352 VPWR VGND sg13g2_decap_4
X_18012_ _18539_/B _18538_/S _18008_/X _18011_/Y VPWR VGND sg13g2_a21oi_1
X_15224_ _16871_/A _15307_/B VPWR VGND sg13g2_inv_1
XFILLER_32_80 VPWR VGND sg13g2_fill_1
X_12436_ _12436_/Y _12436_/A _12436_/B VPWR VGND sg13g2_nor2_1
X_15155_ _17034_/C _15178_/B _16852_/A VPWR VGND sg13g2_or2_1
X_12367_ _12370_/C _12772_/B _12367_/B VPWR VGND sg13g2_nor2_1
XFILLER_5_873 VPWR VGND sg13g2_decap_8
XFILLER_29_1800 VPWR VGND sg13g2_decap_8
XFILLER_10_1060 VPWR VGND sg13g2_fill_1
XFILLER_29_1811 VPWR VGND sg13g2_fill_1
X_14106_ _14107_/C _19320_/A _19608_/A VPWR VGND sg13g2_or2_1
X_12298_ _12298_/X _12298_/A _12298_/B VPWR VGND sg13g2_or2_1
X_19963_ _19965_/C _20062_/B _19960_/Y _19962_/Y VPWR VGND sg13g2_a21oi_1
X_15086_ _15086_/Y _15086_/A _15086_/B VPWR VGND sg13g2_nand2_1
XFILLER_68_1893 VPWR VGND sg13g2_decap_8
XFILLER_113_259 VPWR VGND sg13g2_decap_4
X_14037_ _14049_/B _14025_/Y _14029_/Y _14036_/Y VPWR VGND sg13g2_a21o_1
XFILLER_84_1172 VPWR VGND sg13g2_decap_8
X_18914_ _18914_/Y _18955_/A _18914_/B _18914_/C VPWR VGND sg13g2_nand3b_1
XFILLER_9_1927 VPWR VGND sg13g2_decap_8
XFILLER_49_1292 VPWR VGND sg13g2_decap_4
X_11249_ _11249_/X _11250_/A _19235_/B VPWR VGND sg13g2_or2_1
X_19894_ _19894_/Y _19894_/A _19950_/B VPWR VGND sg13g2_nand2_1
XFILLER_68_825 VPWR VGND sg13g2_decap_4
X_18845_ _18850_/A _23042_/Q _18865_/B _18865_/C VPWR VGND sg13g2_nand3_1
XFILLER_95_644 VPWR VGND sg13g2_fill_2
XFILLER_3_1504 VPWR VGND sg13g2_decap_8
XFILLER_110_988 VPWR VGND sg13g2_decap_8
X_18776_ _23030_/D _18776_/A _18776_/B _18776_/C VPWR VGND sg13g2_nand3_1
X_15988_ _15988_/Y _15988_/A VPWR VGND sg13g2_inv_1
XFILLER_55_519 VPWR VGND sg13g2_decap_8
XFILLER_95_699 VPWR VGND sg13g2_decap_8
Xclkbuf_4_9__f_clk_i clkbuf_4_9__f_clk_i/X clkbuf_3_4_0_clk_i/X VPWR VGND sg13g2_buf_8
X_17727_ _17727_/Y _17153_/A _17824_/A2 _17824_/B1 _17726_/Y VPWR VGND sg13g2_a22oi_1
XFILLER_23_1487 VPWR VGND sg13g2_decap_8
X_14939_ _14940_/A _14949_/A _14939_/B _14939_/C _14939_/D VPWR VGND sg13g2_nand4_1
XFILLER_110_1446 VPWR VGND sg13g2_decap_8
XFILLER_24_917 VPWR VGND sg13g2_fill_1
X_17658_ _17658_/Y _17710_/A1 _17655_/Y _17657_/Y VPWR VGND sg13g2_o21ai_1
XFILLER_50_202 VPWR VGND sg13g2_fill_2
XFILLER_90_382 VPWR VGND sg13g2_decap_4
X_16609_ _16610_/B _22637_/Q _16609_/B VPWR VGND sg13g2_xnor2_1
XFILLER_35_298 VPWR VGND sg13g2_decap_8
XFILLER_56_1230 VPWR VGND sg13g2_fill_1
XFILLER_36_1815 VPWR VGND sg13g2_decap_8
X_17589_ _22882_/D _22882_/Q _17588_/Y _17631_/B VPWR VGND sg13g2_mux2_1
XFILLER_108_1331 VPWR VGND sg13g2_fill_1
XFILLER_92_0 VPWR VGND sg13g2_decap_8
XFILLER_32_950 VPWR VGND sg13g2_decap_4
XFILLER_56_1263 VPWR VGND sg13g2_decap_8
XFILLER_32_983 VPWR VGND sg13g2_decap_8
XFILLER_91_1198 VPWR VGND sg13g2_fill_2
XFILLER_17_1269 VPWR VGND sg13g2_fill_1
XFILLER_52_1149 VPWR VGND sg13g2_decap_8
X_19259_ _19259_/Y _19256_/Y _19240_/X _19257_/Y _19258_/Y VPWR VGND sg13g2_a22oi_1
XFILLER_12_28 VPWR VGND sg13g2_decap_8
X_22270_ _24123_/D _22270_/A1 _22269_/B _22269_/Y VPWR VGND sg13g2_o21ai_1
Xoutput4476 data_addr_o[18] _24263_/X VPWR VGND sg13g2_buf_1
Xoutput4487 data_addr_o[29] _24274_/X VPWR VGND sg13g2_buf_1
X_21221_ _21221_/Y _21221_/A _21221_/B VPWR VGND sg13g2_nand2_1
Xoutput4498 data_be_o[0] _14622_/X VPWR VGND sg13g2_buf_1
XFILLER_69_1646 VPWR VGND sg13g2_fill_2
XFILLER_69_1679 VPWR VGND sg13g2_decap_8
XFILLER_105_738 VPWR VGND sg13g2_decap_8
X_21152_ _23602_/D _21619_/A1 _21151_/B _21151_/Y VPWR VGND sg13g2_o21ai_1
XFILLER_82_1824 VPWR VGND sg13g2_decap_8
XFILLER_67_1381 VPWR VGND sg13g2_decap_8
X_21083_ _23571_/D _13894_/Y _21082_/B _21082_/Y VPWR VGND sg13g2_o21ai_1
XFILLER_99_983 VPWR VGND sg13g2_decap_8
XFILLER_113_771 VPWR VGND sg13g2_decap_8
XFILLER_101_922 VPWR VGND sg13g2_decap_8
XFILLER_58_302 VPWR VGND sg13g2_decap_8
XFILLER_63_1256 VPWR VGND sg13g2_decap_8
X_20034_ _20034_/Y _20034_/A _20035_/B VPWR VGND sg13g2_nor2_1
XFILLER_115_1346 VPWR VGND sg13g2_decap_8
XFILLER_58_335 VPWR VGND sg13g2_decap_4
XFILLER_100_443 VPWR VGND sg13g2_fill_1
XFILLER_115_1379 VPWR VGND sg13g2_decap_8
XFILLER_86_677 VPWR VGND sg13g2_decap_4
XFILLER_85_165 VPWR VGND sg13g2_decap_8
XFILLER_6_1161 VPWR VGND sg13g2_decap_8
XFILLER_100_476 VPWR VGND sg13g2_decap_8
XFILLER_6_1172 VPWR VGND sg13g2_fill_1
XFILLER_2_1003 VPWR VGND sg13g2_fill_1
XFILLER_37_47 VPWR VGND sg13g2_fill_2
XFILLER_74_839 VPWR VGND sg13g2_decap_8
XFILLER_2_1014 VPWR VGND sg13g2_decap_4
XFILLER_37_58 VPWR VGND sg13g2_fill_2
XFILLER_39_571 VPWR VGND sg13g2_fill_2
XFILLER_113_1070 VPWR VGND sg13g2_decap_4
XFILLER_6_1183 VPWR VGND sg13g2_decap_8
XFILLER_41_1576 VPWR VGND sg13g2_decap_8
XFILLER_96_1021 VPWR VGND sg13g2_decap_8
XFILLER_73_349 VPWR VGND sg13g2_fill_2
XFILLER_15_906 VPWR VGND sg13g2_decap_8
XFILLER_54_552 VPWR VGND sg13g2_decap_8
X_23724_ _23724_/Q clkload49/A _23724_/D fanout2674/X VPWR VGND sg13g2_dfrbpq_1
X_20936_ _20936_/Y _20936_/A _20936_/B VPWR VGND sg13g2_nand2_1
XFILLER_93_1920 VPWR VGND sg13g2_decap_8
XFILLER_15_939 VPWR VGND sg13g2_decap_8
XFILLER_27_799 VPWR VGND sg13g2_fill_2
XFILLER_82_894 VPWR VGND sg13g2_decap_8
XFILLER_14_438 VPWR VGND sg13g2_fill_1
X_20867_ _23480_/D _22396_/A1 _20874_/B _20866_/Y VPWR VGND sg13g2_o21ai_1
X_23655_ _23655_/Q _24170_/CLK _23655_/D fanout2698/X VPWR VGND sg13g2_dfrbpq_1
XFILLER_53_46 VPWR VGND sg13g2_decap_4
XFILLER_23_950 VPWR VGND sg13g2_decap_4
XFILLER_35_1303 VPWR VGND sg13g2_decap_8
X_22606_ _22606_/Q clkload8/A _22606_/D fanout2798/X VPWR VGND sg13g2_dfrbpq_1
X_23586_ _23586_/Q _23682_/CLK _23586_/D fanout2726/X VPWR VGND sg13g2_dfrbpq_1
XFILLER_70_1238 VPWR VGND sg13g2_decap_8
X_22537_ _22537_/Q clkload6/A _22537_/D fanout2832/X VPWR VGND sg13g2_dfrbpq_1
XFILLER_104_1740 VPWR VGND sg13g2_decap_4
XFILLER_52_1672 VPWR VGND sg13g2_decap_8
XFILLER_108_510 VPWR VGND sg13g2_decap_8
XFILLER_104_1762 VPWR VGND sg13g2_fill_2
X_13270_ _13270_/X _24170_/Q _24202_/Q _23242_/Q _23274_/Q _13555_/S0 _13270_/S1 VPWR
+ VGND sg13g2_mux4_1
XFILLER_100_1604 VPWR VGND sg13g2_decap_4
X_22468_ _22468_/Q clkload9/A _22468_/D fanout2823/X VPWR VGND sg13g2_dfrbpq_1
X_24207_ _24207_/Q clkload32/A _24207_/D fanout2648/X VPWR VGND sg13g2_dfrbpq_1
XFILLER_68_1112 VPWR VGND sg13g2_decap_8
X_21419_ _21419_/Y _23730_/Q _21422_/B VPWR VGND sg13g2_nand2_1
X_22399_ _24185_/D _19788_/Y _22408_/B _22398_/Y VPWR VGND sg13g2_o21ai_1
XFILLER_108_587 VPWR VGND sg13g2_decap_8
X_12152_ _12350_/B _14341_/B _14296_/A2 _12151_/Y VPWR VGND sg13g2_a21oi_1
XFILLER_2_821 VPWR VGND sg13g2_fill_1
XFILLER_29_1118 VPWR VGND sg13g2_decap_8
X_24138_ _24138_/Q clkload37/A _24138_/D fanout2710/X VPWR VGND sg13g2_dfrbpq_1
XFILLER_2_832 VPWR VGND sg13g2_fill_2
XFILLER_97_909 VPWR VGND sg13g2_decap_8
Xfanout2802 fanout2802/X fanout2805/X VPWR VGND sg13g2_buf_1
Xfanout2813 fanout2813/X fanout2815/X VPWR VGND sg13g2_buf_1
Xfanout2824 fanout2824/X fanout2826/X VPWR VGND sg13g2_buf_1
XFILLER_78_65 VPWR VGND sg13g2_decap_8
Xfanout2835 fanout2835/X fanout2849/X VPWR VGND sg13g2_buf_1
XFILLER_1_342 VPWR VGND sg13g2_fill_2
XFILLER_104_760 VPWR VGND sg13g2_decap_8
Xfanout2846 fanout2846/X fanout2848/X VPWR VGND sg13g2_buf_1
X_24069_ _24069_/Q clkload45/A _24069_/D fanout2714/X VPWR VGND sg13g2_dfrbpq_1
XFILLER_77_600 VPWR VGND sg13g2_decap_4
Xfanout2857 fanout2857/X fanout2860/X VPWR VGND sg13g2_buf_1
XFILLER_46_1465 VPWR VGND sg13g2_decap_8
XFILLER_81_1356 VPWR VGND sg13g2_decap_8
Xfanout2868 fanout2868/X fanout2869/X VPWR VGND sg13g2_buf_1
X_15911_ _15911_/Y _23024_/Q VPWR VGND sg13g2_inv_1
XFILLER_77_622 VPWR VGND sg13g2_decap_8
Xfanout2879 fanout2879/X fanout2882/X VPWR VGND sg13g2_buf_1
XFILLER_49_324 VPWR VGND sg13g2_decap_8
X_16891_ _22688_/D _16895_/S _16889_/Y _16890_/Y VPWR VGND sg13g2_o21ai_1
XFILLER_76_121 VPWR VGND sg13g2_decap_4
XFILLER_4_1802 VPWR VGND sg13g2_decap_8
XFILLER_76_132 VPWR VGND sg13g2_decap_8
X_18630_ _18633_/B _18742_/A _18630_/B _18637_/B VPWR VGND sg13g2_nand3_1
XFILLER_49_357 VPWR VGND sg13g2_decap_8
XFILLER_76_143 VPWR VGND sg13g2_decap_8
X_15842_ _15842_/Y _22474_/Q _15935_/S VPWR VGND sg13g2_nand2b_1
XFILLER_91_102 VPWR VGND sg13g2_fill_2
XFILLER_18_711 VPWR VGND sg13g2_decap_8
XFILLER_24_1774 VPWR VGND sg13g2_fill_2
X_18561_ _18561_/Y _18539_/B _18560_/X _18479_/X VPWR VGND sg13g2_o21ai_1
XFILLER_18_733 VPWR VGND sg13g2_decap_4
X_15773_ _15774_/C _15773_/A _15773_/B _15773_/C _15773_/D VPWR VGND sg13g2_nand4_1
X_12985_ _12985_/X _24166_/Q _24198_/Q _23238_/Q _23270_/Q _12983_/A _12986_/S1 VPWR
+ VGND sg13g2_mux4_1
XFILLER_4_1879 VPWR VGND sg13g2_decap_8
XFILLER_18_766 VPWR VGND sg13g2_decap_8
X_17512_ _17514_/A _17147_/A _22873_/Q _17512_/S VPWR VGND sg13g2_mux2_1
XFILLER_73_861 VPWR VGND sg13g2_fill_1
X_14724_ _14724_/X _14646_/Y _14643_/Y _14728_/S VPWR VGND sg13g2_mux2_1
XFILLER_33_703 VPWR VGND sg13g2_decap_8
X_18492_ _18494_/B _18538_/S _18008_/X _18491_/X VPWR VGND sg13g2_o21ai_1
XFILLER_33_714 VPWR VGND sg13g2_fill_2
X_17443_ _17443_/Y _17443_/A _17453_/B VPWR VGND sg13g2_nand2_1
XFILLER_60_522 VPWR VGND sg13g2_decap_8
X_14655_ _14655_/Y _14653_/X _14714_/A2 _14654_/Y VPWR VGND sg13g2_a21oi_1
XFILLER_57_1550 VPWR VGND sg13g2_decap_8
X_11867_ _14038_/A _11867_/A _11867_/B _11867_/C _11867_/D VPWR VGND sg13g2_and4_1
XFILLER_32_235 VPWR VGND sg13g2_decap_8
XFILLER_33_769 VPWR VGND sg13g2_decap_8
XFILLER_57_1561 VPWR VGND sg13g2_fill_2
XFILLER_109_1651 VPWR VGND sg13g2_fill_1
X_13606_ _13607_/B _23727_/Q _23759_/Q _23791_/Q _23823_/Q _13606_/S0 _13606_/S1 VPWR
+ VGND sg13g2_mux4_1
XFILLER_53_1414 VPWR VGND sg13g2_decap_8
XFILLER_18_1556 VPWR VGND sg13g2_decap_8
XFILLER_14_983 VPWR VGND sg13g2_decap_8
X_14586_ _19253_/A _23192_/Q _19241_/A VPWR VGND sg13g2_nor2_1
X_11798_ _11803_/B _12475_/A _11798_/B VPWR VGND sg13g2_nor2_1
X_19113_ _23092_/D _23092_/Q _19112_/X _19115_/S VPWR VGND sg13g2_mux2_1
Xrebuffer5409 _14342_/C _11935_/Y VPWR VGND sg13g2_buf_2
XFILLER_13_482 VPWR VGND sg13g2_decap_8
X_16325_ _22540_/D _16325_/A _16331_/B VPWR VGND sg13g2_xor2_1
X_13537_ _13537_/X _19489_/A _13537_/B VPWR VGND sg13g2_and2_1
Xplace3707 _20091_/B _20286_/B VPWR VGND sg13g2_buf_1
XFILLER_9_453 VPWR VGND sg13g2_decap_8
XFILLER_31_1701 VPWR VGND sg13g2_decap_8
XFILLER_70_1750 VPWR VGND sg13g2_decap_8
Xplace3718 _15447_/A _12418_/B VPWR VGND sg13g2_buf_2
XFILLER_70_1761 VPWR VGND sg13g2_fill_2
Xplace3729 _14026_/A place3729/A VPWR VGND sg13g2_buf_2
XFILLER_31_1723 VPWR VGND sg13g2_fill_1
X_19044_ _19046_/B _19041_/Y _19044_/B VPWR VGND sg13g2_nand2b_1
X_16256_ _16256_/Y _22522_/Q _16241_/C _16255_/Y VPWR VGND sg13g2_o21ai_1
XFILLER_70_1783 VPWR VGND sg13g2_decap_8
X_13468_ _13469_/D _14134_/D _13468_/B VPWR VGND sg13g2_nor2_1
XFILLER_16_1291 VPWR VGND sg13g2_fill_2
XFILLER_31_1756 VPWR VGND sg13g2_fill_2
XFILLER_31_1767 VPWR VGND sg13g2_fill_1
X_15207_ _16334_/A _15482_/A _15393_/B VPWR VGND sg13g2_nor2_1
X_16187_ _16187_/Y _17917_/A _16187_/B VPWR VGND sg13g2_nor2_1
X_13399_ _13399_/X _23564_/Q _24012_/Q _13565_/A VPWR VGND sg13g2_mux2_1
X_15138_ _16046_/A _18339_/A _16023_/B _15137_/Y VPWR VGND sg13g2_o21ai_1
XFILLER_88_909 VPWR VGND sg13g2_decap_4
XFILLER_99_246 VPWR VGND sg13g2_decap_8
XFILLER_29_1630 VPWR VGND sg13g2_fill_1
XFILLER_114_557 VPWR VGND sg13g2_decap_8
XFILLER_9_1724 VPWR VGND sg13g2_decap_8
X_19946_ _19946_/Y _20100_/A1 _19943_/Y _19945_/Y _20130_/B _19946_/C1 VPWR VGND sg13g2_a221oi_1
X_15069_ _15071_/A _17914_/A1 _15029_/B _18679_/A2 _15069_/B2 _15068_/Y VPWR VGND
+ sg13g2_a221oi_1
XFILLER_68_611 VPWR VGND sg13g2_decap_8
XFILLER_29_1685 VPWR VGND sg13g2_fill_2
XFILLER_25_1527 VPWR VGND sg13g2_decap_4
XFILLER_96_942 VPWR VGND sg13g2_decap_8
XFILLER_68_633 VPWR VGND sg13g2_decap_8
XFILLER_96_953 VPWR VGND sg13g2_fill_1
X_19877_ _19877_/X _20060_/A _19877_/B VPWR VGND sg13g2_and2_1
XFILLER_68_644 VPWR VGND sg13g2_fill_1
XFILLER_110_741 VPWR VGND sg13g2_decap_8
XFILLER_99_1628 VPWR VGND sg13g2_fill_2
XFILLER_28_508 VPWR VGND sg13g2_decap_8
XFILLER_68_677 VPWR VGND sg13g2_fill_1
X_18828_ _18828_/Y _18866_/A _18828_/B VPWR VGND sg13g2_nand2_1
XFILLER_67_154 VPWR VGND sg13g2_fill_1
XFILLER_56_839 VPWR VGND sg13g2_decap_8
XFILLER_110_1210 VPWR VGND sg13g2_fill_1
XFILLER_3_1345 VPWR VGND sg13g2_fill_1
X_18759_ _23029_/D _16022_/Y _18757_/Y _18758_/Y _18756_/A VPWR VGND sg13g2_a22oi_1
XFILLER_3_1356 VPWR VGND sg13g2_decap_8
XFILLER_64_850 VPWR VGND sg13g2_fill_2
XFILLER_91_680 VPWR VGND sg13g2_decap_8
XFILLER_93_1249 VPWR VGND sg13g2_decap_4
X_23440_ _23440_/Q clkload38/A _23440_/D fanout2629/X VPWR VGND sg13g2_dfrbpq_1
XFILLER_11_419 VPWR VGND sg13g2_decap_8
XFILLER_17_1033 VPWR VGND sg13g2_decap_8
XFILLER_71_1558 VPWR VGND sg13g2_fill_1
X_23371_ _23371_/Q _24214_/CLK _23371_/D fanout2627/X VPWR VGND sg13g2_dfrbpq_1
X_20583_ _20644_/B _22186_/A _20649_/B VPWR VGND sg13g2_nand2_1
XFILLER_109_307 VPWR VGND sg13g2_decap_8
XFILLER_14_1921 VPWR VGND sg13g2_decap_8
X_22322_ _22322_/Y _24149_/Q _22335_/B VPWR VGND sg13g2_nand2_1
XFILLER_105_502 VPWR VGND sg13g2_decap_8
X_21204_ _23625_/D _23625_/Q _21336_/A0 _21220_/S VPWR VGND sg13g2_mux2_1
Xhold4910 _22263_/A _24120_/Q VPWR VGND sg13g2_dlygate4sd3_1
XFILLER_30_1299 VPWR VGND sg13g2_fill_2
XFILLER_65_1307 VPWR VGND sg13g2_decap_8
Xhold4921 _20410_/A _23269_/Q VPWR VGND sg13g2_dlygate4sd3_1
X_22184_ _22184_/Y _22184_/A _22184_/B VPWR VGND sg13g2_nand2_1
Xhold4932 _20622_/A _23365_/Q VPWR VGND sg13g2_dlygate4sd3_1
Xhold4943 _20796_/A _23448_/Q VPWR VGND sg13g2_dlygate4sd3_1
XFILLER_69_1498 VPWR VGND sg13g2_fill_1
Xhold4954 _22060_/A _24023_/Q VPWR VGND sg13g2_dlygate4sd3_1
XFILLER_78_408 VPWR VGND sg13g2_decap_8
XFILLER_105_579 VPWR VGND sg13g2_decap_8
Xhold4965 _21353_/A _23700_/Q VPWR VGND sg13g2_dlygate4sd3_1
Xhold4976 _21883_/A _23937_/Q VPWR VGND sg13g2_dlygate4sd3_1
Xhold4987 _21367_/A _23704_/Q VPWR VGND sg13g2_dlygate4sd3_1
XFILLER_115_1110 VPWR VGND sg13g2_decap_8
Xhold4998 _20894_/A _23493_/Q VPWR VGND sg13g2_dlygate4sd3_1
XFILLER_48_24 VPWR VGND sg13g2_fill_1
XFILLER_63_1053 VPWR VGND sg13g2_decap_8
XFILLER_82_1687 VPWR VGND sg13g2_decap_4
XFILLER_58_121 VPWR VGND sg13g2_fill_1
X_20017_ _20018_/B _20310_/A1 _20310_/A3 _20310_/A0 _20310_/A2 _20019_/S0 _20072_/S1
+ VPWR VGND sg13g2_mux4_1
XFILLER_4_1109 VPWR VGND sg13g2_decap_8
XFILLER_48_79 VPWR VGND sg13g2_fill_2
XFILLER_47_817 VPWR VGND sg13g2_fill_2
XFILLER_87_997 VPWR VGND sg13g2_fill_1
XFILLER_21_1903 VPWR VGND sg13g2_decap_8
XFILLER_115_1187 VPWR VGND sg13g2_fill_2
XFILLER_111_1018 VPWR VGND sg13g2_fill_1
XFILLER_100_262 VPWR VGND sg13g2_fill_1
XFILLER_111_1029 VPWR VGND sg13g2_decap_8
XFILLER_104_63 VPWR VGND sg13g2_decap_8
XFILLER_46_349 VPWR VGND sg13g2_fill_2
XFILLER_73_135 VPWR VGND sg13g2_fill_1
XFILLER_27_552 VPWR VGND sg13g2_decap_8
XFILLER_15_703 VPWR VGND sg13g2_fill_1
X_12770_ _12770_/Y _14129_/C _13350_/A VPWR VGND sg13g2_nor2_1
XFILLER_3_1890 VPWR VGND sg13g2_decap_8
X_21968_ _21968_/Y _21968_/A _21976_/B VPWR VGND sg13g2_nand2_1
XFILLER_14_202 VPWR VGND sg13g2_fill_2
XFILLER_55_894 VPWR VGND sg13g2_decap_8
XFILLER_54_382 VPWR VGND sg13g2_fill_1
X_23707_ _23707_/Q clkload58/A _23707_/D fanout2763/X VPWR VGND sg13g2_dfrbpq_1
X_11721_ _11722_/B _23704_/Q _23832_/Q _11723_/S VPWR VGND sg13g2_mux2_1
XFILLER_70_842 VPWR VGND sg13g2_fill_2
X_20919_ _20919_/Y _20919_/A _20919_/B VPWR VGND sg13g2_nand2_1
X_21899_ _23945_/D _21965_/A0 _23945_/Q _21899_/S VPWR VGND sg13g2_mux2_1
XFILLER_14_246 VPWR VGND sg13g2_fill_1
XFILLER_19_1843 VPWR VGND sg13g2_fill_2
XFILLER_42_577 VPWR VGND sg13g2_decap_4
X_14440_ _14441_/B _14437_/Y _14766_/A _14439_/Y _18432_/A VPWR VGND sg13g2_a22oi_1
X_23638_ _23638_/Q clkload57/A _23638_/D fanout2764/X VPWR VGND sg13g2_dfrbpq_1
XFILLER_80_33 VPWR VGND sg13g2_decap_8
XFILLER_35_1133 VPWR VGND sg13g2_fill_1
XFILLER_42_599 VPWR VGND sg13g2_decap_8
XFILLER_70_1013 VPWR VGND sg13g2_decap_8
XFILLER_54_1767 VPWR VGND sg13g2_fill_2
XFILLER_106_1846 VPWR VGND sg13g2_decap_8
X_14371_ _17034_/B _15172_/A _15172_/B VPWR VGND sg13g2_nand2_1
XFILLER_19_1898 VPWR VGND sg13g2_decap_8
X_23569_ _23569_/Q clkload47/A _23569_/D fanout2679/X VPWR VGND sg13g2_dfrbpq_1
XFILLER_35_1166 VPWR VGND sg13g2_fill_2
X_11583_ _11583_/X _22994_/Q _14118_/B _11583_/S VPWR VGND sg13g2_mux2_1
XFILLER_11_964 VPWR VGND sg13g2_decap_8
XFILLER_31_1008 VPWR VGND sg13g2_fill_1
XFILLER_70_1057 VPWR VGND sg13g2_decap_8
XFILLER_7_924 VPWR VGND sg13g2_fill_2
X_16110_ _16110_/Y _22495_/Q _16203_/B _16109_/Y VPWR VGND sg13g2_a21oi_1
XFILLER_80_99 VPWR VGND sg13g2_decap_8
X_13322_ _13322_/Y _11861_/A _13314_/X _13321_/Y VPWR VGND sg13g2_o21ai_1
X_17090_ _17091_/B _17090_/A _17095_/B VPWR VGND sg13g2_nor2b_1
XFILLER_109_830 VPWR VGND sg13g2_fill_2
XFILLER_87_1510 VPWR VGND sg13g2_decap_8
XFILLER_7_968 VPWR VGND sg13g2_decap_8
XFILLER_109_863 VPWR VGND sg13g2_decap_8
X_13253_ _13253_/X _23562_/Q _24010_/Q _13253_/S VPWR VGND sg13g2_mux2_1
XFILLER_100_1434 VPWR VGND sg13g2_decap_4
X_12204_ _12209_/B _12475_/A _12204_/B VPWR VGND sg13g2_nor2_1
X_13184_ _13292_/A _13373_/C _13373_/D VPWR VGND sg13g2_or2_1
XFILLER_83_1429 VPWR VGND sg13g2_fill_2
X_19800_ _19800_/Y _20092_/A2 _19799_/Y _19663_/X VPWR VGND sg13g2_a21oi_1
X_12135_ _12135_/Y _12475_/A _12135_/B VPWR VGND sg13g2_nor2_1
X_17992_ _17992_/X _19028_/A _23060_/Q _17992_/S VPWR VGND sg13g2_mux2_1
Xfanout2632 fanout2632/X fanout2644/X VPWR VGND sg13g2_buf_1
XFILLER_111_527 VPWR VGND sg13g2_decap_8
XFILLER_96_216 VPWR VGND sg13g2_decap_8
Xfanout2643 fanout2643/X fanout2644/X VPWR VGND sg13g2_buf_1
XFILLER_96_227 VPWR VGND sg13g2_fill_2
Xfanout2654 fanout2654/X fanout2655/X VPWR VGND sg13g2_buf_1
Xfanout2665 fanout2665/X fanout2667/X VPWR VGND sg13g2_buf_1
X_16943_ _16947_/D _22698_/Q _22697_/Q VPWR VGND sg13g2_nand2_1
X_19731_ _19732_/B _24248_/A _19977_/B VPWR VGND sg13g2_nand2_1
X_12066_ _12099_/B _13123_/A _13179_/B _12066_/C VPWR VGND sg13g2_nand3_1
XFILLER_65_1896 VPWR VGND sg13g2_decap_8
XFILLER_29_7 VPWR VGND sg13g2_decap_8
XFILLER_42_1115 VPWR VGND sg13g2_fill_2
Xfanout2676 fanout2676/X fanout2677/X VPWR VGND sg13g2_buf_1
Xfanout2687 fanout2687/X fanout2691/X VPWR VGND sg13g2_buf_1
XFILLER_81_1186 VPWR VGND sg13g2_decap_8
Xfanout2698 fanout2698/X fanout2706/X VPWR VGND sg13g2_buf_1
XFILLER_78_986 VPWR VGND sg13g2_decap_8
X_16874_ _22685_/D _16870_/Y _16357_/A _16895_/S VPWR VGND sg13g2_mux2_1
X_19662_ _19662_/Y _19824_/A _19661_/Y _19541_/A VPWR VGND sg13g2_a21oi_1
XFILLER_8_1790 VPWR VGND sg13g2_decap_8
XFILLER_77_485 VPWR VGND sg13g2_decap_8
X_15825_ _15829_/A _22901_/Q _15825_/B VPWR VGND sg13g2_nand2_1
X_18613_ _18613_/Y _18613_/A _18613_/B VPWR VGND sg13g2_nand2_1
XFILLER_111_1530 VPWR VGND sg13g2_decap_4
X_19593_ _19594_/B _19932_/B _19581_/Y _19586_/Y _19592_/Y _20028_/A _20080_/A VPWR
+ VGND sg13g2_mux4_1
XFILLER_37_349 VPWR VGND sg13g2_decap_8
XFILLER_18_530 VPWR VGND sg13g2_fill_1
XFILLER_4_1665 VPWR VGND sg13g2_fill_1
XFILLER_53_809 VPWR VGND sg13g2_decap_8
XFILLER_111_1552 VPWR VGND sg13g2_decap_8
XFILLER_93_978 VPWR VGND sg13g2_fill_1
XFILLER_4_1676 VPWR VGND sg13g2_decap_8
X_18544_ _18544_/Y _18544_/A _18544_/B VPWR VGND sg13g2_nor2_1
XFILLER_52_319 VPWR VGND sg13g2_fill_2
X_15756_ _17158_/A _20166_/A _15754_/Y _15755_/Y VPWR VGND sg13g2_a21o_1
X_12968_ _12968_/X _12968_/A _12968_/B _12968_/C VPWR VGND sg13g2_or3_1
XFILLER_64_179 VPWR VGND sg13g2_decap_8
XFILLER_46_894 VPWR VGND sg13g2_fill_2
XFILLER_61_820 VPWR VGND sg13g2_fill_1
X_14707_ _14707_/Y _14707_/A1 _14710_/B _14706_/Y VPWR VGND sg13g2_a21oi_1
X_11919_ _11919_/X _24026_/Q _24058_/Q _11919_/S VPWR VGND sg13g2_mux2_1
X_15687_ _15688_/D _22856_/Q _15989_/A2 _15873_/B _22603_/Q VPWR VGND sg13g2_a22oi_1
XFILLER_72_190 VPWR VGND sg13g2_decap_8
X_12899_ _12899_/X _12668_/Y _12898_/Y _12899_/S VPWR VGND sg13g2_mux2_1
X_17426_ _22832_/D _17917_/A _17425_/B _17425_/Y VPWR VGND sg13g2_o21ai_1
XFILLER_21_717 VPWR VGND sg13g2_fill_1
XFILLER_60_352 VPWR VGND sg13g2_fill_1
X_14638_ _19238_/B _15407_/A _19611_/A _14629_/Y VPWR VGND sg13g2_o21ai_1
XFILLER_37_1954 VPWR VGND sg13g2_fill_1
XFILLER_57_1380 VPWR VGND sg13g2_decap_4
Xplace4205 _12028_/A _13193_/S0 VPWR VGND sg13g2_buf_4
XFILLER_20_216 VPWR VGND sg13g2_decap_8
Xplace4216 _14852_/A _22984_/Q VPWR VGND sg13g2_buf_2
X_17357_ _22805_/D _16169_/A _17358_/B _17356_/Y VPWR VGND sg13g2_o21ai_1
Xplace4227 _12042_/B _11774_/A VPWR VGND sg13g2_buf_4
Xrebuffer5217 _24250_/A _14049_/A VPWR VGND sg13g2_buf_1
Xplace4238 _13774_/A _12285_/A VPWR VGND sg13g2_buf_1
XFILLER_20_249 VPWR VGND sg13g2_fill_2
XFILLER_53_1266 VPWR VGND sg13g2_decap_4
Xplace3504 _20329_/B2 _20201_/B VPWR VGND sg13g2_buf_1
Xplace4249 _12709_/A _13236_/S1 VPWR VGND sg13g2_buf_2
Xrebuffer5228 place3712/A _12992_/Y VPWR VGND sg13g2_buf_2
Xplace3515 _19231_/S _19209_/S VPWR VGND sg13g2_buf_1
Xrebuffer5239 _20147_/A _13057_/B VPWR VGND sg13g2_buf_1
X_16308_ _16311_/B _16314_/C _16324_/C VPWR VGND sg13g2_nor2_2
Xplace3526 _15991_/A2 _15312_/Y VPWR VGND sg13g2_buf_1
XFILLER_88_1307 VPWR VGND sg13g2_fill_1
Xplace3537 _19159_/S _19169_/S VPWR VGND sg13g2_buf_1
X_17288_ _22773_/D _16169_/A _17293_/B _17287_/Y VPWR VGND sg13g2_o21ai_1
XFILLER_31_1531 VPWR VGND sg13g2_decap_4
Xplace3548 _15893_/A2 _15767_/B VPWR VGND sg13g2_buf_1
XFILLER_70_1591 VPWR VGND sg13g2_decap_8
Xplace3559 _14739_/S _14726_/S VPWR VGND sg13g2_buf_1
Xclkload20 clkload20/X clkload20/A VPWR VGND sg13g2_buf_16
X_19027_ _23059_/D _19021_/Y _19024_/Y _19025_/Y _19026_/Y VPWR VGND sg13g2_a22oi_1
Xclkload31 clkload31/X clkload31/A VPWR VGND sg13g2_buf_16
X_16239_ _16240_/B _24251_/A _14879_/A _14866_/Y VPWR VGND sg13g2_a21oi_1
Xclkload42 clkload42/Y clkload42/A VPWR VGND sg13g2_inv_8
XFILLER_31_1575 VPWR VGND sg13g2_decap_4
Xclkload53 clkload53/Y clkload53/A VPWR VGND sg13g2_inv_2
XFILLER_115_866 VPWR VGND sg13g2_decap_8
XFILLER_86_1075 VPWR VGND sg13g2_decap_8
XFILLER_102_505 VPWR VGND sg13g2_decap_8
XFILLER_44_1903 VPWR VGND sg13g2_fill_2
XFILLER_29_1471 VPWR VGND sg13g2_decap_8
X_19929_ _19929_/Y _19928_/A _19927_/X _19928_/Y VPWR VGND sg13g2_o21ai_1
XFILLER_29_817 VPWR VGND sg13g2_decap_8
X_22940_ _22940_/Q clkload9/A _22940_/D fanout2825/X VPWR VGND sg13g2_dfrbpq_1
XFILLER_110_571 VPWR VGND sg13g2_decap_8
XFILLER_42_1660 VPWR VGND sg13g2_fill_1
XFILLER_68_496 VPWR VGND sg13g2_decap_8
XFILLER_18_49 VPWR VGND sg13g2_decap_4
XFILLER_55_124 VPWR VGND sg13g2_decap_8
XFILLER_3_1131 VPWR VGND sg13g2_decap_8
X_22871_ _22871_/Q _22893_/CLK _22871_/D fanout2821/X VPWR VGND sg13g2_dfrbpq_1
XFILLER_23_1081 VPWR VGND sg13g2_decap_8
XFILLER_55_157 VPWR VGND sg13g2_fill_1
XFILLER_71_606 VPWR VGND sg13g2_decap_8
XFILLER_71_617 VPWR VGND sg13g2_fill_2
XFILLER_37_872 VPWR VGND sg13g2_decap_4
X_21822_ _21822_/Y _23908_/Q _21826_/B VPWR VGND sg13g2_nand2_1
XFILLER_3_1186 VPWR VGND sg13g2_decap_8
XFILLER_110_1084 VPWR VGND sg13g2_decap_8
XFILLER_110_1095 VPWR VGND sg13g2_decap_8
XFILLER_52_842 VPWR VGND sg13g2_fill_1
XFILLER_93_1046 VPWR VGND sg13g2_decap_8
XFILLER_24_555 VPWR VGND sg13g2_decap_4
X_20704_ _20704_/Y _23406_/Q _20704_/B VPWR VGND sg13g2_nand2_1
XFILLER_90_1934 VPWR VGND sg13g2_decap_8
XFILLER_11_205 VPWR VGND sg13g2_fill_1
X_21684_ _21684_/Y _23856_/Q _21690_/B VPWR VGND sg13g2_nand2_1
XFILLER_75_1491 VPWR VGND sg13g2_decap_8
XFILLER_11_238 VPWR VGND sg13g2_decap_8
X_23423_ _23423_/Q clkload40/A _23423_/D fanout2725/X VPWR VGND sg13g2_dfrbpq_1
X_20635_ _20635_/Y _23372_/Q _20647_/B VPWR VGND sg13g2_nand2_1
Xclkload3 clkload3/X clkload3/A VPWR VGND sg13g2_buf_16
XFILLER_109_126 VPWR VGND sg13g2_decap_8
X_23354_ _23354_/Q clkload54/A _23354_/D fanout2751/X VPWR VGND sg13g2_dfrbpq_1
X_20566_ _23338_/D _22435_/A1 _20572_/B _20565_/Y VPWR VGND sg13g2_o21ai_1
XFILLER_50_58 VPWR VGND sg13g2_decap_4
X_22305_ _24140_/D _22305_/A1 _22310_/B _22304_/Y VPWR VGND sg13g2_o21ai_1
XFILLER_101_1743 VPWR VGND sg13g2_decap_8
X_23285_ _23285_/Q clkload57/A _23285_/D fanout2747/X VPWR VGND sg13g2_dfrbpq_1
X_20497_ _23308_/D _20702_/A1 _20504_/B _20496_/Y VPWR VGND sg13g2_o21ai_1
XFILLER_14_1795 VPWR VGND sg13g2_decap_8
XFILLER_3_404 VPWR VGND sg13g2_fill_2
XFILLER_69_1240 VPWR VGND sg13g2_decap_8
XFILLER_49_1825 VPWR VGND sg13g2_decap_8
XFILLER_69_1251 VPWR VGND sg13g2_fill_1
X_22236_ _22236_/Y _22236_/A _22250_/B VPWR VGND sg13g2_nand2_1
XFILLER_106_855 VPWR VGND sg13g2_decap_8
Xhold4740 _20803_/A _23451_/Q VPWR VGND sg13g2_dlygate4sd3_1
XFILLER_79_717 VPWR VGND sg13g2_decap_4
Xhold4751 _22015_/A _24001_/Q VPWR VGND sg13g2_dlygate4sd3_1
X_22167_ _24073_/D _24073_/Q _20187_/Y _22183_/S VPWR VGND sg13g2_mux2_1
Xhold4762 _21410_/A _23724_/Q VPWR VGND sg13g2_dlygate4sd3_1
Xhold4773 _22307_/A _24142_/Q VPWR VGND sg13g2_dlygate4sd3_1
Xhold4784 _17238_/A _22750_/Q VPWR VGND sg13g2_dlygate4sd3_1
XFILLER_43_1402 VPWR VGND sg13g2_fill_1
X_21118_ _23584_/D _21587_/A1 _21121_/B _21117_/Y VPWR VGND sg13g2_o21ai_1
Xhold4795 _22422_/A _24196_/Q VPWR VGND sg13g2_dlygate4sd3_1
XFILLER_87_750 VPWR VGND sg13g2_decap_8
XFILLER_82_1484 VPWR VGND sg13g2_decap_4
XFILLER_59_452 VPWR VGND sg13g2_decap_8
X_21049_ _23557_/D _22292_/A1 _21051_/B _21048_/Y VPWR VGND sg13g2_o21ai_1
X_13940_ _13940_/X _13940_/A _20338_/B VPWR VGND sg13g2_and2_1
XFILLER_87_783 VPWR VGND sg13g2_decap_8
XFILLER_115_84 VPWR VGND sg13g2_decap_8
XFILLER_5_1952 VPWR VGND sg13g2_fill_2
XFILLER_101_593 VPWR VGND sg13g2_decap_8
XFILLER_19_338 VPWR VGND sg13g2_decap_8
XFILLER_47_647 VPWR VGND sg13g2_fill_1
XFILLER_60_1782 VPWR VGND sg13g2_decap_8
X_13871_ _13886_/A _13999_/A _13880_/A _13880_/B VPWR VGND sg13g2_nor3_1
XFILLER_47_669 VPWR VGND sg13g2_fill_2
XFILLER_112_1861 VPWR VGND sg13g2_decap_8
XFILLER_95_1812 VPWR VGND sg13g2_fill_2
X_15610_ _15610_/X _17119_/A _22463_/Q _15694_/S VPWR VGND sg13g2_mux2_1
X_12822_ _12822_/X _12822_/A _12822_/B _12822_/C VPWR VGND sg13g2_and3_2
X_16590_ _16591_/B _22633_/Q _16590_/B VPWR VGND sg13g2_xnor2_1
XFILLER_46_179 VPWR VGND sg13g2_decap_4
X_15541_ _17102_/A _19430_/A _15335_/B _15540_/Y VPWR VGND sg13g2_a21o_1
XFILLER_15_544 VPWR VGND sg13g2_decap_8
X_12753_ _12757_/B _20035_/B VPWR VGND sg13g2_inv_1
XFILLER_15_555 VPWR VGND sg13g2_fill_1
X_11704_ _11705_/B _23576_/Q _23640_/Q _11714_/S VPWR VGND sg13g2_mux2_1
X_18260_ _18260_/Y _18260_/A _18260_/B VPWR VGND sg13g2_nor2_1
XFILLER_43_886 VPWR VGND sg13g2_decap_4
XFILLER_72_1119 VPWR VGND sg13g2_decap_4
X_15472_ _22457_/D _16069_/A _15471_/X _15497_/S VPWR VGND sg13g2_mux2_1
XFILLER_70_672 VPWR VGND sg13g2_decap_4
X_12684_ _12691_/A _23906_/Q _12889_/C _12682_/X _11688_/A _12683_/X VPWR VGND sg13g2_a221oi_1
XFILLER_54_1542 VPWR VGND sg13g2_fill_1
X_17211_ _17217_/B _22744_/Q _17211_/B VPWR VGND sg13g2_and2_1
XFILLER_106_1621 VPWR VGND sg13g2_fill_2
X_14423_ _17039_/A _19835_/A _14423_/B VPWR VGND sg13g2_or2_1
XFILLER_19_1684 VPWR VGND sg13g2_decap_8
XFILLER_24_70 VPWR VGND sg13g2_decap_8
X_18191_ _18191_/Y _18318_/A _18240_/A VPWR VGND sg13g2_nor2_1
X_11635_ _13537_/B _11635_/A _14087_/B _14087_/C VPWR VGND sg13g2_and3_2
XFILLER_15_1537 VPWR VGND sg13g2_fill_2
X_17142_ _22732_/D _17141_/B _17140_/Y _17141_/Y VPWR VGND sg13g2_a21oi_1
X_14354_ _15389_/A _15233_/B _15300_/C _15191_/B VPWR VGND sg13g2_and3_1
X_11566_ _11566_/Y _11571_/B _14098_/A _14098_/B _11596_/C VPWR VGND sg13g2_nor4_1
XFILLER_32_1851 VPWR VGND sg13g2_fill_1
X_13305_ _13306_/A _13288_/Y _13298_/Y _13303_/Y _14061_/S VPWR VGND sg13g2_a22oi_1
X_17073_ _17074_/B _17073_/A _17090_/A _17083_/B _17073_/D VPWR VGND sg13g2_nor4_1
XFILLER_10_293 VPWR VGND sg13g2_fill_1
XFILLER_6_242 VPWR VGND sg13g2_fill_2
XFILLER_109_671 VPWR VGND sg13g2_decap_8
XFILLER_100_1220 VPWR VGND sg13g2_fill_1
X_11497_ _11497_/Y _11446_/X _11448_/X _12668_/A _11497_/B2 _11496_/Y VPWR VGND sg13g2_a221oi_1
XFILLER_87_1340 VPWR VGND sg13g2_decap_4
X_16024_ _16209_/A _16022_/Y _16023_/B _16023_/Y VPWR VGND sg13g2_o21ai_1
X_13236_ _13236_/X _23306_/Q _23338_/Q _23370_/Q _23402_/Q _13236_/S0 _13236_/S1 VPWR
+ VGND sg13g2_mux4_1
XFILLER_48_1335 VPWR VGND sg13g2_decap_8
XFILLER_100_1286 VPWR VGND sg13g2_decap_8
XFILLER_112_803 VPWR VGND sg13g2_decap_8
X_13167_ _13167_/Y _13166_/B _23657_/Q _13166_/Y VPWR VGND sg13g2_o21ai_1
XFILLER_3_982 VPWR VGND sg13g2_decap_8
XFILLER_26_1600 VPWR VGND sg13g2_decap_8
XFILLER_97_547 VPWR VGND sg13g2_decap_4
X_12118_ _12119_/C _12123_/A _23900_/Q VPWR VGND sg13g2_or2_1
XFILLER_65_1671 VPWR VGND sg13g2_decap_4
X_17975_ _18517_/A _18491_/A _17972_/Y _17974_/Y VPWR VGND sg13g2_o21ai_1
X_13098_ _13098_/X _13098_/A _20147_/B _13098_/C VPWR VGND sg13g2_and3_1
XFILLER_26_1655 VPWR VGND sg13g2_decap_8
Xclkbuf_leaf_52_clk_i clkload41/A clkbuf_leaf_55_clk_i/A VPWR VGND sg13g2_buf_16
X_19714_ _19867_/B _19552_/X _19549_/X _19714_/S VPWR VGND sg13g2_mux2_1
X_16926_ _16926_/Y _16954_/A _16926_/B VPWR VGND sg13g2_xnor2_1
XFILLER_66_923 VPWR VGND sg13g2_fill_2
X_12049_ _12052_/A _23227_/Q _23259_/Q _23355_/Q _23387_/Q _12401_/B _11423_/B VPWR
+ VGND sg13g2_mux4_1
XFILLER_6_1749 VPWR VGND sg13g2_decap_8
XFILLER_77_271 VPWR VGND sg13g2_decap_8
XFILLER_61_1579 VPWR VGND sg13g2_decap_8
X_19645_ _19645_/Y _19703_/A _19459_/B _19644_/Y VPWR VGND sg13g2_a21oi_1
XFILLER_77_293 VPWR VGND sg13g2_fill_1
X_16857_ _16858_/D _17042_/C _17042_/D _16857_/C VPWR VGND sg13g2_nand3_1
XFILLER_1_63 VPWR VGND sg13g2_decap_8
XFILLER_37_157 VPWR VGND sg13g2_decap_4
XFILLER_93_786 VPWR VGND sg13g2_decap_8
XFILLER_25_308 VPWR VGND sg13g2_decap_8
XFILLER_53_617 VPWR VGND sg13g2_decap_4
XFILLER_80_403 VPWR VGND sg13g2_decap_8
X_15808_ _15815_/A _22932_/Q _15897_/A2 _15807_/Y VPWR VGND sg13g2_a21oi_1
X_19576_ _19577_/B _19584_/S _19576_/B VPWR VGND sg13g2_xnor2_1
X_16788_ _16789_/B _15232_/Y _16785_/Y _16787_/Y VPWR VGND sg13g2_a21oi_1
Xclkbuf_leaf_67_clk_i clkload13/A clkbuf_4_2__f_clk_i/X VPWR VGND sg13g2_buf_16
X_15739_ _22469_/D _16138_/A _15738_/X _15981_/S VPWR VGND sg13g2_mux2_1
X_18527_ _18527_/X _17939_/X _18846_/B _18549_/S VPWR VGND sg13g2_mux2_1
XFILLER_34_875 VPWR VGND sg13g2_decap_8
XFILLER_61_672 VPWR VGND sg13g2_fill_1
X_18458_ _18530_/B _18458_/A _18458_/B VPWR VGND sg13g2_and2_1
XFILLER_60_160 VPWR VGND sg13g2_decap_4
XFILLER_37_1751 VPWR VGND sg13g2_decap_8
XFILLER_72_1631 VPWR VGND sg13g2_decap_8
Xplace4002 _13120_/A _11917_/A VPWR VGND sg13g2_buf_1
X_17409_ _22823_/D _16136_/A _17412_/B _17408_/Y VPWR VGND sg13g2_o21ai_1
Xplace4013 _12707_/S _12406_/A VPWR VGND sg13g2_buf_2
Xplace4024 _11517_/S _12119_/A VPWR VGND sg13g2_buf_1
X_18389_ _18389_/Y _18538_/S _17972_/Y _18388_/Y VPWR VGND sg13g2_o21ai_1
XFILLER_21_558 VPWR VGND sg13g2_fill_1
XFILLER_18_1172 VPWR VGND sg13g2_decap_8
XFILLER_33_1626 VPWR VGND sg13g2_fill_1
XFILLER_37_1795 VPWR VGND sg13g2_decap_8
Xplace4035 _11602_/B _14461_/B VPWR VGND sg13g2_buf_1
Xplace3301 _21934_/A1 _22268_/A1 VPWR VGND sg13g2_buf_1
Xplace4046 _19077_/S _19054_/S VPWR VGND sg13g2_buf_1
X_20420_ _23274_/D _22435_/A1 _20426_/B _20419_/Y VPWR VGND sg13g2_o21ai_1
Xplace3312 _21299_/A1 _19688_/Y VPWR VGND sg13g2_buf_1
Xplace4057 _18446_/S _24226_/Q VPWR VGND sg13g2_buf_1
XFILLER_53_1085 VPWR VGND sg13g2_decap_4
Xplace4068 _18015_/S _18899_/A VPWR VGND sg13g2_buf_1
Xplace3323 _22445_/A1 _20297_/Y VPWR VGND sg13g2_buf_1
Xplace4079 _20072_/S1 _20343_/S0 VPWR VGND sg13g2_buf_1
Xplace3334 _22437_/A1 _20700_/A1 VPWR VGND sg13g2_buf_1
XFILLER_50_1940 VPWR VGND sg13g2_decap_8
XFILLER_11_1902 VPWR VGND sg13g2_decap_8
Xplace3345 _22282_/A1 _21948_/A1 VPWR VGND sg13g2_buf_1
Xplace3356 _22405_/A1 _21309_/A1 VPWR VGND sg13g2_buf_1
X_20351_ _20352_/B _19912_/S _19910_/X _20350_/Y VPWR VGND sg13g2_a21oi_1
Xplace3367 _22266_/A1 _19788_/Y VPWR VGND sg13g2_buf_1
Xplace3378 _17909_/B _17930_/B VPWR VGND sg13g2_buf_1
Xplace3389 _17467_/B _17462_/B VPWR VGND sg13g2_buf_1
X_23070_ _23070_/Q clkload14/A _23070_/D fanout2905/X VPWR VGND sg13g2_dfrbpq_1
X_22021_ _22021_/Y _22021_/A _22025_/B VPWR VGND sg13g2_nand2_1
XFILLER_115_663 VPWR VGND sg13g2_decap_8
XFILLER_114_140 VPWR VGND sg13g2_decap_8
XFILLER_66_1457 VPWR VGND sg13g2_decap_8
XFILLER_103_836 VPWR VGND sg13g2_fill_2
XFILLER_25_1121 VPWR VGND sg13g2_decap_8
XFILLER_9_1362 VPWR VGND sg13g2_decap_8
XFILLER_9_1373 VPWR VGND sg13g2_fill_2
XFILLER_64_1181 VPWR VGND sg13g2_decap_8
X_23972_ _23972_/Q clkload40/A _23972_/D fanout2731/X VPWR VGND sg13g2_dfrbpq_1
XFILLER_111_891 VPWR VGND sg13g2_decap_8
XFILLER_29_636 VPWR VGND sg13g2_fill_1
XFILLER_84_731 VPWR VGND sg13g2_decap_8
XFILLER_28_113 VPWR VGND sg13g2_decap_4
XFILLER_60_1067 VPWR VGND sg13g2_fill_2
XFILLER_68_282 VPWR VGND sg13g2_decap_8
X_22923_ _22923_/Q clkload9/A _22923_/D fanout2823/X VPWR VGND sg13g2_dfrbpq_1
XFILLER_68_293 VPWR VGND sg13g2_fill_1
XFILLER_29_658 VPWR VGND sg13g2_fill_2
XFILLER_84_764 VPWR VGND sg13g2_fill_2
XFILLER_112_1179 VPWR VGND sg13g2_decap_8
X_22854_ _22854_/Q _22893_/CLK _22854_/D fanout2819/X VPWR VGND sg13g2_dfrbpq_1
XFILLER_44_639 VPWR VGND sg13g2_fill_2
X_21805_ _23900_/D _19891_/Y _21804_/B _21804_/Y VPWR VGND sg13g2_o21ai_1
XFILLER_25_853 VPWR VGND sg13g2_decap_8
XFILLER_36_190 VPWR VGND sg13g2_decap_8
X_22785_ _22785_/Q clkload18/A _22785_/D fanout2820/X VPWR VGND sg13g2_dfrbpq_1
XFILLER_80_970 VPWR VGND sg13g2_fill_1
XFILLER_101_42 VPWR VGND sg13g2_decap_8
XFILLER_25_886 VPWR VGND sg13g2_fill_2
XFILLER_0_1893 VPWR VGND sg13g2_decap_8
XFILLER_52_683 VPWR VGND sg13g2_fill_2
X_21736_ _23873_/D _21950_/A1 _21738_/B _21735_/Y VPWR VGND sg13g2_o21ai_1
XFILLER_107_1930 VPWR VGND sg13g2_decap_8
XFILLER_71_1130 VPWR VGND sg13g2_decap_8
XFILLER_16_1835 VPWR VGND sg13g2_decap_8
X_21667_ _23846_/D _22294_/A1 _21666_/B _21666_/Y VPWR VGND sg13g2_o21ai_1
X_11420_ _11420_/Y _11379_/Y _11417_/Y _11754_/B1 VPWR VGND sg13g2_a21oi_1
X_23406_ _23406_/Q clkload35/A _23406_/D fanout2630/X VPWR VGND sg13g2_dfrbpq_1
X_20618_ _20618_/Y _23363_/Q _20624_/B VPWR VGND sg13g2_nand2_1
X_21598_ _21598_/Y _23814_/Q _21605_/B VPWR VGND sg13g2_nand2_1
X_11351_ _11351_/X _13158_/S _11348_/Y _11350_/Y VPWR VGND sg13g2_a21o_1
X_23337_ _23337_/Q _24205_/CLK _23337_/D fanout2650/X VPWR VGND sg13g2_dfrbpq_1
Xrebuffer5570 _19238_/A _14634_/Y VPWR VGND sg13g2_buf_8
X_20549_ _23330_/D _22418_/A1 _20548_/B _20548_/Y VPWR VGND sg13g2_o21ai_1
XFILLER_3_201 VPWR VGND sg13g2_decap_4
XFILLER_49_1600 VPWR VGND sg13g2_decap_8
Xplace3890 _18485_/B _18562_/B VPWR VGND sg13g2_buf_1
XFILLER_49_1611 VPWR VGND sg13g2_fill_1
XFILLER_88_1671 VPWR VGND sg13g2_decap_8
X_11282_ _12557_/S _12128_/A VPWR VGND sg13g2_inv_4
X_23268_ _23268_/Q _24196_/CLK _23268_/D fanout2704/X VPWR VGND sg13g2_dfrbpq_1
X_13021_ _14653_/A _14134_/D _13021_/B VPWR VGND sg13g2_nor2_1
XFILLER_105_140 VPWR VGND sg13g2_decap_8
X_22219_ _22219_/Y _24098_/Q _22219_/B VPWR VGND sg13g2_nand2_1
X_23199_ _23199_/Q _23215_/CLK _23199_/D fanout2926/X VPWR VGND sg13g2_dfrbpq_1
XFILLER_62_1800 VPWR VGND sg13g2_fill_2
XFILLER_10_94 VPWR VGND sg13g2_fill_2
XFILLER_0_952 VPWR VGND sg13g2_fill_1
XFILLER_27_1953 VPWR VGND sg13g2_fill_2
XFILLER_67_709 VPWR VGND sg13g2_fill_1
XFILLER_86_43 VPWR VGND sg13g2_decap_8
XFILLER_114_1923 VPWR VGND sg13g2_decap_8
X_14972_ _14972_/Y _24228_/Q _23140_/Q VPWR VGND sg13g2_nand2_1
XFILLER_23_1817 VPWR VGND sg13g2_fill_1
X_17760_ _17760_/Y _22900_/Q _17789_/B VPWR VGND sg13g2_nor2_1
XFILLER_62_1866 VPWR VGND sg13g2_fill_2
XFILLER_0_996 VPWR VGND sg13g2_fill_2
XFILLER_43_1265 VPWR VGND sg13g2_decap_4
XFILLER_47_422 VPWR VGND sg13g2_decap_8
X_16711_ _16711_/Y _16711_/A _16711_/B VPWR VGND sg13g2_nor2_1
X_13923_ _13923_/X _11442_/A _13923_/A2 _22578_/Q VPWR VGND sg13g2_a21o_1
XFILLER_97_1918 VPWR VGND sg13g2_decap_8
XFILLER_19_70 VPWR VGND sg13g2_decap_8
X_17691_ _17691_/Y _17130_/A _17382_/A _17580_/B _17690_/Y VPWR VGND sg13g2_a22oi_1
XFILLER_48_967 VPWR VGND sg13g2_decap_4
XFILLER_74_230 VPWR VGND sg13g2_decap_8
XFILLER_19_146 VPWR VGND sg13g2_decap_8
XFILLER_60_1590 VPWR VGND sg13g2_fill_2
X_19430_ _19430_/Y _19430_/A _19430_/B VPWR VGND sg13g2_nand2_1
XFILLER_47_477 VPWR VGND sg13g2_decap_8
X_16642_ _16642_/Y _16656_/A _16642_/B VPWR VGND sg13g2_nor2_1
XFILLER_63_926 VPWR VGND sg13g2_decap_8
XFILLER_78_1339 VPWR VGND sg13g2_decap_4
X_13854_ _13855_/B _13854_/A _13854_/B _13854_/C VPWR VGND sg13g2_or3_1
XFILLER_95_1620 VPWR VGND sg13g2_fill_1
X_12805_ _12822_/A _13243_/S1 _12799_/X _12804_/Y VPWR VGND sg13g2_o21ai_1
X_16573_ _22629_/D _16080_/Y _16678_/S _16572_/Y VPWR VGND sg13g2_a21oi_1
X_19361_ _19757_/A _19361_/A _19419_/B VPWR VGND sg13g2_xnor2_1
XFILLER_90_767 VPWR VGND sg13g2_fill_2
X_13785_ _13786_/B _23857_/Q _23889_/Q _23953_/Q _23985_/Q _13798_/B2 _13795_/S1 VPWR
+ VGND sg13g2_mux4_1
XFILLER_56_1626 VPWR VGND sg13g2_decap_4
X_15524_ _15524_/Y _22693_/Q _16013_/A2 _16013_/B1 _22629_/Q VPWR VGND sg13g2_a22oi_1
XFILLER_16_886 VPWR VGND sg13g2_decap_8
XFILLER_15_363 VPWR VGND sg13g2_decap_8
X_18312_ _18312_/X _18288_/A _18553_/A1 _18311_/Y VPWR VGND sg13g2_a21o_1
XFILLER_37_1025 VPWR VGND sg13g2_decap_4
XFILLER_91_1539 VPWR VGND sg13g2_decap_8
XFILLER_16_897 VPWR VGND sg13g2_fill_1
X_19292_ _23209_/D _23209_/Q _20310_/A3 _19299_/S VPWR VGND sg13g2_mux2_1
X_12736_ _12745_/D _12558_/A _12730_/X _12735_/Y VPWR VGND sg13g2_o21ai_1
XFILLER_108_1727 VPWR VGND sg13g2_fill_2
XFILLER_35_91 VPWR VGND sg13g2_decap_4
XFILLER_108_1738 VPWR VGND sg13g2_decap_8
XFILLER_96_7 VPWR VGND sg13g2_decap_8
XFILLER_34_1902 VPWR VGND sg13g2_fill_1
XFILLER_42_182 VPWR VGND sg13g2_fill_2
XFILLER_73_1951 VPWR VGND sg13g2_decap_4
X_18243_ _18243_/Y _17979_/A _18240_/Y _18254_/B _18498_/C VPWR VGND sg13g2_a22oi_1
X_15455_ _15466_/B _16790_/A _15455_/B VPWR VGND sg13g2_nor2_1
XFILLER_42_193 VPWR VGND sg13g2_decap_4
XFILLER_30_377 VPWR VGND sg13g2_decap_8
X_14406_ _24237_/D _14273_/Y _14571_/B _14571_/A VPWR VGND sg13g2_a21oi_1
XFILLER_50_1214 VPWR VGND sg13g2_fill_1
X_18174_ _18458_/B _18254_/A _18174_/B VPWR VGND sg13g2_and2_1
X_11618_ _11623_/A _14143_/C _14133_/A _11618_/C VPWR VGND sg13g2_nand3_1
X_12598_ _12598_/Y _12813_/S _23905_/Q _12597_/Y VPWR VGND sg13g2_o21ai_1
XFILLER_11_1209 VPWR VGND sg13g2_fill_1
X_17125_ _22729_/D _17226_/A _17123_/Y _17124_/Y VPWR VGND sg13g2_a21oi_1
XFILLER_11_591 VPWR VGND sg13g2_fill_2
XFILLER_7_540 VPWR VGND sg13g2_decap_8
X_11549_ _11549_/Y _13985_/B _11549_/B _11549_/C VPWR VGND sg13g2_nor3_1
XFILLER_89_1468 VPWR VGND sg13g2_fill_2
XFILLER_32_1692 VPWR VGND sg13g2_decap_8
X_17056_ _17113_/B _17056_/A _17056_/B _17056_/C VPWR VGND sg13g2_nand3_1
X_14268_ _16856_/C _14435_/B _14766_/B VPWR VGND sg13g2_nand2_1
XFILLER_100_1072 VPWR VGND sg13g2_decap_8
X_16007_ _16008_/D _22813_/Q _16007_/B VPWR VGND sg13g2_nand2_1
XFILLER_98_812 VPWR VGND sg13g2_fill_1
XFILLER_112_600 VPWR VGND sg13g2_decap_8
X_14199_ _14199_/Y _14782_/C _14187_/C _14198_/Y VPWR VGND sg13g2_a21oi_1
XFILLER_67_1777 VPWR VGND sg13g2_decap_8
XFILLER_83_1045 VPWR VGND sg13g2_fill_2
XFILLER_67_1788 VPWR VGND sg13g2_fill_2
XFILLER_98_845 VPWR VGND sg13g2_decap_4
XFILLER_67_1799 VPWR VGND sg13g2_fill_2
XFILLER_83_1078 VPWR VGND sg13g2_fill_2
XFILLER_100_806 VPWR VGND sg13g2_decap_8
XFILLER_112_677 VPWR VGND sg13g2_decap_8
XFILLER_111_154 VPWR VGND sg13g2_decap_8
XFILLER_26_1452 VPWR VGND sg13g2_fill_1
XFILLER_97_388 VPWR VGND sg13g2_fill_1
XFILLER_100_839 VPWR VGND sg13g2_decap_8
XFILLER_113_1433 VPWR VGND sg13g2_decap_4
XFILLER_78_591 VPWR VGND sg13g2_decap_8
XFILLER_18_0 VPWR VGND sg13g2_decap_8
XFILLER_39_956 VPWR VGND sg13g2_decap_8
X_16909_ _16910_/B _17030_/A _16954_/B VPWR VGND sg13g2_nor2_1
XFILLER_6_1568 VPWR VGND sg13g2_decap_8
XFILLER_93_550 VPWR VGND sg13g2_fill_2
X_17889_ _22927_/D _17889_/A VPWR VGND sg13g2_inv_1
XFILLER_61_1398 VPWR VGND sg13g2_fill_1
XFILLER_26_617 VPWR VGND sg13g2_decap_4
X_19628_ _19628_/Y _20329_/B2 _19613_/Y _19627_/Y VPWR VGND sg13g2_a21oi_1
XFILLER_78_1851 VPWR VGND sg13g2_fill_1
XFILLER_19_691 VPWR VGND sg13g2_fill_1
XFILLER_4_1292 VPWR VGND sg13g2_fill_1
XFILLER_53_436 VPWR VGND sg13g2_fill_2
XFILLER_65_296 VPWR VGND sg13g2_decap_4
XFILLER_0_1134 VPWR VGND sg13g2_fill_2
XFILLER_80_233 VPWR VGND sg13g2_decap_8
X_19559_ _19559_/X _19386_/B _19389_/Y _19584_/S VPWR VGND sg13g2_mux2_1
XFILLER_80_255 VPWR VGND sg13g2_fill_1
XFILLER_59_1261 VPWR VGND sg13g2_fill_2
XFILLER_80_266 VPWR VGND sg13g2_decap_8
XFILLER_78_1895 VPWR VGND sg13g2_decap_8
XFILLER_90_1005 VPWR VGND sg13g2_decap_4
X_22570_ _22570_/Q _23029_/CLK _22570_/D fanout2808/X VPWR VGND sg13g2_dfrbpq_1
XFILLER_90_1038 VPWR VGND sg13g2_decap_8
XFILLER_22_856 VPWR VGND sg13g2_fill_2
X_21521_ _23776_/D _21948_/A1 _21539_/B _21520_/Y VPWR VGND sg13g2_o21ai_1
XFILLER_72_1450 VPWR VGND sg13g2_decap_4
XFILLER_37_1592 VPWR VGND sg13g2_fill_1
XFILLER_21_377 VPWR VGND sg13g2_decap_4
X_24240_ _24240_/Q clkload27/A _24240_/D fanout2856/X VPWR VGND sg13g2_dfrbpq_1
XFILLER_72_1483 VPWR VGND sg13g2_decap_8
X_21452_ _21452_/Y _23744_/Q _21456_/B VPWR VGND sg13g2_nand2_1
Xplace3120 _21271_/B _21266_/B VPWR VGND sg13g2_buf_1
XFILLER_33_1467 VPWR VGND sg13g2_fill_2
Xplace3131 _20936_/B _20930_/B VPWR VGND sg13g2_buf_1
Xplace3142 _20902_/S _20919_/B VPWR VGND sg13g2_buf_1
X_20403_ _23265_/D _22416_/A1 _20404_/B _20402_/Y VPWR VGND sg13g2_o21ai_1
X_24171_ _24171_/Q clkload38/A _24171_/D fanout2634/X VPWR VGND sg13g2_dfrbpq_1
Xplace3153 _20841_/B _20847_/B VPWR VGND sg13g2_buf_1
X_21383_ _21383_/Y _23711_/Q _21389_/B VPWR VGND sg13g2_nand2_1
Xplace3164 _20713_/B _20710_/B VPWR VGND sg13g2_buf_1
Xplace3175 _20646_/S _20640_/S VPWR VGND sg13g2_buf_1
XFILLER_68_1519 VPWR VGND sg13g2_decap_8
X_23122_ _23122_/Q _23215_/CLK _23122_/D fanout2924/X VPWR VGND sg13g2_dfrbpq_1
Xplace3186 _20451_/B _20512_/B VPWR VGND sg13g2_buf_1
XFILLER_107_449 VPWR VGND sg13g2_decap_8
Xplace3197 _20426_/B _20429_/B VPWR VGND sg13g2_buf_1
X_20334_ _20342_/A _20334_/A _20334_/B VPWR VGND sg13g2_nor2_1
XFILLER_85_1833 VPWR VGND sg13g2_decap_8
XFILLER_66_1221 VPWR VGND sg13g2_fill_2
X_23053_ _23053_/Q clkload12/A _23053_/D fanout2912/X VPWR VGND sg13g2_dfrbpq_1
X_20265_ _20265_/Y _20265_/A _20265_/B _20265_/C _20265_/D VPWR VGND sg13g2_nand4_1
XFILLER_115_460 VPWR VGND sg13g2_decap_8
XFILLER_103_611 VPWR VGND sg13g2_decap_8
XFILLER_0_215 VPWR VGND sg13g2_fill_2
X_22004_ _23996_/D _19891_/Y _22003_/B _22003_/Y VPWR VGND sg13g2_o21ai_1
XFILLER_62_1118 VPWR VGND sg13g2_fill_1
XFILLER_66_1287 VPWR VGND sg13g2_fill_2
X_20196_ _20196_/Y _13370_/B _20233_/A2 _20195_/Y VPWR VGND sg13g2_o21ai_1
XFILLER_89_878 VPWR VGND sg13g2_decap_8
XFILLER_76_528 VPWR VGND sg13g2_decap_8
XFILLER_9_1170 VPWR VGND sg13g2_decap_8
XFILLER_102_176 VPWR VGND sg13g2_decap_8
XFILLER_5_1034 VPWR VGND sg13g2_decap_8
XFILLER_40_1427 VPWR VGND sg13g2_fill_2
X_23955_ _23955_/Q clkload51/A _23955_/D fanout2667/X VPWR VGND sg13g2_dfrbpq_1
XFILLER_2_1911 VPWR VGND sg13g2_decap_8
XFILLER_84_561 VPWR VGND sg13g2_fill_1
XFILLER_22_1850 VPWR VGND sg13g2_decap_8
XFILLER_56_68 VPWR VGND sg13g2_decap_8
X_22906_ _22906_/Q clkload8/A _22906_/D fanout2800/X VPWR VGND sg13g2_dfrbpq_1
XFILLER_56_274 VPWR VGND sg13g2_decap_8
XFILLER_72_723 VPWR VGND sg13g2_decap_4
XFILLER_29_499 VPWR VGND sg13g2_decap_8
X_23886_ _23886_/Q clkload49/A _23886_/D fanout2641/X VPWR VGND sg13g2_dfrbpq_1
XFILLER_16_127 VPWR VGND sg13g2_fill_1
XFILLER_112_63 VPWR VGND sg13g2_decap_8
X_22837_ _22837_/Q _22917_/CLK _22837_/D fanout2872/X VPWR VGND sg13g2_dfrbpq_1
XFILLER_25_650 VPWR VGND sg13g2_decap_8
XFILLER_72_45 VPWR VGND sg13g2_fill_2
X_13570_ _13571_/C _14143_/C _13904_/B VPWR VGND sg13g2_nand2_1
X_22768_ _22768_/Q _22869_/CLK _22768_/D fanout2797/X VPWR VGND sg13g2_dfrbpq_1
XFILLER_73_1236 VPWR VGND sg13g2_decap_4
XFILLER_52_480 VPWR VGND sg13g2_decap_4
XFILLER_24_182 VPWR VGND sg13g2_fill_1
XFILLER_72_78 VPWR VGND sg13g2_fill_2
X_12521_ _12521_/Y _14438_/B _14296_/A2 _12387_/X VPWR VGND sg13g2_a21oi_2
X_21719_ _21719_/Y _23868_/Q _21725_/B VPWR VGND sg13g2_nand2_1
XFILLER_51_1501 VPWR VGND sg13g2_fill_1
X_22699_ _22699_/Q _22733_/CLK _22699_/D fanout2882/X VPWR VGND sg13g2_dfrbpq_1
XFILLER_40_664 VPWR VGND sg13g2_decap_8
XFILLER_90_1572 VPWR VGND sg13g2_fill_1
X_15240_ _15252_/B _15447_/A _15447_/B _15447_/C VPWR VGND sg13g2_nor3_1
XFILLER_8_337 VPWR VGND sg13g2_decap_4
X_12452_ _12456_/B _12452_/A _12452_/B VPWR VGND sg13g2_nand2_1
XFILLER_90_1594 VPWR VGND sg13g2_decap_8
XFILLER_12_399 VPWR VGND sg13g2_fill_2
XFILLER_51_1556 VPWR VGND sg13g2_decap_8
X_11403_ _11403_/Y _11393_/Y _11396_/Y _11384_/Y _11398_/Y _11402_/Y VPWR VGND sg13g2_a221oi_1
X_15171_ _15177_/A _22717_/Q _15487_/A2 _15487_/B1 _22653_/Q VPWR VGND sg13g2_a22oi_1
X_12383_ _12383_/Y _12730_/S _12383_/B VPWR VGND sg13g2_nand2_1
X_14122_ _14122_/Y _14274_/A _14122_/B _14122_/C VPWR VGND sg13g2_nand3b_1
X_11334_ _11393_/A _22981_/Q VPWR VGND sg13g2_inv_2
XFILLER_10_1264 VPWR VGND sg13g2_decap_8
XFILLER_84_1332 VPWR VGND sg13g2_decap_8
X_18930_ _18931_/C _18959_/A _23083_/Q VPWR VGND sg13g2_nand2_1
X_14053_ _14053_/Y _14053_/A _14053_/B _14053_/C _14053_/D VPWR VGND sg13g2_nand4_1
X_11265_ _11265_/Y _22973_/Q _12471_/B _11984_/C VPWR VGND sg13g2_nand3_1
XFILLER_107_994 VPWR VGND sg13g2_decap_8
XFILLER_97_42 VPWR VGND sg13g2_decap_8
Xhold5090 _21574_/A _23803_/Q VPWR VGND sg13g2_dlygate4sd3_1
XFILLER_106_482 VPWR VGND sg13g2_decap_8
XFILLER_45_1305 VPWR VGND sg13g2_decap_8
X_13004_ _13004_/X _23430_/Q _23462_/Q _23494_/Q _23526_/Q _13004_/S0 _13004_/S1 VPWR
+ VGND sg13g2_mux4_1
XFILLER_45_1316 VPWR VGND sg13g2_fill_1
X_18861_ _18861_/Y _18016_/S _23044_/Q _18856_/B _17994_/B VPWR VGND sg13g2_a22oi_1
X_11196_ _14461_/B _22967_/Q _22966_/Q VPWR VGND sg13g2_or2_1
XFILLER_62_1630 VPWR VGND sg13g2_decap_4
X_17812_ _22907_/D _17811_/B _17810_/Y _17811_/Y VPWR VGND sg13g2_a21oi_1
XFILLER_23_1603 VPWR VGND sg13g2_fill_2
X_18792_ _18794_/B _18790_/Y _18791_/Y _18824_/S VPWR VGND sg13g2_mux2_1
XFILLER_7_1855 VPWR VGND sg13g2_decap_8
XFILLER_11_7 VPWR VGND sg13g2_decap_8
XFILLER_3_1708 VPWR VGND sg13g2_decap_8
XFILLER_97_1704 VPWR VGND sg13g2_decap_8
X_14955_ _14962_/A _22527_/Q _14990_/B VPWR VGND sg13g2_nand2_1
X_17743_ _17743_/Y _17164_/A _17824_/A2 _17824_/B1 _17742_/Y VPWR VGND sg13g2_a22oi_1
XFILLER_23_1669 VPWR VGND sg13g2_fill_1
XFILLER_114_1797 VPWR VGND sg13g2_decap_8
XFILLER_63_712 VPWR VGND sg13g2_fill_2
X_13906_ _20338_/B _13858_/A _13906_/A2 _13905_/Y VPWR VGND sg13g2_a21o_1
XFILLER_1_1432 VPWR VGND sg13g2_decap_4
X_19413_ _19413_/Y _13368_/A _19576_/B _19412_/Y VPWR VGND sg13g2_a21oi_1
XFILLER_78_1158 VPWR VGND sg13g2_decap_8
XFILLER_35_447 VPWR VGND sg13g2_fill_1
X_13837_ _13837_/X _24178_/Q _24210_/Q _23250_/Q _23282_/Q _13959_/S0 _13331_/S VPWR
+ VGND sg13g2_mux4_1
X_16625_ _16626_/B _22640_/Q _16625_/B VPWR VGND sg13g2_xnor2_1
XFILLER_63_778 VPWR VGND sg13g2_fill_2
XFILLER_62_255 VPWR VGND sg13g2_decap_8
XFILLER_62_277 VPWR VGND sg13g2_decap_4
X_19344_ _19650_/B _19339_/Y _19343_/Y _19584_/S VPWR VGND sg13g2_mux2_1
X_16556_ _16557_/B _22626_/Q _16556_/B VPWR VGND sg13g2_xnor2_1
XFILLER_50_428 VPWR VGND sg13g2_decap_8
XFILLER_95_1494 VPWR VGND sg13g2_fill_1
X_13768_ _13768_/Y _23569_/Q _13911_/A2 _13767_/X _13911_/B2 VPWR VGND sg13g2_a22oi_1
XFILLER_50_439 VPWR VGND sg13g2_fill_1
XFILLER_15_171 VPWR VGND sg13g2_decap_8
XFILLER_62_299 VPWR VGND sg13g2_decap_8
XFILLER_15_182 VPWR VGND sg13g2_decap_8
XFILLER_56_1467 VPWR VGND sg13g2_decap_4
X_15507_ _15508_/B _22692_/Q _16013_/A2 _16013_/B1 _22628_/Q VPWR VGND sg13g2_a22oi_1
X_12719_ _12719_/Y _24003_/Q _12721_/S VPWR VGND sg13g2_nand2b_1
X_19275_ _23196_/D _19274_/B _14631_/B _19274_/Y VPWR VGND sg13g2_o21ai_1
X_16487_ _16487_/Y _22606_/Q _16508_/B VPWR VGND sg13g2_nand2_1
X_13699_ _13699_/Y _13131_/A _13696_/X _13698_/X VPWR VGND sg13g2_a21oi_1
X_18226_ _18226_/Y _18238_/A _18197_/B _18290_/C VPWR VGND sg13g2_a21oi_1
XFILLER_50_1022 VPWR VGND sg13g2_decap_8
XFILLER_106_1270 VPWR VGND sg13g2_fill_2
X_15369_ _15369_/Y _22623_/Q _15323_/X _15325_/Y _22687_/Q VPWR VGND sg13g2_a22oi_1
XFILLER_7_62 VPWR VGND sg13g2_decap_4
XFILLER_7_84 VPWR VGND sg13g2_fill_2
X_17108_ _22726_/D _17113_/B _17106_/Y _17107_/Y VPWR VGND sg13g2_a21oi_1
X_18088_ _18088_/X _18595_/A1 _14470_/A _24226_/Q VPWR VGND sg13g2_a21o_1
XFILLER_89_1287 VPWR VGND sg13g2_fill_1
XFILLER_104_419 VPWR VGND sg13g2_decap_4
X_17039_ _17039_/Y _17039_/A _17039_/B VPWR VGND sg13g2_nor2_1
XFILLER_28_1503 VPWR VGND sg13g2_fill_1
XFILLER_113_953 VPWR VGND sg13g2_decap_4
XFILLER_8_1619 VPWR VGND sg13g2_decap_8
XFILLER_97_141 VPWR VGND sg13g2_decap_8
XFILLER_63_1449 VPWR VGND sg13g2_fill_1
XFILLER_112_474 VPWR VGND sg13g2_decap_8
XFILLER_6_1310 VPWR VGND sg13g2_decap_8
XFILLER_100_625 VPWR VGND sg13g2_decap_8
XFILLER_45_1872 VPWR VGND sg13g2_fill_1
XFILLER_58_539 VPWR VGND sg13g2_fill_1
XFILLER_41_1714 VPWR VGND sg13g2_decap_8
XFILLER_39_753 VPWR VGND sg13g2_decap_4
XFILLER_96_1203 VPWR VGND sg13g2_fill_2
XFILLER_94_870 VPWR VGND sg13g2_decap_8
XFILLER_27_926 VPWR VGND sg13g2_decap_8
X_23740_ _23740_/Q _23966_/CLK _23740_/D fanout2764/X VPWR VGND sg13g2_dfrbpq_1
XFILLER_66_572 VPWR VGND sg13g2_decap_8
X_20952_ _20952_/Y _20952_/A _20954_/B VPWR VGND sg13g2_nand2_1
XFILLER_38_274 VPWR VGND sg13g2_decap_8
XFILLER_26_27 VPWR VGND sg13g2_decap_8
XFILLER_81_542 VPWR VGND sg13g2_decap_8
X_23671_ _23671_/Q clkload58/A _23671_/D fanout2758/X VPWR VGND sg13g2_dfrbpq_1
XFILLER_81_553 VPWR VGND sg13g2_fill_2
X_20883_ _23487_/D _21317_/A1 _20888_/B _20882_/Y VPWR VGND sg13g2_o21ai_1
XFILLER_35_970 VPWR VGND sg13g2_decap_8
XFILLER_74_1512 VPWR VGND sg13g2_fill_1
X_22622_ _22622_/Q clkload24/A _22622_/D fanout2899/X VPWR VGND sg13g2_dfrbpq_1
XFILLER_107_1001 VPWR VGND sg13g2_decap_8
XFILLER_39_1698 VPWR VGND sg13g2_fill_1
XFILLER_70_1409 VPWR VGND sg13g2_decap_8
X_22553_ _22553_/Q clkload26/A _22553_/D fanout2852/X VPWR VGND sg13g2_dfrbpq_1
XFILLER_50_962 VPWR VGND sg13g2_decap_8
XFILLER_52_1810 VPWR VGND sg13g2_fill_2
XFILLER_17_1941 VPWR VGND sg13g2_decap_8
XFILLER_10_815 VPWR VGND sg13g2_fill_1
XFILLER_52_1821 VPWR VGND sg13g2_fill_2
X_21504_ _21504_/Y _21504_/A _21515_/B VPWR VGND sg13g2_nand2_1
XFILLER_104_1922 VPWR VGND sg13g2_decap_8
XFILLER_10_848 VPWR VGND sg13g2_decap_8
X_22484_ _22484_/Q clkload28/A _22484_/D fanout2829/X VPWR VGND sg13g2_dfrbpq_1
XFILLER_10_859 VPWR VGND sg13g2_fill_2
XFILLER_6_819 VPWR VGND sg13g2_decap_8
X_24223_ _24223_/Q clkload15/A _24223_/D fanout2854/X VPWR VGND sg13g2_dfrbpq_1
X_21435_ _23736_/D _21930_/A1 _21489_/B _21434_/Y VPWR VGND sg13g2_o21ai_1
XFILLER_33_1286 VPWR VGND sg13g2_fill_1
XFILLER_107_224 VPWR VGND sg13g2_fill_2
X_24154_ _24154_/Q clkload44/A _24154_/D fanout2751/X VPWR VGND sg13g2_dfrbpq_1
X_21366_ _23703_/D _21928_/A1 _21367_/B _21365_/Y VPWR VGND sg13g2_o21ai_1
XFILLER_107_257 VPWR VGND sg13g2_fill_2
X_23105_ _23105_/Q _23114_/CLK _23105_/D fanout2906/X VPWR VGND sg13g2_dfrbpq_1
X_20317_ _20317_/Y _20316_/X _20317_/B VPWR VGND sg13g2_nand2b_1
X_24085_ _24085_/Q clkload48/A _24085_/D fanout2681/X VPWR VGND sg13g2_dfrbpq_1
X_21297_ _23670_/D _21297_/A1 _21349_/S _21296_/Y VPWR VGND sg13g2_o21ai_1
X_23036_ _23036_/Q clkload13/A _23036_/D fanout2908/X VPWR VGND sg13g2_dfrbpq_1
XFILLER_85_1696 VPWR VGND sg13g2_fill_1
XFILLER_27_1024 VPWR VGND sg13g2_decap_8
X_20248_ _20248_/Y _24269_/A _20318_/B _20247_/Y VPWR VGND sg13g2_a21oi_1
XFILLER_107_63 VPWR VGND sg13g2_decap_8
XFILLER_103_441 VPWR VGND sg13g2_decap_8
XFILLER_46_1658 VPWR VGND sg13g2_decap_8
XFILLER_67_23 VPWR VGND sg13g2_decap_4
XFILLER_89_686 VPWR VGND sg13g2_fill_1
XFILLER_77_826 VPWR VGND sg13g2_decap_8
XFILLER_67_45 VPWR VGND sg13g2_decap_4
X_20179_ _20179_/Y _20179_/A _20179_/B VPWR VGND sg13g2_nand2_1
XFILLER_40_1202 VPWR VGND sg13g2_fill_1
XFILLER_111_1948 VPWR VGND sg13g2_decap_8
XFILLER_85_881 VPWR VGND sg13g2_decap_4
X_14740_ _19260_/B _14740_/A1 _19241_/A _23193_/Q VPWR VGND sg13g2_a21oi_1
X_11952_ _11953_/B _23706_/Q _23770_/Q _11960_/S VPWR VGND sg13g2_mux2_1
XFILLER_40_1268 VPWR VGND sg13g2_fill_1
X_23938_ _23938_/Q clkload43/A _23938_/D fanout2734/X VPWR VGND sg13g2_dfrbpq_1
XFILLER_18_948 VPWR VGND sg13g2_decap_8
XFILLER_57_594 VPWR VGND sg13g2_decap_8
XFILLER_79_1467 VPWR VGND sg13g2_fill_2
X_14671_ _14671_/Y _14711_/A1 _14714_/A2 _14670_/Y VPWR VGND sg13g2_o21ai_1
XFILLER_72_553 VPWR VGND sg13g2_decap_4
X_23869_ _23869_/Q _23966_/CLK _23869_/D fanout2785/X VPWR VGND sg13g2_dfrbpq_1
X_11883_ _11883_/Y _14039_/A _19727_/S VPWR VGND sg13g2_nor2_1
XFILLER_44_255 VPWR VGND sg13g2_fill_2
XFILLER_2_1785 VPWR VGND sg13g2_decap_8
XFILLER_45_789 VPWR VGND sg13g2_decap_8
XFILLER_109_1800 VPWR VGND sg13g2_fill_1
X_13622_ _13622_/Y _23567_/Q _13911_/A2 _13621_/X _13911_/B2 _13115_/A VPWR VGND sg13g2_a221oi_1
X_17390_ _17391_/C _17390_/A _17390_/B VPWR VGND sg13g2_nor2_1
XFILLER_25_491 VPWR VGND sg13g2_decap_8
XFILLER_109_1855 VPWR VGND sg13g2_decap_8
X_16341_ _16341_/Y _16340_/Y _15179_/A _16518_/C _22619_/Q VPWR VGND sg13g2_a22oi_1
XFILLER_18_1749 VPWR VGND sg13g2_decap_8
X_13553_ _13568_/A _13553_/A1 _13550_/X _13552_/X VPWR VGND sg13g2_o21ai_1
XFILLER_38_1186 VPWR VGND sg13g2_decap_4
XFILLER_8_112 VPWR VGND sg13g2_fill_1
X_19060_ _19060_/X _19121_/A1 _23099_/Q _19077_/S VPWR VGND sg13g2_mux2_1
X_12504_ _12505_/C _12504_/A _12504_/B _12504_/C _12504_/D VPWR VGND sg13g2_nor4_2
X_16272_ _16272_/Y _16304_/A _16271_/Y _14962_/B VPWR VGND sg13g2_o21ai_1
X_13484_ _13485_/B _13482_/X _13483_/X _13615_/S VPWR VGND sg13g2_mux2_1
XFILLER_70_1954 VPWR VGND sg13g2_fill_1
XFILLER_73_9 VPWR VGND sg13g2_fill_1
X_18011_ _18011_/Y _18009_/Y _18010_/Y _18030_/A VPWR VGND sg13g2_a21oi_1
X_12435_ _12436_/B _12435_/A _12435_/B VPWR VGND sg13g2_nand2_1
XFILLER_103_1443 VPWR VGND sg13g2_decap_8
XFILLER_103_1454 VPWR VGND sg13g2_fill_1
XFILLER_51_1397 VPWR VGND sg13g2_fill_2
X_15154_ _15178_/B _19673_/A _19728_/A VPWR VGND sg13g2_nand2_1
X_12366_ _12367_/B _23775_/Q _23935_/Q _12485_/S VPWR VGND sg13g2_mux2_1
XFILLER_86_1449 VPWR VGND sg13g2_decap_8
X_14105_ _14433_/A _14103_/Y _14104_/Y _14105_/S VPWR VGND sg13g2_mux2_1
X_11317_ _11317_/Y _11308_/X _11310_/Y _11314_/X _19235_/B _11316_/Y VPWR VGND sg13g2_a221oi_1
XFILLER_114_739 VPWR VGND sg13g2_decap_8
X_19962_ _19962_/Y _20294_/A _19962_/B VPWR VGND sg13g2_nor2_1
X_15085_ _15086_/B _22479_/Q _15114_/A2 _14966_/B VPWR VGND sg13g2_a21oi_1
XFILLER_4_362 VPWR VGND sg13g2_decap_8
X_12297_ _12298_/B _23710_/Q _23742_/Q _23774_/Q _23806_/Q _11855_/S _12297_/S1 VPWR
+ VGND sg13g2_mux4_1
XFILLER_113_238 VPWR VGND sg13g2_decap_8
XFILLER_84_1151 VPWR VGND sg13g2_decap_8
XFILLER_9_1906 VPWR VGND sg13g2_decap_8
X_14036_ _14036_/Y _14031_/Y _14036_/B _14036_/C VPWR VGND sg13g2_nand3b_1
X_18913_ _18914_/C _19023_/B _23049_/Q _19045_/C VPWR VGND sg13g2_or3_1
XFILLER_4_395 VPWR VGND sg13g2_decap_8
XFILLER_80_1004 VPWR VGND sg13g2_fill_1
X_11248_ _11270_/B _22970_/Q VPWR VGND sg13g2_inv_1
XFILLER_64_1736 VPWR VGND sg13g2_decap_8
XFILLER_29_1867 VPWR VGND sg13g2_decap_8
XFILLER_95_601 VPWR VGND sg13g2_fill_2
XFILLER_79_163 VPWR VGND sg13g2_decap_4
XFILLER_95_623 VPWR VGND sg13g2_decap_8
X_18844_ _23041_/D _18844_/A _18844_/B _18844_/C VPWR VGND sg13g2_nand3_1
X_11179_ _14121_/A _22967_/Q VPWR VGND sg13g2_inv_2
XFILLER_79_196 VPWR VGND sg13g2_decap_4
XFILLER_67_347 VPWR VGND sg13g2_decap_8
X_18775_ _18776_/C _23062_/Q _18825_/B VPWR VGND sg13g2_nand2_1
X_15987_ _15988_/A _22714_/Q _16013_/A2 _16013_/B1 _22650_/Q VPWR VGND sg13g2_a22oi_1
XFILLER_82_306 VPWR VGND sg13g2_fill_1
XFILLER_94_177 VPWR VGND sg13g2_decap_8
XFILLER_110_1425 VPWR VGND sg13g2_fill_1
X_17726_ _17726_/Y _17823_/A1 _17724_/X _17725_/Y VPWR VGND sg13g2_o21ai_1
XFILLER_94_199 VPWR VGND sg13g2_decap_4
X_14938_ _14939_/D _22495_/Q _15113_/B _15103_/B1 _22923_/Q VPWR VGND sg13g2_a22oi_1
XFILLER_23_1499 VPWR VGND sg13g2_decap_4
XFILLER_58_1529 VPWR VGND sg13g2_decap_8
XFILLER_97_1589 VPWR VGND sg13g2_decap_8
X_17657_ _17657_/Y _23167_/Q _17815_/A2 _17689_/B1 _17656_/X VPWR VGND sg13g2_a22oi_1
X_14869_ _14869_/X _23130_/Q _16250_/A _14982_/S VPWR VGND sg13g2_mux2_1
XFILLER_35_255 VPWR VGND sg13g2_fill_2
XFILLER_36_789 VPWR VGND sg13g2_decap_8
XFILLER_63_564 VPWR VGND sg13g2_fill_2
XFILLER_90_372 VPWR VGND sg13g2_fill_1
XFILLER_17_981 VPWR VGND sg13g2_decap_8
X_16608_ _16609_/B _22636_/Q _22635_/Q _22634_/Q _16635_/A VPWR VGND sg13g2_nand4_1
XFILLER_51_737 VPWR VGND sg13g2_decap_4
XFILLER_56_1220 VPWR VGND sg13g2_fill_1
XFILLER_17_992 VPWR VGND sg13g2_decap_8
X_17588_ _17588_/Y _17583_/Y _17587_/Y _17388_/Y VPWR VGND sg13g2_o21ai_1
XFILLER_51_759 VPWR VGND sg13g2_decap_8
XFILLER_36_1838 VPWR VGND sg13g2_fill_1
X_16539_ _22622_/D _16048_/X _16561_/A _16538_/Y VPWR VGND sg13g2_a21oi_1
XFILLER_91_1155 VPWR VGND sg13g2_decap_8
XFILLER_91_1166 VPWR VGND sg13g2_fill_2
XFILLER_31_461 VPWR VGND sg13g2_decap_8
XFILLER_85_0 VPWR VGND sg13g2_decap_8
XFILLER_104_1207 VPWR VGND sg13g2_decap_8
X_19258_ _19258_/Y _19263_/A _19240_/B _19252_/Y VPWR VGND sg13g2_o21ai_1
X_18209_ _18236_/B _18562_/B _18498_/A VPWR VGND sg13g2_nand2_1
X_19189_ _19189_/Y _23194_/Q _19186_/Y _19188_/Y VPWR VGND sg13g2_o21ai_1
XFILLER_30_1426 VPWR VGND sg13g2_decap_8
XFILLER_30_1437 VPWR VGND sg13g2_fill_2
Xoutput4477 data_addr_o[19] _24264_/X VPWR VGND sg13g2_buf_1
X_21220_ _23635_/D _23635_/Q _21781_/A1 _21220_/S VPWR VGND sg13g2_mux2_1
XFILLER_69_1625 VPWR VGND sg13g2_decap_8
Xoutput4488 data_addr_o[2] _24247_/X VPWR VGND sg13g2_buf_1
Xoutput4499 data_be_o[1] _14626_/Y VPWR VGND sg13g2_buf_1
X_21151_ _21151_/Y _23602_/Q _21151_/B VPWR VGND sg13g2_nand2_1
XFILLER_47_1923 VPWR VGND sg13g2_fill_2
XFILLER_47_1934 VPWR VGND sg13g2_decap_8
XFILLER_99_962 VPWR VGND sg13g2_fill_1
X_21082_ _21082_/Y _21848_/A _21082_/B VPWR VGND sg13g2_nand2_1
XFILLER_113_750 VPWR VGND sg13g2_decap_8
XFILLER_101_901 VPWR VGND sg13g2_decap_8
X_20033_ _20150_/B _20033_/A1 _19643_/Y _19663_/X VPWR VGND sg13g2_a21o_1
XFILLER_86_612 VPWR VGND sg13g2_fill_2
XFILLER_115_1325 VPWR VGND sg13g2_fill_2
XFILLER_28_1377 VPWR VGND sg13g2_fill_1
XFILLER_101_934 VPWR VGND sg13g2_decap_8
XFILLER_8_1449 VPWR VGND sg13g2_decap_4
XFILLER_101_945 VPWR VGND sg13g2_fill_1
XFILLER_112_282 VPWR VGND sg13g2_decap_4
XFILLER_101_956 VPWR VGND sg13g2_decap_8
XFILLER_74_807 VPWR VGND sg13g2_decap_8
XFILLER_85_144 VPWR VGND sg13g2_fill_2
XFILLER_41_1533 VPWR VGND sg13g2_decap_8
XFILLER_41_1544 VPWR VGND sg13g2_fill_1
XFILLER_73_306 VPWR VGND sg13g2_decap_8
XFILLER_67_892 VPWR VGND sg13g2_fill_1
XFILLER_27_734 VPWR VGND sg13g2_fill_2
XFILLER_39_594 VPWR VGND sg13g2_decap_4
X_21984_ _22045_/B _21984_/A _22252_/A VPWR VGND sg13g2_nand2_1
X_23723_ _23723_/Q clkload49/A _23723_/D fanout2674/X VPWR VGND sg13g2_dfrbpq_1
XFILLER_96_1055 VPWR VGND sg13g2_decap_4
X_20935_ _23513_/D _21237_/A1 _20936_/B _20934_/Y VPWR VGND sg13g2_o21ai_1
XFILLER_82_873 VPWR VGND sg13g2_fill_2
XFILLER_81_350 VPWR VGND sg13g2_decap_8
XFILLER_42_704 VPWR VGND sg13g2_decap_8
XFILLER_81_361 VPWR VGND sg13g2_fill_1
XFILLER_14_417 VPWR VGND sg13g2_decap_8
XFILLER_41_203 VPWR VGND sg13g2_fill_2
X_23654_ _23654_/Q clkload42/A _23654_/D fanout2720/X VPWR VGND sg13g2_dfrbpq_1
X_20866_ _20866_/Y _20866_/A _20874_/B VPWR VGND sg13g2_nand2_1
XFILLER_41_225 VPWR VGND sg13g2_decap_8
XFILLER_74_1331 VPWR VGND sg13g2_fill_1
XFILLER_74_1342 VPWR VGND sg13g2_decap_8
X_22605_ _22605_/Q clkload10/A _22605_/D fanout2813/X VPWR VGND sg13g2_dfrbpq_1
XFILLER_35_1315 VPWR VGND sg13g2_decap_4
XFILLER_39_1484 VPWR VGND sg13g2_fill_1
X_23585_ _23585_/Q _23682_/CLK _23585_/D fanout2725/X VPWR VGND sg13g2_dfrbpq_1
XFILLER_74_1375 VPWR VGND sg13g2_decap_4
X_20797_ _23448_/D _22396_/A1 _20801_/B _20796_/Y VPWR VGND sg13g2_o21ai_1
XFILLER_74_1397 VPWR VGND sg13g2_fill_2
X_22536_ _22536_/Q clkload6/A _22536_/D fanout2832/X VPWR VGND sg13g2_dfrbpq_1
XFILLER_13_1624 VPWR VGND sg13g2_decap_8
XFILLER_6_627 VPWR VGND sg13g2_fill_2
X_22467_ _22467_/Q clkload9/A _22467_/D fanout2823/X VPWR VGND sg13g2_dfrbpq_1
X_12220_ _12341_/A _12220_/A_N _13858_/A VPWR VGND sg13g2_nand2b_1
XFILLER_13_1668 VPWR VGND sg13g2_decap_8
XFILLER_6_649 VPWR VGND sg13g2_fill_2
X_24206_ _24206_/Q clkload38/A _24206_/D fanout2630/X VPWR VGND sg13g2_dfrbpq_1
X_21418_ _23729_/D _23729_/Q _21617_/A0 _21421_/S VPWR VGND sg13g2_mux2_1
XFILLER_104_1796 VPWR VGND sg13g2_decap_8
XFILLER_108_566 VPWR VGND sg13g2_decap_8
X_22398_ _22398_/Y _22398_/A _22408_/B VPWR VGND sg13g2_nand2_1
X_12151_ _12151_/Y _12266_/A _12151_/B VPWR VGND sg13g2_nor2_1
XFILLER_68_1157 VPWR VGND sg13g2_fill_2
X_24137_ _24137_/Q clkload46/A _24137_/D fanout2650/X VPWR VGND sg13g2_dfrbpq_1
X_21349_ _23697_/D _21617_/A0 _23697_/Q _21349_/S VPWR VGND sg13g2_mux2_1
XFILLER_11_1392 VPWR VGND sg13g2_decap_8
XFILLER_68_1168 VPWR VGND sg13g2_decap_8
Xfanout2803 fanout2803/X fanout2805/X VPWR VGND sg13g2_buf_1
Xfanout2814 fanout2814/X fanout2815/X VPWR VGND sg13g2_buf_1
XFILLER_111_709 VPWR VGND sg13g2_decap_8
X_12082_ _12091_/B _14038_/A _14038_/B _12082_/C _12082_/D VPWR VGND sg13g2_or4_1
Xfanout2825 fanout2825/X fanout2826/X VPWR VGND sg13g2_buf_1
X_24068_ _24068_/Q clkload37/A _24068_/D fanout2713/X VPWR VGND sg13g2_dfrbpq_1
Xfanout2836 fanout2836/X fanout2839/X VPWR VGND sg13g2_buf_1
XFILLER_81_1335 VPWR VGND sg13g2_fill_1
Xfanout2847 fanout2847/X fanout2848/X VPWR VGND sg13g2_buf_1
Xfanout2858 fanout2858/X fanout2860/X VPWR VGND sg13g2_buf_1
XFILLER_104_783 VPWR VGND sg13g2_fill_2
Xfanout2869 fanout2869/X fanout2878/X VPWR VGND sg13g2_buf_1
X_23019_ _23019_/Q clkload11/A _23019_/D fanout2808/X VPWR VGND sg13g2_dfrbpq_1
XFILLER_2_899 VPWR VGND sg13g2_fill_2
X_15910_ _15910_/Y _15980_/S _17197_/A _15909_/Y VPWR VGND sg13g2_o21ai_1
XFILLER_49_314 VPWR VGND sg13g2_decap_4
XFILLER_76_100 VPWR VGND sg13g2_decap_8
X_16890_ _16890_/Y _17316_/A1 _16895_/S VPWR VGND sg13g2_nand2b_1
XFILLER_1_387 VPWR VGND sg13g2_fill_1
XFILLER_46_1488 VPWR VGND sg13g2_fill_1
XFILLER_111_1701 VPWR VGND sg13g2_decap_4
XFILLER_77_678 VPWR VGND sg13g2_decap_4
XFILLER_18_701 VPWR VGND sg13g2_fill_2
XFILLER_77_689 VPWR VGND sg13g2_decap_8
XFILLER_111_1734 VPWR VGND sg13g2_decap_8
X_18560_ _18560_/X _17980_/X _18866_/B _18560_/S VPWR VGND sg13g2_mux2_1
XFILLER_4_1858 VPWR VGND sg13g2_decap_8
XFILLER_92_648 VPWR VGND sg13g2_decap_8
X_12984_ _12989_/C _12873_/A _12981_/X _12983_/X VPWR VGND sg13g2_o21ai_1
X_15772_ _15773_/D _15667_/B _15766_/Y _15771_/Y VPWR VGND sg13g2_a21oi_1
XFILLER_111_1767 VPWR VGND sg13g2_decap_8
XFILLER_94_98 VPWR VGND sg13g2_decap_8
X_17511_ _22872_/D _16154_/X _17512_/S _17510_/Y VPWR VGND sg13g2_o21ai_1
XFILLER_94_1718 VPWR VGND sg13g2_decap_8
X_11935_ _11935_/Y _11502_/A _12551_/C _11234_/X _12870_/B VPWR VGND sg13g2_a22oi_1
XFILLER_94_1729 VPWR VGND sg13g2_decap_4
X_18491_ _18491_/X _18491_/A _18834_/B VPWR VGND sg13g2_or2_1
XFILLER_75_1106 VPWR VGND sg13g2_decap_4
XFILLER_60_501 VPWR VGND sg13g2_decap_8
XFILLER_32_203 VPWR VGND sg13g2_fill_1
XFILLER_33_726 VPWR VGND sg13g2_fill_1
X_14654_ _14654_/Y _14696_/A _14686_/B VPWR VGND sg13g2_nor2_1
XFILLER_109_1630 VPWR VGND sg13g2_decap_8
XFILLER_14_940 VPWR VGND sg13g2_decap_8
X_13605_ _13605_/X _23855_/Q _23887_/Q _23951_/Q _23983_/Q _13606_/S0 _13606_/S1 VPWR
+ VGND sg13g2_mux4_1
XFILLER_14_951 VPWR VGND sg13g2_fill_1
XFILLER_14_962 VPWR VGND sg13g2_decap_8
XFILLER_32_269 VPWR VGND sg13g2_fill_1
X_14585_ _19241_/A _14591_/B _14585_/B VPWR VGND sg13g2_nand2_1
X_17373_ _17385_/S _17373_/A _17835_/B VPWR VGND sg13g2_and2_1
X_11797_ _11798_/B _23449_/Q _23513_/Q _11797_/S VPWR VGND sg13g2_mux2_1
XFILLER_13_450 VPWR VGND sg13g2_fill_1
X_19112_ _19112_/X _19028_/A _23124_/Q _19114_/S VPWR VGND sg13g2_mux2_1
X_16324_ _16331_/B _16324_/A _16324_/B _16324_/C _16324_/D VPWR VGND sg13g2_nor4_2
XFILLER_41_792 VPWR VGND sg13g2_decap_8
X_13536_ _19489_/A _14090_/A _14090_/B VPWR VGND sg13g2_nor2_1
Xplace3708 _20258_/A _13602_/A VPWR VGND sg13g2_buf_1
Xplace3719 _19928_/A _12514_/B VPWR VGND sg13g2_buf_2
X_16255_ _16255_/Y _22522_/Q _16273_/C VPWR VGND sg13g2_nand2_1
XFILLER_16_1270 VPWR VGND sg13g2_decap_8
X_19043_ _19043_/Y _19043_/A _19043_/B VPWR VGND sg13g2_nand2_1
X_13467_ _13468_/B _13463_/X _13464_/X _13465_/X _13466_/X _14758_/A _13131_/A VPWR
+ VGND sg13g2_mux4_1
XFILLER_31_1735 VPWR VGND sg13g2_fill_2
XFILLER_103_1251 VPWR VGND sg13g2_fill_2
X_12418_ _12535_/B _19953_/B _12418_/B VPWR VGND sg13g2_xnor2_1
X_16186_ _22508_/D _16193_/B _16184_/Y _16185_/Y VPWR VGND sg13g2_o21ai_1
XFILLER_103_1284 VPWR VGND sg13g2_fill_2
XFILLER_86_1224 VPWR VGND sg13g2_fill_1
X_13398_ _13398_/X _24044_/Q _24108_/Q _13398_/S VPWR VGND sg13g2_mux2_1
XFILLER_12_1178 VPWR VGND sg13g2_decap_8
X_15137_ _15137_/Y _22549_/Q _16023_/B VPWR VGND sg13g2_nand2_1
X_12349_ _12349_/Y _12535_/A _14340_/A _12532_/B VPWR VGND sg13g2_nor3_1
XFILLER_114_536 VPWR VGND sg13g2_decap_8
X_15068_ _15068_/Y _15068_/A _15068_/B _15068_/C VPWR VGND sg13g2_nand3_1
X_19945_ _19945_/Y _19945_/A VPWR VGND sg13g2_inv_1
XFILLER_29_1642 VPWR VGND sg13g2_decap_8
X_14019_ _14024_/A _15289_/A _14019_/B VPWR VGND sg13g2_xnor2_1
XFILLER_64_1555 VPWR VGND sg13g2_decap_4
X_19876_ _19877_/B _20080_/A _19873_/Y _19875_/Y VPWR VGND sg13g2_a21oi_1
XFILLER_96_965 VPWR VGND sg13g2_decap_8
XFILLER_42_1831 VPWR VGND sg13g2_decap_8
X_18827_ _18832_/A _23039_/Q _18827_/B _18865_/C VPWR VGND sg13g2_nand3_1
XFILLER_56_807 VPWR VGND sg13g2_decap_4
XFILLER_95_475 VPWR VGND sg13g2_decap_8
XFILLER_49_881 VPWR VGND sg13g2_decap_8
X_18758_ _18758_/Y _16424_/A _18756_/B _18651_/B VPWR VGND sg13g2_o21ai_1
XFILLER_97_1331 VPWR VGND sg13g2_decap_8
X_17709_ _17709_/Y _23172_/Q _17734_/A2 _17706_/X _17709_/B2 VPWR VGND sg13g2_a22oi_1
XFILLER_64_862 VPWR VGND sg13g2_fill_1
XFILLER_110_1266 VPWR VGND sg13g2_fill_2
X_18689_ _18689_/Y _18689_/A _18689_/B VPWR VGND sg13g2_nand2_1
XFILLER_36_564 VPWR VGND sg13g2_fill_1
XFILLER_63_350 VPWR VGND sg13g2_fill_1
XFILLER_110_1288 VPWR VGND sg13g2_decap_8
XFILLER_51_545 VPWR VGND sg13g2_fill_2
XFILLER_75_1662 VPWR VGND sg13g2_decap_4
XFILLER_36_1624 VPWR VGND sg13g2_fill_2
XFILLER_23_269 VPWR VGND sg13g2_fill_2
XFILLER_23_17 VPWR VGND sg13g2_decap_8
XFILLER_108_1151 VPWR VGND sg13g2_decap_8
XFILLER_20_921 VPWR VGND sg13g2_fill_1
XFILLER_108_1162 VPWR VGND sg13g2_fill_2
XFILLER_32_781 VPWR VGND sg13g2_decap_8
X_23370_ _23370_/Q clkload34/A _23370_/D fanout2696/X VPWR VGND sg13g2_dfrbpq_1
XFILLER_14_1900 VPWR VGND sg13g2_decap_8
XFILLER_32_792 VPWR VGND sg13g2_decap_8
XFILLER_20_943 VPWR VGND sg13g2_fill_2
X_20582_ _23348_/D _22451_/A1 _20516_/Y _20581_/Y VPWR VGND sg13g2_o21ai_1
XFILLER_31_280 VPWR VGND sg13g2_decap_4
XFILLER_17_1078 VPWR VGND sg13g2_decap_8
XFILLER_17_1089 VPWR VGND sg13g2_decap_8
XFILLER_30_1212 VPWR VGND sg13g2_fill_2
XFILLER_101_1936 VPWR VGND sg13g2_decap_8
X_22252_ _22316_/B _22252_/A _22252_/B VPWR VGND sg13g2_nand2_1
XFILLER_30_1278 VPWR VGND sg13g2_decap_8
Xhold4900 _22136_/A _24059_/Q VPWR VGND sg13g2_dlygate4sd3_1
X_21203_ _23624_/D _23624_/Q _21335_/A0 _21220_/S VPWR VGND sg13g2_mux2_1
Xhold4911 _21655_/A _23841_/Q VPWR VGND sg13g2_dlygate4sd3_1
XFILLER_69_1466 VPWR VGND sg13g2_fill_1
X_22183_ _24083_/D _24083_/Q _22449_/A1 _22183_/S VPWR VGND sg13g2_mux2_1
XFILLER_12_1690 VPWR VGND sg13g2_decap_8
Xhold4922 _21318_/A _23680_/Q VPWR VGND sg13g2_dlygate4sd3_1
Xhold4933 _17346_/A _22800_/Q VPWR VGND sg13g2_dlygate4sd3_1
XFILLER_105_558 VPWR VGND sg13g2_decap_8
Xhold4944 _22117_/A _24052_/Q VPWR VGND sg13g2_dlygate4sd3_1
X_21134_ _21153_/S _22363_/B _21201_/B VPWR VGND sg13g2_nor2_1
Xhold4955 _21539_/A _23786_/Q VPWR VGND sg13g2_dlygate4sd3_1
XFILLER_86_1791 VPWR VGND sg13g2_decap_8
Xhold4966 _21380_/A _23710_/Q VPWR VGND sg13g2_dlygate4sd3_1
Xhold4977 _20240_/A _23244_/Q VPWR VGND sg13g2_dlygate4sd3_1
XFILLER_59_601 VPWR VGND sg13g2_decap_8
Xhold4988 _21376_/A _23708_/Q VPWR VGND sg13g2_dlygate4sd3_1
XFILLER_87_921 VPWR VGND sg13g2_decap_4
XFILLER_48_14 VPWR VGND sg13g2_fill_1
XFILLER_63_1032 VPWR VGND sg13g2_decap_8
Xhold4999 _20749_/A _23425_/Q VPWR VGND sg13g2_dlygate4sd3_1
XFILLER_82_1666 VPWR VGND sg13g2_fill_2
X_21065_ _23563_/D _22437_/A1 _21079_/B _21064_/Y VPWR VGND sg13g2_o21ai_1
XFILLER_87_943 VPWR VGND sg13g2_decap_8
XFILLER_47_1797 VPWR VGND sg13g2_fill_1
XFILLER_58_111 VPWR VGND sg13g2_fill_2
XFILLER_43_1639 VPWR VGND sg13g2_decap_8
XFILLER_59_667 VPWR VGND sg13g2_decap_8
X_20016_ _20016_/Y _20016_/A _20016_/B _20016_/C VPWR VGND sg13g2_nand3_1
XFILLER_24_1049 VPWR VGND sg13g2_decap_8
XFILLER_59_678 VPWR VGND sg13g2_fill_1
XFILLER_115_1166 VPWR VGND sg13g2_decap_8
XFILLER_46_317 VPWR VGND sg13g2_decap_8
XFILLER_74_626 VPWR VGND sg13g2_decap_4
XFILLER_115_1199 VPWR VGND sg13g2_decap_8
XFILLER_104_42 VPWR VGND sg13g2_decap_8
XFILLER_86_497 VPWR VGND sg13g2_decap_4
XFILLER_74_637 VPWR VGND sg13g2_decap_8
XFILLER_55_851 VPWR VGND sg13g2_decap_4
X_21967_ _23978_/D _22033_/A1 _21976_/B _21966_/Y VPWR VGND sg13g2_o21ai_1
XFILLER_15_715 VPWR VGND sg13g2_fill_1
XFILLER_82_670 VPWR VGND sg13g2_fill_1
XFILLER_54_361 VPWR VGND sg13g2_decap_8
X_23706_ _23706_/Q clkload58/A _23706_/D fanout2754/X VPWR VGND sg13g2_dfrbpq_1
X_11720_ _11725_/B _13212_/A _11720_/B VPWR VGND sg13g2_nor2_1
X_20918_ _23507_/D _22315_/A0 _23507_/Q _20918_/S VPWR VGND sg13g2_mux2_1
XFILLER_93_1740 VPWR VGND sg13g2_decap_8
XFILLER_15_748 VPWR VGND sg13g2_decap_8
X_21898_ _23944_/D _21898_/A0 _23944_/Q _21915_/S VPWR VGND sg13g2_mux2_1
XFILLER_30_707 VPWR VGND sg13g2_decap_4
X_23637_ _23637_/Q clkload52/A _23637_/D fanout2756/X VPWR VGND sg13g2_dfrbpq_1
XFILLER_14_258 VPWR VGND sg13g2_decap_8
XFILLER_42_567 VPWR VGND sg13g2_fill_2
X_20849_ _23473_/D _23473_/Q _21978_/A0 _20852_/S VPWR VGND sg13g2_mux2_1
XFILLER_54_1746 VPWR VGND sg13g2_decap_8
XFILLER_106_1825 VPWR VGND sg13g2_decap_8
XFILLER_19_1877 VPWR VGND sg13g2_decap_8
X_14370_ _15172_/B _19673_/A _19728_/A _19777_/A _15193_/C VPWR VGND sg13g2_nand4_1
X_11582_ _14118_/B _11861_/B _22994_/Q VPWR VGND sg13g2_nand2b_1
X_23568_ _23568_/Q _24210_/CLK _23568_/D fanout2636/X VPWR VGND sg13g2_dfrbpq_1
XFILLER_11_954 VPWR VGND sg13g2_fill_1
XFILLER_80_78 VPWR VGND sg13g2_decap_8
XFILLER_13_1410 VPWR VGND sg13g2_fill_2
X_13321_ _13321_/Y _13320_/X _13985_/B VPWR VGND sg13g2_nand2b_1
XFILLER_13_50 VPWR VGND sg13g2_fill_1
X_22519_ _22519_/Q clkload11/A _22519_/D fanout2837/X VPWR VGND sg13g2_dfrbpq_1
XFILLER_52_1470 VPWR VGND sg13g2_fill_1
X_23499_ _23499_/Q clkload38/A _23499_/D fanout2638/X VPWR VGND sg13g2_dfrbpq_1
XFILLER_52_1481 VPWR VGND sg13g2_decap_8
XFILLER_10_475 VPWR VGND sg13g2_decap_4
X_13252_ _13252_/Y _13253_/S _24074_/Q _13251_/Y VPWR VGND sg13g2_o21ai_1
XFILLER_104_1582 VPWR VGND sg13g2_decap_8
XFILLER_89_21 VPWR VGND sg13g2_fill_2
XFILLER_87_1522 VPWR VGND sg13g2_fill_1
XFILLER_6_468 VPWR VGND sg13g2_decap_8
X_12203_ _12204_/B _24189_/Q _23261_/Q _12203_/S VPWR VGND sg13g2_mux2_1
XFILLER_108_396 VPWR VGND sg13g2_decap_8
X_12134_ _12135_/B _23452_/Q _23516_/Q _12134_/S VPWR VGND sg13g2_mux2_1
XFILLER_65_1831 VPWR VGND sg13g2_fill_2
XFILLER_111_506 VPWR VGND sg13g2_decap_8
Xfanout2622 fanout2622/X fanout2625/X VPWR VGND sg13g2_buf_1
Xfanout2633 fanout2633/X fanout2637/X VPWR VGND sg13g2_buf_1
XFILLER_78_921 VPWR VGND sg13g2_fill_2
X_19730_ _19732_/A _11882_/C _19803_/B _20356_/B _19729_/Y VPWR VGND sg13g2_a22oi_1
XFILLER_81_1132 VPWR VGND sg13g2_fill_2
Xfanout2644 fanout2644/X fanout2792/X VPWR VGND sg13g2_buf_1
XFILLER_46_1252 VPWR VGND sg13g2_decap_8
Xfanout2655 fanout2655/X fanout2668/X VPWR VGND sg13g2_buf_1
X_16942_ _16947_/A _22699_/Q VPWR VGND sg13g2_inv_1
X_12065_ _12066_/C _12065_/A _12065_/B _12065_/C _12065_/D VPWR VGND sg13g2_or4_1
Xfanout2666 fanout2666/X fanout2667/X VPWR VGND sg13g2_buf_1
Xfanout2677 fanout2677/X fanout2678/X VPWR VGND sg13g2_buf_1
Xfanout2688 fanout2688/X fanout2690/X VPWR VGND sg13g2_buf_1
XFILLER_113_1829 VPWR VGND sg13g2_decap_8
X_19661_ _19661_/Y _19874_/B _19560_/X _19538_/A VPWR VGND sg13g2_a21oi_1
Xfanout2699 fanout2699/X fanout2701/X VPWR VGND sg13g2_buf_1
XFILLER_92_412 VPWR VGND sg13g2_decap_8
X_18612_ _18613_/B _23000_/Q _18616_/D VPWR VGND sg13g2_nand2_1
X_15824_ _22473_/D _15981_/S _15821_/Y _15823_/Y VPWR VGND sg13g2_a21oi_1
X_19592_ _19592_/Y _19703_/A _19704_/B _19591_/Y VPWR VGND sg13g2_a21oi_1
XFILLER_24_1594 VPWR VGND sg13g2_fill_1
XFILLER_65_659 VPWR VGND sg13g2_decap_4
XFILLER_18_542 VPWR VGND sg13g2_decap_8
X_18543_ _18544_/B _18494_/A _18334_/A _18538_/X _18301_/B VPWR VGND sg13g2_a22oi_1
XFILLER_64_158 VPWR VGND sg13g2_decap_8
X_12967_ _12968_/C _12965_/X _12966_/X _12955_/X VPWR VGND sg13g2_o21ai_1
X_15755_ _15755_/Y _20166_/A _15963_/B VPWR VGND sg13g2_nor2_1
XFILLER_111_1586 VPWR VGND sg13g2_decap_8
XFILLER_20_1469 VPWR VGND sg13g2_decap_8
XFILLER_59_1646 VPWR VGND sg13g2_decap_8
XFILLER_18_586 VPWR VGND sg13g2_decap_8
X_14706_ _14706_/Y _14706_/A _14710_/B VPWR VGND sg13g2_nor2_1
XFILLER_94_1559 VPWR VGND sg13g2_decap_8
X_18474_ _18514_/A _18554_/A1 _18334_/A _18269_/A VPWR VGND sg13g2_a21oi_1
X_15686_ _15688_/C _22926_/Q _15924_/B _15767_/B _22498_/Q VPWR VGND sg13g2_a22oi_1
X_12898_ _12898_/Y _13120_/A _13350_/A VPWR VGND sg13g2_nor2_1
XFILLER_72_1802 VPWR VGND sg13g2_fill_1
X_17425_ _17425_/Y _22832_/Q _17425_/B VPWR VGND sg13g2_nand2_1
XFILLER_61_876 VPWR VGND sg13g2_decap_4
X_11849_ _11850_/B _23833_/Q _23865_/Q _11855_/S VPWR VGND sg13g2_mux2_1
X_14637_ _14637_/Y _19238_/A _14637_/B VPWR VGND sg13g2_nand2_1
XFILLER_57_1370 VPWR VGND sg13g2_decap_4
XFILLER_53_1212 VPWR VGND sg13g2_decap_8
XFILLER_60_364 VPWR VGND sg13g2_decap_8
Xplace4206 _13193_/S0 _13961_/S0 VPWR VGND sg13g2_buf_2
XFILLER_105_1302 VPWR VGND sg13g2_decap_8
Xplace4217 _11465_/A _11688_/A VPWR VGND sg13g2_buf_1
XFILLER_33_1819 VPWR VGND sg13g2_fill_1
X_17356_ _17356_/Y _17356_/A _17358_/B VPWR VGND sg13g2_nand2_1
Xplace4228 _11774_/A _22982_/Q VPWR VGND sg13g2_buf_2
XFILLER_13_280 VPWR VGND sg13g2_decap_8
Xplace4239 _12039_/A _12285_/A VPWR VGND sg13g2_buf_1
Xrebuffer5218 _20123_/A1 _14064_/A VPWR VGND sg13g2_buf_1
Xplace3505 _20266_/B2 _20201_/B VPWR VGND sg13g2_buf_1
Xrebuffer5229 _14706_/A _12585_/B2 VPWR VGND sg13g2_buf_1
Xplace3516 _19221_/S _19209_/S VPWR VGND sg13g2_buf_1
XFILLER_9_262 VPWR VGND sg13g2_decap_8
Xplace3527 _15940_/B _15312_/Y VPWR VGND sg13g2_buf_1
X_13519_ _13519_/Y _13949_/C _13519_/B VPWR VGND sg13g2_nor2_1
Xplace3538 _19169_/S _19176_/B VPWR VGND sg13g2_buf_1
X_17287_ _17287_/Y _17287_/A _17293_/B VPWR VGND sg13g2_nand2_1
XFILLER_35_1690 VPWR VGND sg13g2_decap_4
X_14499_ _14508_/B _22613_/Q _23024_/Q VPWR VGND sg13g2_xnor2_1
XFILLER_88_1319 VPWR VGND sg13g2_fill_1
XFILLER_9_284 VPWR VGND sg13g2_decap_4
Xplace3549 _15767_/B _15309_/Y VPWR VGND sg13g2_buf_1
XFILLER_70_1581 VPWR VGND sg13g2_decap_4
Xclkload10 clkload10/Y clkload10/A VPWR VGND sg13g2_inv_2
Xclkload21 clkload21/Y clkload21/A VPWR VGND sg13g2_inv_4
X_19026_ _19026_/Y _23059_/Q _19019_/A _19048_/B1 VPWR VGND sg13g2_o21ai_1
X_16238_ _16238_/Y _22518_/Q _16241_/C _16237_/Y VPWR VGND sg13g2_o21ai_1
Xclkload32 clkload32/Y clkload32/A VPWR VGND sg13g2_inv_2
XFILLER_86_1010 VPWR VGND sg13g2_decap_8
Xclkload43 clkload43/X clkload43/A VPWR VGND sg13g2_buf_8
Xclkload54 clkload54/Y clkload54/A VPWR VGND sg13g2_inv_2
XFILLER_86_1043 VPWR VGND sg13g2_fill_2
X_16169_ _16169_/Y _16169_/A _16187_/B VPWR VGND sg13g2_nor2_1
XFILLER_115_845 VPWR VGND sg13g2_decap_8
XFILLER_86_1065 VPWR VGND sg13g2_decap_4
XFILLER_47_1016 VPWR VGND sg13g2_decap_4
XFILLER_88_707 VPWR VGND sg13g2_fill_2
XFILLER_83_1920 VPWR VGND sg13g2_fill_2
XFILLER_48_0 VPWR VGND sg13g2_decap_8
XFILLER_64_1330 VPWR VGND sg13g2_decap_8
XFILLER_29_1461 VPWR VGND sg13g2_fill_1
X_19928_ _19928_/Y _19928_/A _19928_/B _19930_/B VPWR VGND sg13g2_nand3_1
XFILLER_25_1347 VPWR VGND sg13g2_decap_8
XFILLER_110_550 VPWR VGND sg13g2_decap_8
XFILLER_96_773 VPWR VGND sg13g2_fill_2
XFILLER_84_924 VPWR VGND sg13g2_decap_4
XFILLER_112_1328 VPWR VGND sg13g2_fill_2
XFILLER_18_28 VPWR VGND sg13g2_decap_8
XFILLER_83_423 VPWR VGND sg13g2_decap_8
XFILLER_3_1110 VPWR VGND sg13g2_fill_1
X_22870_ _22870_/Q clkload10/A _22870_/D fanout2814/X VPWR VGND sg13g2_dfrbpq_1
XFILLER_56_648 VPWR VGND sg13g2_fill_2
XFILLER_95_294 VPWR VGND sg13g2_decap_8
XFILLER_23_1060 VPWR VGND sg13g2_decap_8
X_21821_ _23907_/D _22288_/A1 _21833_/B _21820_/Y VPWR VGND sg13g2_o21ai_1
XFILLER_3_1165 VPWR VGND sg13g2_decap_8
XFILLER_58_1101 VPWR VGND sg13g2_decap_8
XFILLER_110_1052 VPWR VGND sg13g2_fill_1
XFILLER_24_501 VPWR VGND sg13g2_fill_2
XFILLER_52_810 VPWR VGND sg13g2_fill_1
XFILLER_70_117 VPWR VGND sg13g2_decap_8
XFILLER_70_128 VPWR VGND sg13g2_fill_1
XFILLER_93_1025 VPWR VGND sg13g2_decap_8
X_21752_ _23878_/D _22294_/A1 _21751_/B _21751_/Y VPWR VGND sg13g2_o21ai_1
XFILLER_51_342 VPWR VGND sg13g2_fill_2
X_20703_ _23405_/D _22373_/A1 _23405_/Q _20706_/S VPWR VGND sg13g2_mux2_1
X_21683_ _23855_/D _23855_/Q _21975_/A0 _21689_/S VPWR VGND sg13g2_mux2_1
XFILLER_12_729 VPWR VGND sg13g2_fill_2
XFILLER_71_1301 VPWR VGND sg13g2_decap_8
XFILLER_11_217 VPWR VGND sg13g2_decap_8
X_23422_ _23422_/Q clkload53/A _23422_/D fanout2777/X VPWR VGND sg13g2_dfrbpq_1
XFILLER_36_1454 VPWR VGND sg13g2_decap_4
X_20634_ _23371_/D _20700_/A1 _20647_/B _20633_/Y VPWR VGND sg13g2_o21ai_1
XFILLER_51_1919 VPWR VGND sg13g2_decap_8
Xclkload4 clkload4/X clkload4/A VPWR VGND sg13g2_buf_16
XFILLER_109_105 VPWR VGND sg13g2_decap_8
X_23353_ _23353_/Q _24190_/CLK _23353_/D fanout2770/X VPWR VGND sg13g2_dfrbpq_1
X_20565_ _20565_/Y _23338_/Q _20565_/B VPWR VGND sg13g2_nand2_1
XFILLER_88_1820 VPWR VGND sg13g2_fill_1
XFILLER_30_1020 VPWR VGND sg13g2_fill_1
X_22304_ _22304_/Y _22304_/A _22310_/B VPWR VGND sg13g2_nand2_1
XFILLER_105_1891 VPWR VGND sg13g2_decap_8
X_23284_ _23284_/Q _24214_/CLK _23284_/D fanout2934/X VPWR VGND sg13g2_dfrbpq_1
XFILLER_106_801 VPWR VGND sg13g2_decap_8
X_20496_ _20496_/Y _20496_/A _20504_/B VPWR VGND sg13g2_nand2_1
XFILLER_88_1853 VPWR VGND sg13g2_decap_4
XFILLER_30_1075 VPWR VGND sg13g2_decap_8
X_22235_ _24106_/D _20202_/X _22241_/B _22234_/Y VPWR VGND sg13g2_o21ai_1
XFILLER_3_449 VPWR VGND sg13g2_fill_2
XFILLER_65_1116 VPWR VGND sg13g2_decap_4
Xhold4730 _20529_/A _23321_/Q VPWR VGND sg13g2_dlygate4sd3_1
XFILLER_69_1296 VPWR VGND sg13g2_decap_8
Xhold4741 _20526_/A _23320_/Q VPWR VGND sg13g2_dlygate4sd3_1
X_22166_ _24072_/D _24072_/Q _22298_/A0 _22183_/S VPWR VGND sg13g2_mux2_1
Xhold4752 _20853_/A _23476_/Q VPWR VGND sg13g2_dlygate4sd3_1
Xhold4763 _21477_/A _23756_/Q VPWR VGND sg13g2_dlygate4sd3_1
Xhold4774 _20932_/A _23512_/Q VPWR VGND sg13g2_dlygate4sd3_1
XFILLER_59_68 VPWR VGND sg13g2_decap_4
Xhold4785 _21374_/A _23707_/Q VPWR VGND sg13g2_dlygate4sd3_1
XFILLER_105_388 VPWR VGND sg13g2_decap_8
XFILLER_82_1441 VPWR VGND sg13g2_decap_8
XFILLER_47_1561 VPWR VGND sg13g2_decap_4
X_21117_ _21117_/Y _21117_/A _21121_/B VPWR VGND sg13g2_nand2_1
Xhold4796 _17319_/A _22788_/Q VPWR VGND sg13g2_dlygate4sd3_1
X_22097_ _22116_/S _22318_/B _22252_/B VPWR VGND sg13g2_and2_1
XFILLER_82_1474 VPWR VGND sg13g2_fill_1
XFILLER_47_1594 VPWR VGND sg13g2_decap_8
X_21048_ _21048_/Y _23557_/Q _21051_/B VPWR VGND sg13g2_nand2_1
XFILLER_115_63 VPWR VGND sg13g2_decap_8
XFILLER_43_1469 VPWR VGND sg13g2_decap_8
XFILLER_74_401 VPWR VGND sg13g2_fill_2
XFILLER_101_572 VPWR VGND sg13g2_decap_8
XFILLER_5_1931 VPWR VGND sg13g2_decap_8
XFILLER_59_497 VPWR VGND sg13g2_decap_8
XFILLER_86_283 VPWR VGND sg13g2_fill_1
X_13870_ _13880_/B _13946_/B _13856_/Y _13869_/Y VPWR VGND sg13g2_a21oi_1
XFILLER_112_1840 VPWR VGND sg13g2_decap_8
XFILLER_21_1734 VPWR VGND sg13g2_decap_8
XFILLER_28_840 VPWR VGND sg13g2_decap_8
XFILLER_41_1171 VPWR VGND sg13g2_fill_1
XFILLER_74_456 VPWR VGND sg13g2_decap_8
X_12821_ _12822_/C _14129_/A _12817_/Y _12820_/X _11363_/B VPWR VGND sg13g2_a22oi_1
XFILLER_90_927 VPWR VGND sg13g2_decap_8
XFILLER_1_1839 VPWR VGND sg13g2_decap_8
X_22999_ _22999_/Q clkload17/A _22999_/D fanout2846/X VPWR VGND sg13g2_dfrbpq_1
XFILLER_76_1212 VPWR VGND sg13g2_fill_1
X_15540_ _15540_/Y _19430_/A _15690_/B _19941_/A VPWR VGND sg13g2_nor3_1
XFILLER_15_523 VPWR VGND sg13g2_decap_8
XFILLER_70_640 VPWR VGND sg13g2_fill_1
X_15471_ _15471_/X _17087_/A _22457_/Q _15496_/S VPWR VGND sg13g2_mux2_1
X_12683_ _12683_/X _22988_/Q _13141_/B _13708_/B VPWR VGND sg13g2_or3_2
XFILLER_93_1570 VPWR VGND sg13g2_fill_2
XFILLER_54_1521 VPWR VGND sg13g2_decap_8
X_17210_ _22744_/D _17141_/B _17208_/Y _17209_/Y VPWR VGND sg13g2_a21oi_1
XFILLER_19_1663 VPWR VGND sg13g2_decap_8
X_11634_ _14087_/C _11634_/A _14117_/B _14116_/C _11634_/D VPWR VGND sg13g2_nand4_1
XFILLER_54_1554 VPWR VGND sg13g2_decap_8
X_18190_ _18240_/A _18395_/A _18216_/B VPWR VGND sg13g2_nand2_1
XFILLER_106_1666 VPWR VGND sg13g2_fill_1
X_17141_ _17141_/Y _17141_/A _17141_/B VPWR VGND sg13g2_nor2_1
XFILLER_11_773 VPWR VGND sg13g2_fill_1
XFILLER_106_1688 VPWR VGND sg13g2_decap_8
XFILLER_10_261 VPWR VGND sg13g2_decap_4
X_13304_ _14061_/S _12864_/Y _14053_/C _13304_/B1 VPWR VGND sg13g2_a21oi_2
X_17072_ _17073_/A _22719_/Q VPWR VGND sg13g2_inv_1
XFILLER_6_232 VPWR VGND sg13g2_fill_2
XFILLER_32_1863 VPWR VGND sg13g2_decap_8
XFILLER_109_650 VPWR VGND sg13g2_decap_8
X_14284_ _14284_/Y _19361_/A _19437_/A _19360_/B VPWR VGND sg13g2_nand3_1
XFILLER_32_1874 VPWR VGND sg13g2_fill_2
X_11496_ _11496_/Y _11245_/B _11492_/Y _11493_/Y _11495_/X _13350_/A VPWR VGND sg13g2_a221oi_1
XFILLER_115_119 VPWR VGND sg13g2_decap_8
XFILLER_6_276 VPWR VGND sg13g2_decap_8
X_13235_ _13235_/X _24170_/Q _24202_/Q _23242_/Q _23274_/Q _13236_/S0 _13236_/S1 VPWR
+ VGND sg13g2_mux4_1
X_16023_ _16023_/Y _22579_/Q _16023_/B VPWR VGND sg13g2_nand2_1
XFILLER_87_1363 VPWR VGND sg13g2_fill_2
XFILLER_108_182 VPWR VGND sg13g2_decap_8
X_13166_ _13166_/Y _23689_/Q _13166_/B VPWR VGND sg13g2_nand2b_1
XFILLER_41_7 VPWR VGND sg13g2_fill_1
XFILLER_83_1249 VPWR VGND sg13g2_fill_2
XFILLER_111_303 VPWR VGND sg13g2_fill_2
X_12117_ _12119_/B _23996_/Q _12121_/S _12123_/A VPWR VGND sg13g2_nand3b_1
XFILLER_112_859 VPWR VGND sg13g2_decap_8
X_17974_ _17974_/Y _18491_/A _17974_/B VPWR VGND sg13g2_nand2_1
X_13097_ _13097_/X _12955_/A _13098_/A _13059_/Y VPWR VGND sg13g2_a21o_1
XFILLER_69_239 VPWR VGND sg13g2_decap_8
XFILLER_61_1525 VPWR VGND sg13g2_decap_8
X_19713_ _19872_/B _19712_/B _19564_/Y _19712_/Y VPWR VGND sg13g2_o21ai_1
XFILLER_46_1082 VPWR VGND sg13g2_decap_8
X_16925_ _16926_/B _17030_/A _16954_/B _16954_/C VPWR VGND sg13g2_nor3_2
XFILLER_6_1728 VPWR VGND sg13g2_decap_8
X_12048_ _12048_/Y _12048_/A _12820_/S VPWR VGND sg13g2_nand2_2
XFILLER_93_710 VPWR VGND sg13g2_decap_4
XFILLER_66_935 VPWR VGND sg13g2_decap_4
XFILLER_38_637 VPWR VGND sg13g2_fill_2
X_19644_ _19644_/Y _19703_/A _19644_/B VPWR VGND sg13g2_nor2_1
XFILLER_37_114 VPWR VGND sg13g2_decap_8
XFILLER_65_423 VPWR VGND sg13g2_decap_8
XFILLER_92_220 VPWR VGND sg13g2_fill_2
XFILLER_1_42 VPWR VGND sg13g2_decap_8
X_16856_ _16857_/C _16856_/A _16856_/B _16856_/C VPWR VGND sg13g2_or3_1
XFILLER_92_231 VPWR VGND sg13g2_decap_8
XFILLER_81_905 VPWR VGND sg13g2_decap_4
XFILLER_19_840 VPWR VGND sg13g2_fill_1
XFILLER_92_242 VPWR VGND sg13g2_fill_1
XFILLER_19_851 VPWR VGND sg13g2_decap_8
X_15807_ _15807_/Y _15807_/A _15807_/B _15807_/C _15807_/D VPWR VGND sg13g2_nand4_1
XFILLER_53_607 VPWR VGND sg13g2_fill_2
X_19575_ _19932_/B _19703_/A _19571_/X _19574_/Y VPWR VGND sg13g2_a21oi_1
X_16787_ _16787_/Y _16787_/A _16787_/B _16787_/C VPWR VGND sg13g2_nand3_1
XFILLER_98_1481 VPWR VGND sg13g2_decap_8
X_13999_ _13999_/X _13999_/A _14005_/B VPWR VGND sg13g2_or2_1
XFILLER_20_1266 VPWR VGND sg13g2_decap_4
X_18526_ _18846_/B _17941_/B _23074_/Q _18548_/S VPWR VGND sg13g2_mux2_1
X_15738_ _15738_/X _17153_/A _22469_/Q _15935_/S VPWR VGND sg13g2_mux2_1
XFILLER_20_1288 VPWR VGND sg13g2_decap_8
XFILLER_34_843 VPWR VGND sg13g2_decap_4
XFILLER_45_180 VPWR VGND sg13g2_decap_8
XFILLER_33_331 VPWR VGND sg13g2_decap_8
XFILLER_33_364 VPWR VGND sg13g2_decap_4
X_18457_ _22987_/D _18456_/Y _14441_/A _18457_/S VPWR VGND sg13g2_mux2_1
X_15669_ _15669_/X _15669_/A _16352_/B _15669_/C VPWR VGND sg13g2_and3_1
XFILLER_21_526 VPWR VGND sg13g2_decap_4
X_17408_ _17408_/Y _17408_/A _17412_/B VPWR VGND sg13g2_nand2_1
XFILLER_21_537 VPWR VGND sg13g2_decap_8
Xplace4003 _12820_/S _11917_/A VPWR VGND sg13g2_buf_1
XFILLER_72_1654 VPWR VGND sg13g2_fill_1
Xplace4014 _13615_/S _13770_/A VPWR VGND sg13g2_buf_2
XFILLER_18_1162 VPWR VGND sg13g2_decap_4
X_18388_ _18388_/Y _18538_/S _18790_/B VPWR VGND sg13g2_nand2_1
XFILLER_37_1785 VPWR VGND sg13g2_fill_1
XFILLER_105_1121 VPWR VGND sg13g2_fill_2
Xplace4025 _12119_/A _12889_/A VPWR VGND sg13g2_buf_1
XFILLER_14_1004 VPWR VGND sg13g2_decap_4
XFILLER_14_1015 VPWR VGND sg13g2_decap_8
Xplace4036 _14124_/A _14098_/A VPWR VGND sg13g2_buf_2
Xplace3302 _22268_/A1 _19817_/Y VPWR VGND sg13g2_buf_1
Xplace4047 _19054_/S _24227_/Q VPWR VGND sg13g2_buf_1
Xplace3313 _16635_/A _16604_/C VPWR VGND sg13g2_buf_1
Xplace4058 _18029_/S _17987_/B VPWR VGND sg13g2_buf_1
X_17339_ _17339_/Y _17339_/A _17351_/B VPWR VGND sg13g2_nand2_1
Xplace4069 _18999_/A _19043_/A VPWR VGND sg13g2_buf_1
Xplace3324 _22308_/A1 _21345_/A1 VPWR VGND sg13g2_buf_1
Xplace3335 _20700_/A1 _20217_/Y VPWR VGND sg13g2_buf_1
Xplace3346 _21948_/A1 _19997_/Y VPWR VGND sg13g2_buf_1
Xplace3357 _21309_/A1 _22272_/A1 VPWR VGND sg13g2_buf_1
X_20350_ _20350_/Y _20350_/A _20350_/B VPWR VGND sg13g2_nor2_1
Xplace3368 _21297_/A1 _20929_/A1 VPWR VGND sg13g2_buf_1
Xplace3379 _17930_/B _17927_/B VPWR VGND sg13g2_buf_1
XFILLER_106_119 VPWR VGND sg13g2_decap_8
X_19009_ _19010_/B _19008_/Y _23058_/Q _19044_/B VPWR VGND sg13g2_mux2_1
XFILLER_115_642 VPWR VGND sg13g2_decap_8
X_22020_ _24003_/D _22288_/A1 _22039_/B _22019_/Y VPWR VGND sg13g2_o21ai_1
XFILLER_66_1447 VPWR VGND sg13g2_decap_4
XFILLER_114_196 VPWR VGND sg13g2_decap_8
XFILLER_44_1734 VPWR VGND sg13g2_decap_8
XFILLER_102_358 VPWR VGND sg13g2_fill_1
XFILLER_69_751 VPWR VGND sg13g2_decap_8
XFILLER_29_49 VPWR VGND sg13g2_decap_4
X_23971_ _23971_/Q clkload39/A _23971_/D fanout2731/X VPWR VGND sg13g2_dfrbpq_1
XFILLER_57_913 VPWR VGND sg13g2_decap_8
XFILLER_111_870 VPWR VGND sg13g2_decap_8
XFILLER_84_710 VPWR VGND sg13g2_decap_8
XFILLER_56_412 VPWR VGND sg13g2_fill_2
XFILLER_69_795 VPWR VGND sg13g2_fill_2
XFILLER_96_592 VPWR VGND sg13g2_fill_1
X_22922_ _22922_/Q clkload26/A _22922_/D fanout2826/X VPWR VGND sg13g2_dfrbpq_1
XFILLER_57_946 VPWR VGND sg13g2_fill_1
XFILLER_28_125 VPWR VGND sg13g2_decap_8
XFILLER_25_1199 VPWR VGND sg13g2_decap_8
XFILLER_28_136 VPWR VGND sg13g2_fill_1
XFILLER_99_1278 VPWR VGND sg13g2_fill_1
X_22853_ _22853_/Q clkload18/A _22853_/D fanout2821/X VPWR VGND sg13g2_dfrbpq_1
XFILLER_72_927 VPWR VGND sg13g2_decap_8
XFILLER_72_938 VPWR VGND sg13g2_fill_1
XFILLER_37_670 VPWR VGND sg13g2_fill_1
XFILLER_77_1532 VPWR VGND sg13g2_fill_2
X_21804_ _21804_/Y _23900_/Q _21804_/B VPWR VGND sg13g2_nand2_1
XFILLER_37_692 VPWR VGND sg13g2_fill_2
X_22784_ _22784_/Q clkload22/A _22784_/D fanout2876/X VPWR VGND sg13g2_dfrbpq_1
XFILLER_77_1565 VPWR VGND sg13g2_decap_4
XFILLER_71_459 VPWR VGND sg13g2_decap_8
XFILLER_52_640 VPWR VGND sg13g2_fill_1
XFILLER_101_21 VPWR VGND sg13g2_decap_8
XFILLER_77_1576 VPWR VGND sg13g2_fill_2
XFILLER_0_1861 VPWR VGND sg13g2_fill_1
XFILLER_24_353 VPWR VGND sg13g2_fill_2
XFILLER_52_662 VPWR VGND sg13g2_decap_4
X_21735_ _21735_/Y _21735_/A _21738_/B VPWR VGND sg13g2_nand2_1
XFILLER_12_504 VPWR VGND sg13g2_fill_2
XFILLER_40_835 VPWR VGND sg13g2_decap_8
XFILLER_55_1852 VPWR VGND sg13g2_fill_2
XFILLER_16_1814 VPWR VGND sg13g2_decap_8
XFILLER_71_1120 VPWR VGND sg13g2_fill_1
X_21666_ _21666_/Y _21666_/A _21666_/B VPWR VGND sg13g2_nand2_1
XFILLER_55_1874 VPWR VGND sg13g2_fill_1
X_23405_ _23405_/Q clkload31/A _23405_/D fanout2645/X VPWR VGND sg13g2_dfrbpq_1
XFILLER_61_69 VPWR VGND sg13g2_fill_2
XFILLER_103_1806 VPWR VGND sg13g2_fill_2
X_20617_ _23362_/D _22418_/A1 _20616_/B _20616_/Y VPWR VGND sg13g2_o21ai_1
XFILLER_32_1126 VPWR VGND sg13g2_decap_4
X_21597_ _23813_/D _21958_/A1 _21600_/B _21596_/Y VPWR VGND sg13g2_o21ai_1
X_11350_ _11350_/Y _13158_/S _11350_/B VPWR VGND sg13g2_nor2_1
Xrebuffer5560 _11492_/B _12551_/C VPWR VGND sg13g2_buf_1
X_23336_ _23336_/Q clkload32/A _23336_/D fanout2646/X VPWR VGND sg13g2_dfrbpq_1
X_20548_ _20548_/Y _20548_/A _20548_/B VPWR VGND sg13g2_nand2_1
XFILLER_88_1650 VPWR VGND sg13g2_decap_8
XFILLER_14_1593 VPWR VGND sg13g2_decap_8
XFILLER_101_1552 VPWR VGND sg13g2_fill_2
Xplace3880 _19881_/A2 _19501_/Y VPWR VGND sg13g2_buf_1
X_11281_ _11281_/Y _13213_/S _11274_/X _11280_/Y VPWR VGND sg13g2_a21oi_1
Xplace3891 _18562_/B _18162_/A VPWR VGND sg13g2_buf_1
X_23267_ _23267_/Q clkload34/A _23267_/D fanout2694/X VPWR VGND sg13g2_dfrbpq_1
X_20479_ _23300_/D _21327_/A1 _20482_/B _20478_/Y VPWR VGND sg13g2_o21ai_1
X_13020_ _13021_/B _13019_/A _13017_/Y _13019_/Y VPWR VGND sg13g2_o21ai_1
X_22218_ _24097_/D _22284_/A1 _22219_/B _22217_/Y VPWR VGND sg13g2_o21ai_1
XFILLER_79_504 VPWR VGND sg13g2_fill_2
X_23198_ _23198_/Q clkload33/A _23198_/D fanout2931/X VPWR VGND sg13g2_dfrbpq_1
XFILLER_49_1667 VPWR VGND sg13g2_decap_8
XFILLER_45_1509 VPWR VGND sg13g2_decap_4
XFILLER_84_1569 VPWR VGND sg13g2_fill_2
XFILLER_27_1932 VPWR VGND sg13g2_decap_8
X_22149_ _22149_/Y _22149_/A _22151_/B VPWR VGND sg13g2_nand2_1
XFILLER_114_1902 VPWR VGND sg13g2_decap_8
X_16710_ _16711_/B _22657_/Q _16717_/C VPWR VGND sg13g2_xor2_1
X_13922_ _13922_/Y _13915_/X _13921_/B _13921_/Y VPWR VGND sg13g2_o21ai_1
XFILLER_86_99 VPWR VGND sg13g2_fill_2
X_17690_ _17690_/Y _17710_/A1 _17686_/X _17689_/Y VPWR VGND sg13g2_o21ai_1
XFILLER_19_136 VPWR VGND sg13g2_decap_4
XFILLER_63_905 VPWR VGND sg13g2_decap_8
XFILLER_35_618 VPWR VGND sg13g2_decap_8
X_16641_ _16642_/B _22643_/Q _16641_/B VPWR VGND sg13g2_xnor2_1
XFILLER_112_1670 VPWR VGND sg13g2_decap_8
X_13853_ _13855_/A _13854_/A _13854_/B _13854_/C VPWR VGND sg13g2_nand3_1
XFILLER_34_117 VPWR VGND sg13g2_fill_1
X_19360_ _19419_/B _19360_/A _19360_/B VPWR VGND sg13g2_nor2_1
X_12804_ _12804_/Y _13678_/A1 _12801_/Y _12803_/Y _13595_/B2 _12288_/B VPWR VGND sg13g2_a221oi_1
X_16572_ _16572_/Y _16678_/S _16572_/B VPWR VGND sg13g2_nor2_1
XFILLER_95_1654 VPWR VGND sg13g2_decap_8
X_13784_ _13784_/X _23729_/Q _23761_/Q _23793_/Q _23825_/Q _13798_/B2 _13795_/S1 VPWR
+ VGND sg13g2_mux4_1
XFILLER_43_640 VPWR VGND sg13g2_fill_1
XFILLER_62_459 VPWR VGND sg13g2_decap_8
XFILLER_37_1004 VPWR VGND sg13g2_fill_2
X_18311_ _18311_/Y _18425_/A _18415_/B _18308_/Y _18385_/B _18334_/B VPWR VGND sg13g2_a221oi_1
XFILLER_43_662 VPWR VGND sg13g2_fill_2
X_19291_ _23208_/D _23208_/Q _20284_/A3 _19299_/S VPWR VGND sg13g2_mux2_1
X_12735_ _12735_/Y _12732_/Y _12734_/Y _13256_/A VPWR VGND sg13g2_o21ai_1
XFILLER_73_1930 VPWR VGND sg13g2_decap_8
XFILLER_42_161 VPWR VGND sg13g2_decap_4
XFILLER_30_312 VPWR VGND sg13g2_decap_8
XFILLER_42_172 VPWR VGND sg13g2_fill_1
XFILLER_70_481 VPWR VGND sg13g2_decap_8
X_18242_ _18254_/B _18423_/B _18242_/B VPWR VGND sg13g2_nand2_1
X_15454_ _15455_/B _22658_/Q _15323_/X _15325_/Y _22722_/Q VPWR VGND sg13g2_a22oi_1
XFILLER_30_334 VPWR VGND sg13g2_fill_1
XFILLER_31_857 VPWR VGND sg13g2_decap_8
X_12666_ _13383_/C _11614_/A _11255_/B _22995_/Q VPWR VGND sg13g2_o21ai_1
XFILLER_89_7 VPWR VGND sg13g2_decap_8
XFILLER_106_1441 VPWR VGND sg13g2_fill_1
XFILLER_30_356 VPWR VGND sg13g2_decap_8
XFILLER_15_1335 VPWR VGND sg13g2_decap_8
X_11617_ _11618_/C _14438_/C _14341_/B VPWR VGND sg13g2_nor2_1
X_14405_ _14571_/B _17532_/A _17044_/A VPWR VGND sg13g2_nand2_1
X_12597_ _12597_/Y _24001_/Q _12813_/S VPWR VGND sg13g2_nand2b_1
XFILLER_102_1305 VPWR VGND sg13g2_decap_8
XFILLER_50_1248 VPWR VGND sg13g2_fill_2
X_17124_ _17124_/Y _17124_/A _17226_/A VPWR VGND sg13g2_nor2_1
XFILLER_102_1338 VPWR VGND sg13g2_decap_4
X_14336_ _15193_/C _19605_/A _15165_/B _14336_/C VPWR VGND sg13g2_and3_1
X_11548_ _11549_/C _11921_/A _11548_/B _11548_/C VPWR VGND sg13g2_nor3_1
XFILLER_89_1447 VPWR VGND sg13g2_decap_8
X_17055_ _17055_/Y _17061_/A _17055_/B VPWR VGND sg13g2_xnor2_1
XFILLER_13_1081 VPWR VGND sg13g2_decap_8
X_14267_ _24240_/D _16856_/A _14267_/B VPWR VGND sg13g2_nor2_1
X_11479_ _11479_/Y _23670_/Q _11714_/S VPWR VGND sg13g2_nand2b_1
XFILLER_100_1051 VPWR VGND sg13g2_decap_8
XFILLER_87_1160 VPWR VGND sg13g2_decap_8
XFILLER_83_1002 VPWR VGND sg13g2_decap_4
X_16006_ _16008_/C _22909_/Q _15825_/B _15767_/B _22513_/Q VPWR VGND sg13g2_a22oi_1
X_13218_ _13220_/A _13970_/A _13187_/Y _13217_/Y VPWR VGND sg13g2_a21oi_1
X_14198_ _14198_/Y _14772_/A _14782_/B _14782_/C VPWR VGND sg13g2_nor3_1
X_13149_ _20166_/B _11861_/A _13290_/A2 _13148_/Y VPWR VGND sg13g2_a21oi_2
XFILLER_112_656 VPWR VGND sg13g2_decap_8
XFILLER_111_133 VPWR VGND sg13g2_decap_8
XFILLER_65_1480 VPWR VGND sg13g2_decap_4
XFILLER_113_1401 VPWR VGND sg13g2_fill_2
X_17957_ _17978_/A _18476_/A _18187_/A VPWR VGND sg13g2_and2_1
XFILLER_61_1333 VPWR VGND sg13g2_fill_1
XFILLER_61_1344 VPWR VGND sg13g2_fill_2
XFILLER_6_1536 VPWR VGND sg13g2_fill_1
X_17888_ _17889_/A _17888_/A1 _17918_/A2 _17923_/B _22927_/Q _17887_/Y VPWR VGND sg13g2_a221oi_1
XFILLER_66_765 VPWR VGND sg13g2_decap_8
XFILLER_54_916 VPWR VGND sg13g2_fill_2
X_19627_ _19627_/Y _19624_/Y _19625_/Y _19946_/C1 VPWR VGND sg13g2_a21oi_1
XFILLER_96_1429 VPWR VGND sg13g2_decap_8
X_16839_ _22680_/D _17209_/A _16838_/Y _16846_/A VPWR VGND sg13g2_mux2_1
XFILLER_54_938 VPWR VGND sg13g2_fill_1
XFILLER_19_670 VPWR VGND sg13g2_decap_8
XFILLER_20_1052 VPWR VGND sg13g2_fill_1
XFILLER_53_448 VPWR VGND sg13g2_decap_8
XFILLER_59_1240 VPWR VGND sg13g2_decap_8
XFILLER_59_1251 VPWR VGND sg13g2_fill_1
XFILLER_81_779 VPWR VGND sg13g2_decap_4
XFILLER_20_1085 VPWR VGND sg13g2_decap_8
X_18509_ _18509_/X _18015_/X _18840_/B _18538_/S VPWR VGND sg13g2_mux2_1
XFILLER_22_802 VPWR VGND sg13g2_decap_4
XFILLER_22_813 VPWR VGND sg13g2_decap_8
X_19489_ _20292_/B _19489_/A _19489_/B _19489_/C VPWR VGND sg13g2_nand3_1
XFILLER_74_1749 VPWR VGND sg13g2_fill_2
XFILLER_55_1137 VPWR VGND sg13g2_fill_1
XFILLER_55_1148 VPWR VGND sg13g2_fill_2
X_21520_ _21520_/Y _23776_/Q _21539_/B VPWR VGND sg13g2_nand2_1
XFILLER_37_1582 VPWR VGND sg13g2_fill_2
XFILLER_72_1473 VPWR VGND sg13g2_fill_2
X_21451_ _23743_/D _19972_/Y _21456_/B _21450_/Y VPWR VGND sg13g2_o21ai_1
XFILLER_72_1495 VPWR VGND sg13g2_decap_8
Xplace3110 _21349_/S _21353_/B VPWR VGND sg13g2_buf_1
Xplace3121 _21264_/B _21266_/B VPWR VGND sg13g2_buf_1
XFILLER_108_907 VPWR VGND sg13g2_fill_1
Xplace3132 _20989_/S _20930_/B VPWR VGND sg13g2_buf_1
X_20402_ _20402_/Y _23265_/Q _20404_/B VPWR VGND sg13g2_nand2_1
X_24170_ _24170_/Q _24170_/CLK _24170_/D fanout2697/X VPWR VGND sg13g2_dfrbpq_1
Xplace3143 _20913_/B _20919_/B VPWR VGND sg13g2_buf_1
XFILLER_108_929 VPWR VGND sg13g2_fill_2
Xplace3154 _20768_/B _20772_/B VPWR VGND sg13g2_buf_1
Xplace3165 _20673_/B _20666_/B VPWR VGND sg13g2_buf_1
X_23121_ _23121_/Q _23215_/CLK _23121_/D fanout2925/X VPWR VGND sg13g2_dfrbpq_1
Xplace3176 _20640_/S _20644_/B VPWR VGND sg13g2_buf_1
Xplace3187 _20512_/B _20504_/B VPWR VGND sg13g2_buf_1
X_20333_ _23250_/D _20365_/B _22448_/A1 _20332_/Y VPWR VGND sg13g2_o21ai_1
XFILLER_85_1812 VPWR VGND sg13g2_fill_2
Xplace3198 _20429_/B _20435_/B VPWR VGND sg13g2_buf_1
X_23052_ _23052_/Q clkload12/A _23052_/D fanout2912/X VPWR VGND sg13g2_dfrbpq_1
X_20264_ _20265_/D _19769_/A _19832_/Y _20263_/Y VPWR VGND sg13g2_a21oi_1
XFILLER_89_824 VPWR VGND sg13g2_decap_8
XFILLER_81_1709 VPWR VGND sg13g2_decap_8
XFILLER_0_205 VPWR VGND sg13g2_fill_2
X_22003_ _22003_/Y _22003_/A _22003_/B VPWR VGND sg13g2_nand2_1
XFILLER_66_1266 VPWR VGND sg13g2_decap_8
X_20195_ _20195_/Y _20195_/A _20195_/B VPWR VGND sg13g2_nand2_1
XFILLER_102_144 VPWR VGND sg13g2_decap_8
XFILLER_88_367 VPWR VGND sg13g2_decap_4
XFILLER_76_507 VPWR VGND sg13g2_decap_8
XFILLER_5_1013 VPWR VGND sg13g2_decap_8
XFILLER_29_401 VPWR VGND sg13g2_decap_8
XFILLER_40_1406 VPWR VGND sg13g2_fill_1
XFILLER_56_14 VPWR VGND sg13g2_fill_2
XFILLER_69_581 VPWR VGND sg13g2_fill_1
XFILLER_44_1597 VPWR VGND sg13g2_decap_4
X_23954_ _23954_/Q _24210_/CLK _23954_/D fanout2624/X VPWR VGND sg13g2_dfrbpq_1
XFILLER_45_905 VPWR VGND sg13g2_fill_1
XFILLER_56_242 VPWR VGND sg13g2_decap_4
XFILLER_57_765 VPWR VGND sg13g2_decap_8
XFILLER_29_467 VPWR VGND sg13g2_fill_1
XFILLER_57_776 VPWR VGND sg13g2_fill_2
X_22905_ _22905_/Q clkload9/A _22905_/D fanout2816/X VPWR VGND sg13g2_dfrbpq_1
XFILLER_57_787 VPWR VGND sg13g2_decap_8
X_23885_ _23885_/Q clkload30/A _23885_/D fanout2657/X VPWR VGND sg13g2_dfrbpq_1
XFILLER_17_629 VPWR VGND sg13g2_decap_4
XFILLER_84_584 VPWR VGND sg13g2_decap_8
XFILLER_16_106 VPWR VGND sg13g2_decap_8
XFILLER_38_990 VPWR VGND sg13g2_decap_4
XFILLER_72_735 VPWR VGND sg13g2_fill_1
XFILLER_57_1903 VPWR VGND sg13g2_fill_2
XFILLER_112_42 VPWR VGND sg13g2_decap_8
X_22836_ _22836_/Q _22869_/CLK _22836_/D fanout2800/X VPWR VGND sg13g2_dfrbpq_1
XFILLER_72_757 VPWR VGND sg13g2_decap_8
XFILLER_57_1947 VPWR VGND sg13g2_decap_8
X_22767_ _22767_/Q _22893_/CLK _22767_/D fanout2818/X VPWR VGND sg13g2_dfrbpq_1
XFILLER_13_824 VPWR VGND sg13g2_decap_8
XFILLER_24_161 VPWR VGND sg13g2_fill_2
XFILLER_53_993 VPWR VGND sg13g2_decap_8
XFILLER_80_790 VPWR VGND sg13g2_fill_2
X_12520_ _12520_/Y _15447_/A _16090_/S _19928_/B VPWR VGND sg13g2_a21oi_1
XFILLER_12_323 VPWR VGND sg13g2_fill_1
X_22698_ _22698_/Q _22733_/CLK _22698_/D fanout2881/X VPWR VGND sg13g2_dfrbpq_1
XFILLER_13_868 VPWR VGND sg13g2_fill_1
XFILLER_13_879 VPWR VGND sg13g2_fill_1
XFILLER_8_316 VPWR VGND sg13g2_decap_8
XFILLER_55_1682 VPWR VGND sg13g2_fill_1
XFILLER_16_1644 VPWR VGND sg13g2_fill_2
X_12451_ _12452_/B _24032_/Q _24064_/Q _24096_/Q _24128_/Q _12997_/S _13242_/S1 VPWR
+ VGND sg13g2_mux4_1
X_21649_ _23838_/D _21943_/A1 _21648_/B _21648_/Y VPWR VGND sg13g2_o21ai_1
Xclkbuf_leaf_51_clk_i clkload40/A clkbuf_leaf_55_clk_i/A VPWR VGND sg13g2_buf_16
XFILLER_107_1794 VPWR VGND sg13g2_decap_8
X_11402_ _11402_/Y _11414_/A _11402_/B VPWR VGND sg13g2_nor2_1
X_12382_ _12383_/B _23423_/Q _23455_/Q _23487_/Q _23519_/Q _12978_/S0 _12474_/S VPWR
+ VGND sg13g2_mux4_1
XFILLER_51_1579 VPWR VGND sg13g2_fill_1
XFILLER_86_1609 VPWR VGND sg13g2_decap_4
X_14121_ _14121_/Y _14121_/A _14121_/B VPWR VGND sg13g2_nand2_1
XFILLER_115_0 VPWR VGND sg13g2_decap_8
X_23319_ _23319_/Q clkload57/A _23319_/D fanout2754/X VPWR VGND sg13g2_dfrbpq_1
X_11333_ _11333_/X _24151_/Q _24183_/Q _23223_/Q _23255_/Q _11923_/S0 _11538_/S1 VPWR
+ VGND sg13g2_mux4_1
Xrebuffer5390 _12746_/B2 _12745_/Y VPWR VGND sg13g2_buf_8
X_14052_ _14053_/D _14060_/A _14052_/B VPWR VGND sg13g2_nand2b_1
XFILLER_97_21 VPWR VGND sg13g2_decap_8
Xclkbuf_leaf_66_clk_i clkload17/A clkload0/A VPWR VGND sg13g2_buf_16
X_11264_ _11984_/C _13968_/B _11500_/S VPWR VGND sg13g2_xnor2_1
X_13003_ _13003_/X _23590_/Q _23622_/Q _23654_/Q _23686_/Q _13004_/S0 _13004_/S1 VPWR
+ VGND sg13g2_mux4_1
Xhold5080 _20762_/A _23431_/Q VPWR VGND sg13g2_dlygate4sd3_1
Xhold5091 _20973_/A _23531_/Q VPWR VGND sg13g2_dlygate4sd3_1
X_18860_ _18860_/Y _18866_/A _18860_/B VPWR VGND sg13g2_nand2_1
XFILLER_27_1740 VPWR VGND sg13g2_decap_8
XFILLER_95_816 VPWR VGND sg13g2_fill_1
X_17811_ _17811_/Y _22907_/Q _17811_/B VPWR VGND sg13g2_nor2_1
X_18791_ _18791_/Y _18029_/S _23033_/Q _18766_/Y _19119_/A1 VPWR VGND sg13g2_a22oi_1
XFILLER_7_1834 VPWR VGND sg13g2_decap_8
XFILLER_0_761 VPWR VGND sg13g2_fill_2
XFILLER_0_794 VPWR VGND sg13g2_fill_1
XFILLER_48_732 VPWR VGND sg13g2_decap_8
XFILLER_94_348 VPWR VGND sg13g2_fill_1
X_17742_ _17742_/Y _17823_/A1 _17740_/Y _17741_/Y VPWR VGND sg13g2_o21ai_1
X_14954_ _14954_/Y _14953_/A _16269_/A _14953_/Y VPWR VGND sg13g2_o21ai_1
XFILLER_47_231 VPWR VGND sg13g2_decap_8
XFILLER_75_551 VPWR VGND sg13g2_decap_8
XFILLER_97_1727 VPWR VGND sg13g2_fill_1
XFILLER_36_916 VPWR VGND sg13g2_fill_2
X_13905_ _13905_/Y _13717_/B _13904_/Y _13858_/A VPWR VGND sg13g2_a21oi_1
X_14885_ _14885_/Y _14885_/A _14885_/B _14885_/C _14885_/D VPWR VGND sg13g2_nor4_1
XFILLER_36_949 VPWR VGND sg13g2_fill_1
X_19412_ _19412_/Y _20009_/B _19412_/B VPWR VGND sg13g2_nor2_1
XFILLER_35_437 VPWR VGND sg13g2_fill_2
XFILLER_21_1372 VPWR VGND sg13g2_decap_8
X_16624_ _16625_/B _22639_/Q _22638_/Q _16635_/A _16628_/D VPWR VGND sg13g2_nand4_1
X_13836_ _13836_/X _23314_/Q _23346_/Q _23378_/Q _23410_/Q _13959_/S0 _13331_/S VPWR
+ VGND sg13g2_mux4_1
XFILLER_62_234 VPWR VGND sg13g2_decap_8
XFILLER_16_640 VPWR VGND sg13g2_decap_8
XFILLER_56_1413 VPWR VGND sg13g2_decap_8
X_19343_ _19343_/Y _20117_/B _19412_/B _19342_/Y VPWR VGND sg13g2_o21ai_1
XFILLER_91_1304 VPWR VGND sg13g2_fill_2
XFILLER_16_662 VPWR VGND sg13g2_decap_8
XFILLER_56_1424 VPWR VGND sg13g2_fill_2
XFILLER_62_267 VPWR VGND sg13g2_fill_2
X_16555_ _16556_/B _22625_/Q _16559_/C _16564_/D VPWR VGND sg13g2_nand3_1
XFILLER_50_418 VPWR VGND sg13g2_decap_4
X_13767_ _13767_/X _23921_/Q _24017_/Q _13910_/S VPWR VGND sg13g2_mux2_1
XFILLER_108_1514 VPWR VGND sg13g2_decap_4
XFILLER_31_632 VPWR VGND sg13g2_decap_4
X_15506_ _15509_/B _15506_/A _15506_/B VPWR VGND sg13g2_nand2_1
X_19274_ _19274_/Y _23196_/Q _19274_/B VPWR VGND sg13g2_nand2_1
X_12718_ _12718_/Y _23555_/Q _12922_/A2 _12717_/X _12443_/A VPWR VGND sg13g2_a22oi_1
XFILLER_34_1711 VPWR VGND sg13g2_decap_8
X_16486_ _22605_/D _16136_/A _16506_/B _16485_/Y VPWR VGND sg13g2_o21ai_1
XFILLER_34_1722 VPWR VGND sg13g2_fill_2
X_13698_ _13698_/X _13702_/A _13698_/B VPWR VGND sg13g2_and2_1
Xclkbuf_leaf_19_clk_i clkload25/A clkbuf_4_5__f_clk_i/X VPWR VGND sg13g2_buf_16
X_18225_ _18225_/Y _18253_/B _18421_/A _18363_/B _18451_/A VPWR VGND sg13g2_a22oi_1
XFILLER_30_153 VPWR VGND sg13g2_fill_1
X_15437_ _17394_/A _15436_/A _15335_/B _15435_/Y _15436_/Y VPWR VGND sg13g2_a22oi_1
XFILLER_62_90 VPWR VGND sg13g2_fill_1
X_12649_ _12649_/Y _12707_/S _12646_/X _12648_/Y VPWR VGND sg13g2_o21ai_1
XFILLER_8_850 VPWR VGND sg13g2_decap_8
XFILLER_50_1045 VPWR VGND sg13g2_fill_2
X_18156_ _18562_/C _18498_/A _18479_/D VPWR VGND sg13g2_nand2_1
XFILLER_15_1165 VPWR VGND sg13g2_decap_8
X_15368_ _15368_/Y _22655_/Q _15323_/X _15325_/Y _22719_/Q VPWR VGND sg13g2_a22oi_1
XFILLER_11_1018 VPWR VGND sg13g2_fill_1
XFILLER_7_360 VPWR VGND sg13g2_decap_8
X_17107_ _17107_/Y _17107_/A _17113_/B VPWR VGND sg13g2_nor2_1
X_14319_ _15140_/B _13846_/A _11938_/Y _14321_/B _14318_/Y VPWR VGND sg13g2_a22oi_1
X_18087_ _18087_/Y _18339_/A _18884_/B _22996_/Q VPWR VGND sg13g2_nor3_1
XFILLER_7_382 VPWR VGND sg13g2_decap_8
XFILLER_102_1179 VPWR VGND sg13g2_fill_1
X_15299_ _15332_/B _22453_/Q _15270_/A _15296_/Y _22880_/Q VPWR VGND sg13g2_a22oi_1
X_17038_ _17048_/A _22715_/Q _17052_/C VPWR VGND sg13g2_nand2_1
XFILLER_28_1515 VPWR VGND sg13g2_fill_2
XFILLER_28_1526 VPWR VGND sg13g2_decap_8
XFILLER_97_120 VPWR VGND sg13g2_decap_8
XFILLER_98_654 VPWR VGND sg13g2_fill_1
XFILLER_30_0 VPWR VGND sg13g2_decap_8
XFILLER_115_1518 VPWR VGND sg13g2_decap_8
XFILLER_112_453 VPWR VGND sg13g2_decap_8
X_18989_ _18991_/B _18986_/Y _19042_/S VPWR VGND sg13g2_nand2b_1
XFILLER_41_1704 VPWR VGND sg13g2_fill_1
XFILLER_6_1322 VPWR VGND sg13g2_fill_1
XFILLER_61_1141 VPWR VGND sg13g2_decap_8
XFILLER_22_1103 VPWR VGND sg13g2_fill_2
XFILLER_41_1726 VPWR VGND sg13g2_fill_2
XFILLER_113_1231 VPWR VGND sg13g2_fill_2
XFILLER_85_359 VPWR VGND sg13g2_decap_8
XFILLER_27_905 VPWR VGND sg13g2_decap_8
XFILLER_61_1185 VPWR VGND sg13g2_decap_4
XFILLER_22_1147 VPWR VGND sg13g2_decap_4
XFILLER_113_1275 VPWR VGND sg13g2_fill_1
XFILLER_22_1158 VPWR VGND sg13g2_fill_2
X_20951_ _23520_/D _19997_/Y _20954_/B _20950_/Y VPWR VGND sg13g2_o21ai_1
XFILLER_53_212 VPWR VGND sg13g2_decap_8
X_23670_ _23670_/Q clkload57/A _23670_/D fanout2763/X VPWR VGND sg13g2_dfrbpq_1
XFILLER_26_448 VPWR VGND sg13g2_fill_1
X_20882_ _20882_/Y _20882_/A _20888_/B VPWR VGND sg13g2_nand2_1
XFILLER_39_1611 VPWR VGND sg13g2_decap_8
X_22621_ _22621_/Q clkload24/A _22621_/D fanout2899/X VPWR VGND sg13g2_dfrbpq_1
XFILLER_53_289 VPWR VGND sg13g2_decap_8
XFILLER_39_1677 VPWR VGND sg13g2_decap_8
X_22552_ _22552_/Q clkload26/A _22552_/D fanout2852/X VPWR VGND sg13g2_dfrbpq_1
XFILLER_17_1920 VPWR VGND sg13g2_decap_8
XFILLER_21_131 VPWR VGND sg13g2_decap_8
XFILLER_42_27 VPWR VGND sg13g2_fill_1
XFILLER_91_1871 VPWR VGND sg13g2_decap_4
X_21503_ _23768_/D _21930_/A1 _21502_/B _21502_/Y VPWR VGND sg13g2_o21ai_1
XFILLER_22_676 VPWR VGND sg13g2_decap_8
XFILLER_107_1057 VPWR VGND sg13g2_decap_4
XFILLER_104_1901 VPWR VGND sg13g2_decap_8
XFILLER_10_827 VPWR VGND sg13g2_decap_8
X_22483_ _22483_/Q clkload28/A _22483_/D fanout2855/X VPWR VGND sg13g2_dfrbpq_1
XFILLER_72_1270 VPWR VGND sg13g2_fill_2
XFILLER_72_1281 VPWR VGND sg13g2_fill_2
X_24222_ _24222_/Q clkload15/A _24222_/D fanout2852/X VPWR VGND sg13g2_dfrbpq_1
X_21434_ _21434_/Y _23736_/Q _21489_/B VPWR VGND sg13g2_nand2_1
XFILLER_33_1276 VPWR VGND sg13g2_fill_1
XFILLER_107_203 VPWR VGND sg13g2_decap_8
X_24153_ _24153_/Q _24190_/CLK _24153_/D fanout2769/X VPWR VGND sg13g2_dfrbpq_1
X_21365_ _21365_/Y _21365_/A _21367_/B VPWR VGND sg13g2_nand2_1
XFILLER_11_1563 VPWR VGND sg13g2_decap_8
X_23104_ _23104_/Q _23114_/CLK _23104_/D fanout2904/X VPWR VGND sg13g2_dfrbpq_1
XFILLER_107_269 VPWR VGND sg13g2_decap_4
XFILLER_102_1691 VPWR VGND sg13g2_decap_8
X_20316_ _20316_/X _20316_/A0 _20316_/A1 _20316_/A2 _20316_/A3 _20316_/S0 _20224_/A
+ VPWR VGND sg13g2_mux4_1
XFILLER_11_1585 VPWR VGND sg13g2_fill_1
X_24084_ _24084_/Q clkload16/A _24084_/D fanout2622/X VPWR VGND sg13g2_dfrbpq_1
X_21296_ _21296_/Y _23670_/Q _21308_/B VPWR VGND sg13g2_nand2_1
X_23035_ _23035_/Q clkload13/A _23035_/D fanout2908/X VPWR VGND sg13g2_dfrbpq_1
XFILLER_1_525 VPWR VGND sg13g2_fill_2
XFILLER_66_1052 VPWR VGND sg13g2_decap_4
XFILLER_115_280 VPWR VGND sg13g2_decap_8
XFILLER_107_42 VPWR VGND sg13g2_decap_8
XFILLER_103_420 VPWR VGND sg13g2_decap_8
X_20247_ _20247_/Y _20305_/A _20247_/B _20247_/C _20247_/D VPWR VGND sg13g2_nand4_1
XFILLER_49_507 VPWR VGND sg13g2_decap_8
XFILLER_49_518 VPWR VGND sg13g2_fill_1
X_20178_ _20178_/Y _13360_/Y _20178_/B VPWR VGND sg13g2_nand2b_1
XFILLER_88_175 VPWR VGND sg13g2_fill_1
XFILLER_88_197 VPWR VGND sg13g2_fill_2
XFILLER_92_808 VPWR VGND sg13g2_fill_1
XFILLER_18_905 VPWR VGND sg13g2_decap_8
XFILLER_29_242 VPWR VGND sg13g2_fill_2
XFILLER_111_1927 VPWR VGND sg13g2_decap_8
X_23937_ _23937_/Q clkload43/A _23937_/D fanout2741/X VPWR VGND sg13g2_dfrbpq_1
X_11951_ _11973_/B _11951_/A _11951_/B _11951_/C VPWR VGND sg13g2_nand3_1
XFILLER_85_893 VPWR VGND sg13g2_fill_1
XFILLER_79_1446 VPWR VGND sg13g2_decap_8
XFILLER_44_223 VPWR VGND sg13g2_fill_1
X_11882_ _11887_/B _12002_/A _11882_/B _11882_/C VPWR VGND sg13g2_nand3_1
XFILLER_17_459 VPWR VGND sg13g2_fill_1
XFILLER_2_1764 VPWR VGND sg13g2_decap_8
X_14670_ _14670_/Y _14670_/A _19195_/B VPWR VGND sg13g2_nand2_1
XFILLER_44_234 VPWR VGND sg13g2_decap_8
X_23868_ _23868_/Q _23966_/CLK _23868_/D fanout2765/X VPWR VGND sg13g2_dfrbpq_1
XFILLER_72_576 VPWR VGND sg13g2_fill_1
X_13621_ _13621_/X _23919_/Q _24015_/Q _13621_/S VPWR VGND sg13g2_mux2_1
XFILLER_83_89 VPWR VGND sg13g2_decap_8
XFILLER_57_1733 VPWR VGND sg13g2_decap_8
X_22819_ _22819_/Q _22917_/CLK _22819_/D fanout2895/X VPWR VGND sg13g2_dfrbpq_1
XFILLER_26_993 VPWR VGND sg13g2_decap_8
XFILLER_44_289 VPWR VGND sg13g2_decap_8
X_23799_ _23799_/Q clkload52/A _23799_/D fanout2690/X VPWR VGND sg13g2_dfrbpq_1
XFILLER_109_1834 VPWR VGND sg13g2_decap_8
XFILLER_25_481 VPWR VGND sg13g2_decap_8
XFILLER_53_1608 VPWR VGND sg13g2_fill_2
X_16340_ _16340_/Y _22544_/Q VPWR VGND sg13g2_inv_1
X_13552_ _13552_/X _13552_/A _13552_/B VPWR VGND sg13g2_or2_1
XFILLER_12_131 VPWR VGND sg13g2_fill_2
XFILLER_73_1067 VPWR VGND sg13g2_decap_4
XFILLER_34_1029 VPWR VGND sg13g2_fill_2
X_12503_ _12504_/D _12486_/A _12502_/X _12575_/A VPWR VGND sg13g2_o21ai_1
X_13483_ _13483_/X _23437_/Q _23469_/Q _23501_/Q _23533_/Q _13614_/S0 _13614_/S1 VPWR
+ VGND sg13g2_mux4_1
X_16271_ _16271_/Y _22527_/Q _22526_/Q VPWR VGND sg13g2_nor2b_1
XFILLER_8_124 VPWR VGND sg13g2_decap_8
XFILLER_16_1452 VPWR VGND sg13g2_fill_2
X_18010_ _18010_/Y _18009_/A _18010_/B VPWR VGND sg13g2_nand2b_1
XFILLER_9_669 VPWR VGND sg13g2_decap_8
XFILLER_107_1591 VPWR VGND sg13g2_decap_8
X_12434_ _12440_/A _12435_/B _12431_/Y _12432_/Y _12438_/B _12433_/Y VPWR VGND sg13g2_a221oi_1
XFILLER_12_1316 VPWR VGND sg13g2_decap_4
XFILLER_8_157 VPWR VGND sg13g2_fill_2
XFILLER_16_1496 VPWR VGND sg13g2_fill_2
XFILLER_12_1349 VPWR VGND sg13g2_decap_4
XFILLER_5_820 VPWR VGND sg13g2_decap_8
X_15153_ _15393_/B _15179_/A VPWR VGND sg13g2_inv_1
X_12365_ _12370_/B _12499_/A _12365_/B VPWR VGND sg13g2_nor2_1
XFILLER_10_1040 VPWR VGND sg13g2_fill_1
XFILLER_114_718 VPWR VGND sg13g2_decap_8
XFILLER_4_341 VPWR VGND sg13g2_decap_8
X_11316_ _11316_/Y _11502_/A _11316_/B _11316_/C VPWR VGND sg13g2_nand3_1
X_14104_ _14104_/Y _14104_/A _14104_/B _14104_/C VPWR VGND sg13g2_nor3_1
X_19961_ _19962_/B _19663_/A _19797_/B _19543_/Y VPWR VGND sg13g2_o21ai_1
X_15084_ _15086_/A _22510_/Q _15067_/B _14885_/Y _22938_/Q VPWR VGND sg13g2_a22oi_1
X_12296_ _12296_/X _23838_/Q _23870_/Q _23934_/Q _23966_/Q _11855_/S _12297_/S1 VPWR
+ VGND sg13g2_mux4_1
XFILLER_113_217 VPWR VGND sg13g2_decap_8
XFILLER_107_792 VPWR VGND sg13g2_fill_1
X_18912_ _18914_/B _18909_/Y _18957_/C VPWR VGND sg13g2_nand2b_1
XFILLER_29_1846 VPWR VGND sg13g2_decap_8
X_11247_ _14614_/A _14121_/A _11247_/B _11595_/A _14122_/C VPWR VGND sg13g2_nand4_1
XFILLER_49_1272 VPWR VGND sg13g2_decap_8
X_18843_ _18844_/C _23073_/Q _18869_/B VPWR VGND sg13g2_nand2_1
X_11178_ _24236_/D _23189_/Q _16855_/B VPWR VGND sg13g2_and2_1
XFILLER_68_838 VPWR VGND sg13g2_fill_1
XFILLER_79_175 VPWR VGND sg13g2_fill_1
XFILLER_45_1169 VPWR VGND sg13g2_fill_1
XFILLER_79_186 VPWR VGND sg13g2_fill_2
XFILLER_67_326 VPWR VGND sg13g2_fill_1
XFILLER_95_646 VPWR VGND sg13g2_fill_1
XFILLER_62_1472 VPWR VGND sg13g2_decap_8
XFILLER_110_979 VPWR VGND sg13g2_decap_4
X_15986_ _15995_/C _22481_/Q _15639_/B _15346_/A _16776_/C _15986_/C1 VPWR VGND sg13g2_a221oi_1
XFILLER_97_1502 VPWR VGND sg13g2_decap_8
XFILLER_94_156 VPWR VGND sg13g2_decap_8
XFILLER_62_1494 VPWR VGND sg13g2_decap_8
XFILLER_7_1697 VPWR VGND sg13g2_decap_8
X_17725_ _17725_/Y _23174_/Q _17734_/A2 _17706_/X _11774_/A VPWR VGND sg13g2_a22oi_1
XFILLER_3_1539 VPWR VGND sg13g2_decap_8
X_14937_ _14939_/C _22464_/Q _14947_/B VPWR VGND sg13g2_nand2_1
XFILLER_76_882 VPWR VGND sg13g2_decap_8
XFILLER_40_1770 VPWR VGND sg13g2_decap_4
XFILLER_91_852 VPWR VGND sg13g2_decap_8
XFILLER_24_908 VPWR VGND sg13g2_decap_8
X_17656_ _17656_/X _22975_/Q _22959_/Q _17697_/A VPWR VGND sg13g2_mux2_1
XFILLER_58_1519 VPWR VGND sg13g2_fill_1
X_14868_ _16250_/A _14051_/A _14825_/Y _14867_/Y VPWR VGND sg13g2_o21ai_1
XFILLER_36_768 VPWR VGND sg13g2_decap_8
XFILLER_75_1800 VPWR VGND sg13g2_decap_8
XFILLER_51_705 VPWR VGND sg13g2_decap_4
XFILLER_63_576 VPWR VGND sg13g2_decap_4
X_16607_ _22636_/D _15693_/A _16610_/A _16606_/Y VPWR VGND sg13g2_a21oi_1
XFILLER_56_1210 VPWR VGND sg13g2_decap_4
X_13819_ _13819_/X _13812_/X _13816_/Y _13817_/X _13818_/X _14129_/B _12050_/B VPWR
+ VGND sg13g2_mux4_1
X_17587_ _17587_/Y _23160_/Q _17734_/A2 _17699_/B1 _17584_/X _17586_/Y VPWR VGND sg13g2_a221oi_1
X_14799_ _14801_/B _17838_/B _14882_/B VPWR VGND sg13g2_xnor2_1
XFILLER_91_1123 VPWR VGND sg13g2_decap_8
XFILLER_32_930 VPWR VGND sg13g2_fill_2
XFILLER_16_492 VPWR VGND sg13g2_decap_4
X_16538_ _16538_/Y _16561_/A _16538_/B VPWR VGND sg13g2_nor2_1
XFILLER_108_1344 VPWR VGND sg13g2_decap_4
XFILLER_17_1227 VPWR VGND sg13g2_decap_4
XFILLER_52_1129 VPWR VGND sg13g2_fill_2
X_19257_ _19257_/Y _19265_/A _19257_/B VPWR VGND sg13g2_nor2_1
XFILLER_34_1541 VPWR VGND sg13g2_fill_1
X_16469_ _22597_/D _17866_/A _16514_/B _16468_/Y VPWR VGND sg13g2_o21ai_1
XFILLER_108_1399 VPWR VGND sg13g2_fill_2
X_18208_ _18208_/X _18399_/A _18224_/B _18485_/A VPWR VGND sg13g2_a21o_1
XFILLER_78_0 VPWR VGND sg13g2_decap_4
XFILLER_30_1405 VPWR VGND sg13g2_fill_2
X_19188_ _19188_/Y _23192_/Q _19190_/B VPWR VGND sg13g2_nand2_1
XFILLER_34_1596 VPWR VGND sg13g2_decap_4
Xoutput4467 core_busy_o _14260_/Y VPWR VGND sg13g2_buf_1
Xoutput4478 data_addr_o[20] _24265_/X VPWR VGND sg13g2_buf_1
Xoutput4489 data_addr_o[30] _24275_/X VPWR VGND sg13g2_buf_1
XFILLER_69_1648 VPWR VGND sg13g2_fill_1
X_21150_ _23601_/D _23601_/Q _21617_/A0 _21153_/S VPWR VGND sg13g2_mux2_1
XFILLER_105_718 VPWR VGND sg13g2_decap_4
XFILLER_12_1883 VPWR VGND sg13g2_decap_8
XFILLER_104_206 VPWR VGND sg13g2_decap_4
X_20101_ _20101_/Y _20266_/B2 _20094_/Y _20100_/Y VPWR VGND sg13g2_a21oi_1
XFILLER_67_1372 VPWR VGND sg13g2_fill_1
XFILLER_63_1214 VPWR VGND sg13g2_decap_4
XFILLER_115_1304 VPWR VGND sg13g2_decap_8
X_20032_ _20032_/Y _20033_/A1 _19662_/Y _20031_/Y VPWR VGND sg13g2_o21ai_1
XFILLER_98_473 VPWR VGND sg13g2_decap_8
XFILLER_59_838 VPWR VGND sg13g2_fill_2
XFILLER_98_495 VPWR VGND sg13g2_decap_8
XFILLER_28_1389 VPWR VGND sg13g2_decap_8
XFILLER_80_1550 VPWR VGND sg13g2_fill_1
XFILLER_41_1501 VPWR VGND sg13g2_fill_2
XFILLER_100_434 VPWR VGND sg13g2_decap_4
XFILLER_100_456 VPWR VGND sg13g2_decap_8
XFILLER_37_49 VPWR VGND sg13g2_fill_1
XFILLER_39_562 VPWR VGND sg13g2_fill_1
X_21983_ _23988_/D _21983_/A1 _21982_/B _21982_/Y VPWR VGND sg13g2_o21ai_1
XFILLER_26_201 VPWR VGND sg13g2_fill_1
XFILLER_82_830 VPWR VGND sg13g2_decap_8
X_20934_ _20934_/Y _20934_/A _20936_/B VPWR VGND sg13g2_nand2_1
X_23722_ _23722_/Q clkload45/A _23722_/D fanout2733/X VPWR VGND sg13g2_dfrbpq_1
XFILLER_82_863 VPWR VGND sg13g2_fill_2
XFILLER_93_1900 VPWR VGND sg13g2_decap_8
XFILLER_81_373 VPWR VGND sg13g2_decap_8
X_20865_ _23479_/D _20931_/A1 _20902_/S _20864_/Y VPWR VGND sg13g2_o21ai_1
X_23653_ _23653_/Q clkload42/A _23653_/D fanout2718/X VPWR VGND sg13g2_dfrbpq_1
XFILLER_53_26 VPWR VGND sg13g2_decap_8
XFILLER_39_1452 VPWR VGND sg13g2_decap_4
XFILLER_39_1463 VPWR VGND sg13g2_decap_4
X_22604_ _22604_/Q clkload10/A _22604_/D fanout2814/X VPWR VGND sg13g2_dfrbpq_1
X_23584_ _23584_/Q clkload39/A _23584_/D fanout2739/X VPWR VGND sg13g2_dfrbpq_1
X_20796_ _20796_/Y _20796_/A _20801_/B VPWR VGND sg13g2_nand2_1
X_22535_ _22535_/Q clkload6/A _22535_/D fanout2803/X VPWR VGND sg13g2_dfrbpq_1
XFILLER_50_793 VPWR VGND sg13g2_fill_2
XFILLER_33_1040 VPWR VGND sg13g2_fill_1
X_22466_ _22466_/Q clkload18/A _22466_/D fanout2827/X VPWR VGND sg13g2_dfrbpq_1
XFILLER_13_1636 VPWR VGND sg13g2_fill_2
XFILLER_104_1764 VPWR VGND sg13g2_fill_1
XFILLER_13_1647 VPWR VGND sg13g2_fill_1
X_24205_ _24205_/Q _24205_/CLK _24205_/D fanout2645/X VPWR VGND sg13g2_dfrbpq_1
X_21417_ _23728_/D _21616_/A1 _21422_/B _21416_/Y VPWR VGND sg13g2_o21ai_1
XFILLER_68_1103 VPWR VGND sg13g2_decap_4
XFILLER_108_545 VPWR VGND sg13g2_decap_8
XFILLER_87_1748 VPWR VGND sg13g2_decap_8
X_24136_ _24136_/Q clkload32/A _24136_/D fanout2648/X VPWR VGND sg13g2_dfrbpq_1
X_21348_ _23696_/D _21616_/A1 _21347_/B _21347_/Y VPWR VGND sg13g2_o21ai_1
XFILLER_2_834 VPWR VGND sg13g2_fill_1
Xfanout2804 fanout2804/X fanout2805/X VPWR VGND sg13g2_buf_1
X_12081_ _12082_/D _15410_/A _12079_/Y _12080_/Y VPWR VGND sg13g2_a21oi_1
Xfanout2815 fanout2815/X fanout2816/X VPWR VGND sg13g2_buf_1
X_24067_ _24067_/Q clkload45/A _24067_/D fanout2712/X VPWR VGND sg13g2_dfrbpq_1
XFILLER_104_740 VPWR VGND sg13g2_fill_2
Xfanout2826 fanout2826/X fanout2831/X VPWR VGND sg13g2_buf_1
XFILLER_46_1423 VPWR VGND sg13g2_decap_8
X_21279_ _23662_/D _21345_/A1 _21281_/B _21278_/Y VPWR VGND sg13g2_o21ai_1
XFILLER_1_344 VPWR VGND sg13g2_fill_1
Xfanout2837 fanout2837/X fanout2839/X VPWR VGND sg13g2_buf_1
XFILLER_2_878 VPWR VGND sg13g2_fill_2
X_23018_ _23018_/Q clkload6/A _23018_/D fanout2804/X VPWR VGND sg13g2_dfrbpq_1
Xfanout2848 fanout2848/X fanout2849/X VPWR VGND sg13g2_buf_1
Xfanout2859 fanout2859/X fanout2860/X VPWR VGND sg13g2_buf_1
XFILLER_89_484 VPWR VGND sg13g2_decap_4
XFILLER_8_1951 VPWR VGND sg13g2_decap_4
XFILLER_49_348 VPWR VGND sg13g2_decap_4
X_15840_ _17182_/A _15839_/A _15838_/Y _15839_/Y VPWR VGND sg13g2_a21o_1
XFILLER_77_657 VPWR VGND sg13g2_decap_8
XFILLER_115_1882 VPWR VGND sg13g2_decap_8
XFILLER_4_1837 VPWR VGND sg13g2_decap_8
XFILLER_92_627 VPWR VGND sg13g2_decap_8
XFILLER_91_104 VPWR VGND sg13g2_fill_1
XFILLER_64_318 VPWR VGND sg13g2_fill_2
XFILLER_92_638 VPWR VGND sg13g2_fill_2
X_15771_ _15771_/Y _15771_/A _15771_/B _15771_/C _15771_/D VPWR VGND sg13g2_nand4_1
X_12983_ _12983_/X _12983_/A _13028_/B _12983_/C VPWR VGND sg13g2_or3_1
XFILLER_45_521 VPWR VGND sg13g2_fill_1
XFILLER_79_1243 VPWR VGND sg13g2_fill_2
X_17510_ _17510_/Y _22872_/Q _17512_/S VPWR VGND sg13g2_nand2_1
X_14722_ _14722_/X _14719_/Y _14721_/Y _14739_/S VPWR VGND sg13g2_mux2_1
X_18490_ _18834_/B _18010_/B _23072_/Q _18548_/S VPWR VGND sg13g2_mux2_1
XFILLER_59_1839 VPWR VGND sg13g2_fill_2
XFILLER_17_256 VPWR VGND sg13g2_decap_8
XFILLER_27_93 VPWR VGND sg13g2_decap_8
XFILLER_45_576 VPWR VGND sg13g2_fill_1
XFILLER_73_896 VPWR VGND sg13g2_decap_8
XFILLER_33_738 VPWR VGND sg13g2_decap_8
X_14653_ _14653_/X _14653_/A _14653_/B _14653_/C _14653_/D VPWR VGND sg13g2_or4_1
XFILLER_96_1590 VPWR VGND sg13g2_fill_2
X_11865_ _14041_/B _11865_/A _11865_/B VPWR VGND sg13g2_xnor2_1
XFILLER_26_790 VPWR VGND sg13g2_decap_4
X_13604_ _13604_/Y _13604_/A _14013_/A VPWR VGND sg13g2_xnor2_1
X_17372_ _17372_/Y _17372_/A _14763_/B VPWR VGND sg13g2_nor2b_1
XFILLER_57_1574 VPWR VGND sg13g2_fill_2
X_11796_ _11803_/A _12473_/A _11796_/B VPWR VGND sg13g2_nor2_1
X_14584_ _24242_/D _17042_/C _14609_/C _14584_/C VPWR VGND sg13g2_and3_1
XFILLER_18_1547 VPWR VGND sg13g2_fill_1
X_19111_ _23091_/D _23091_/Q _19110_/X _19115_/S VPWR VGND sg13g2_mux2_1
X_16323_ _16324_/D _16318_/A _16323_/B _16323_/C VPWR VGND sg13g2_nand3b_1
XFILLER_53_1449 VPWR VGND sg13g2_decap_8
X_13535_ _14090_/B _13535_/A _14154_/B VPWR VGND sg13g2_nand2_1
Xplace3709 _20193_/B _13247_/Y VPWR VGND sg13g2_buf_2
X_19042_ _19043_/B _19041_/Y _23061_/Q _19042_/S VPWR VGND sg13g2_mux2_1
XFILLER_31_1714 VPWR VGND sg13g2_decap_8
XFILLER_71_7 VPWR VGND sg13g2_fill_2
X_13466_ _13466_/X _13466_/A _23917_/Q VPWR VGND sg13g2_and2_1
XFILLER_70_1774 VPWR VGND sg13g2_decap_4
XFILLER_16_1293 VPWR VGND sg13g2_fill_1
XFILLER_51_1173 VPWR VGND sg13g2_decap_8
X_15205_ _15482_/A _16789_/A _19401_/B VPWR VGND sg13g2_and2_1
XFILLER_31_1758 VPWR VGND sg13g2_fill_1
XFILLER_51_1184 VPWR VGND sg13g2_fill_2
XFILLER_51_1195 VPWR VGND sg13g2_fill_2
XFILLER_103_1263 VPWR VGND sg13g2_decap_8
X_16185_ _16185_/Y _16185_/A _16193_/B VPWR VGND sg13g2_nand2_1
XFILLER_12_1157 VPWR VGND sg13g2_decap_8
X_13397_ _13397_/X _24076_/Q _24140_/Q _13565_/A VPWR VGND sg13g2_mux2_1
XFILLER_114_515 VPWR VGND sg13g2_decap_8
XFILLER_86_1247 VPWR VGND sg13g2_fill_2
X_12348_ _12532_/B _12341_/A _12341_/B _12533_/A _12533_/B VPWR VGND sg13g2_a22oi_1
XFILLER_99_226 VPWR VGND sg13g2_fill_2
XFILLER_5_683 VPWR VGND sg13g2_fill_2
X_15067_ _15068_/C _22508_/Q _15067_/B VPWR VGND sg13g2_nand2_1
X_19944_ _19945_/A _20255_/A1 _23206_/Q _23214_/Q _20255_/A2 _20019_/S0 _20072_/S1
+ VPWR VGND sg13g2_mux4_1
XFILLER_4_193 VPWR VGND sg13g2_fill_2
XFILLER_49_1080 VPWR VGND sg13g2_fill_2
XFILLER_64_1534 VPWR VGND sg13g2_decap_4
X_19875_ _19875_/Y _19874_/B _19557_/X _19874_/Y _19735_/B _20030_/S VPWR VGND sg13g2_a221oi_1
XFILLER_9_1759 VPWR VGND sg13g2_decap_8
XFILLER_60_1409 VPWR VGND sg13g2_decap_8
XFILLER_29_1698 VPWR VGND sg13g2_fill_2
X_18826_ _23038_/D _18826_/A _18826_/B _18826_/C VPWR VGND sg13g2_nand3_1
XFILLER_56_819 VPWR VGND sg13g2_fill_2
XFILLER_67_145 VPWR VGND sg13g2_fill_2
XFILLER_23_1231 VPWR VGND sg13g2_decap_4
XFILLER_49_860 VPWR VGND sg13g2_fill_1
XFILLER_7_1472 VPWR VGND sg13g2_fill_1
XFILLER_110_787 VPWR VGND sg13g2_decap_8
X_18757_ _18757_/Y _18757_/A _18757_/B VPWR VGND sg13g2_nand2_1
XFILLER_95_498 VPWR VGND sg13g2_fill_1
XFILLER_3_1336 VPWR VGND sg13g2_decap_8
X_15969_ _15975_/A _15969_/A _15969_/B VPWR VGND sg13g2_nand2_1
XFILLER_82_126 VPWR VGND sg13g2_fill_2
XFILLER_23_1286 VPWR VGND sg13g2_decap_8
XFILLER_110_1245 VPWR VGND sg13g2_decap_8
XFILLER_77_1928 VPWR VGND sg13g2_decap_8
XFILLER_36_543 VPWR VGND sg13g2_decap_8
X_18688_ _18689_/B _18688_/A _18690_/B VPWR VGND sg13g2_nand2_1
XFILLER_36_576 VPWR VGND sg13g2_decap_8
XFILLER_64_885 VPWR VGND sg13g2_fill_1
XFILLER_97_1387 VPWR VGND sg13g2_decap_4
XFILLER_58_1338 VPWR VGND sg13g2_decap_8
XFILLER_23_204 VPWR VGND sg13g2_decap_8
X_17639_ _17639_/Y _23165_/Q _17815_/A2 _17689_/B1 _17638_/Y VPWR VGND sg13g2_a22oi_1
XFILLER_58_1349 VPWR VGND sg13g2_fill_2
XFILLER_23_215 VPWR VGND sg13g2_decap_4
XFILLER_24_749 VPWR VGND sg13g2_decap_8
XFILLER_36_1614 VPWR VGND sg13g2_fill_2
XFILLER_17_1013 VPWR VGND sg13g2_decap_8
XFILLER_32_760 VPWR VGND sg13g2_decap_8
X_19309_ _19311_/A _14399_/C _19308_/Y _16858_/A VPWR VGND sg13g2_a21oi_1
X_20581_ _20581_/Y _23348_/Q _20581_/B VPWR VGND sg13g2_nand2_1
XFILLER_104_1005 VPWR VGND sg13g2_fill_2
XFILLER_53_1950 VPWR VGND sg13g2_decap_4
XFILLER_108_1185 VPWR VGND sg13g2_decap_8
XFILLER_30_1202 VPWR VGND sg13g2_fill_1
XFILLER_101_1915 VPWR VGND sg13g2_decap_8
XFILLER_10_1809 VPWR VGND sg13g2_decap_8
XFILLER_30_1235 VPWR VGND sg13g2_decap_8
X_22251_ _24116_/D _22317_/A1 _22250_/B _22250_/Y VPWR VGND sg13g2_o21ai_1
XFILLER_69_1412 VPWR VGND sg13g2_decap_8
XFILLER_30_1246 VPWR VGND sg13g2_fill_1
XFILLER_30_1257 VPWR VGND sg13g2_decap_8
Xhold4901 _22103_/A _24043_/Q VPWR VGND sg13g2_dlygate4sd3_1
X_22182_ _24082_/D _22314_/A1 _22184_/B _22181_/Y VPWR VGND sg13g2_o21ai_1
Xhold4912 _22058_/A _24022_/Q VPWR VGND sg13g2_dlygate4sd3_1
Xhold4923 _21633_/A _23831_/Q VPWR VGND sg13g2_dlygate4sd3_1
XFILLER_105_537 VPWR VGND sg13g2_decap_8
Xhold4934 _22151_/A _24066_/Q VPWR VGND sg13g2_dlygate4sd3_1
X_21133_ _23591_/D _21333_/A1 _21151_/B _21132_/Y VPWR VGND sg13g2_o21ai_1
Xhold4945 _20569_/A _23340_/Q VPWR VGND sg13g2_dlygate4sd3_1
Xhold4956 _20494_/A _23307_/Q VPWR VGND sg13g2_dlygate4sd3_1
XFILLER_63_1011 VPWR VGND sg13g2_fill_2
Xhold4967 _22335_/A _24155_/Q VPWR VGND sg13g2_dlygate4sd3_1
XFILLER_47_1754 VPWR VGND sg13g2_fill_1
Xhold4978 _22400_/A _24186_/Q VPWR VGND sg13g2_dlygate4sd3_1
XFILLER_82_1645 VPWR VGND sg13g2_decap_8
X_21064_ _21064_/Y _21064_/A _21079_/B VPWR VGND sg13g2_nand2_1
Xhold4989 _20533_/A _23323_/Q VPWR VGND sg13g2_dlygate4sd3_1
XFILLER_58_101 VPWR VGND sg13g2_decap_4
XFILLER_59_646 VPWR VGND sg13g2_fill_1
X_20015_ _20016_/C _20015_/A _20015_/B _20015_/C VPWR VGND sg13g2_nor3_1
XFILLER_115_1145 VPWR VGND sg13g2_decap_8
XFILLER_58_134 VPWR VGND sg13g2_fill_2
XFILLER_63_1077 VPWR VGND sg13g2_fill_1
XFILLER_63_1088 VPWR VGND sg13g2_decap_8
XFILLER_86_465 VPWR VGND sg13g2_decap_4
XFILLER_47_819 VPWR VGND sg13g2_fill_1
XFILLER_74_605 VPWR VGND sg13g2_decap_8
XFILLER_104_21 VPWR VGND sg13g2_decap_8
XFILLER_58_167 VPWR VGND sg13g2_decap_4
XFILLER_21_1938 VPWR VGND sg13g2_decap_8
XFILLER_100_297 VPWR VGND sg13g2_fill_1
XFILLER_67_690 VPWR VGND sg13g2_decap_8
XFILLER_27_532 VPWR VGND sg13g2_decap_4
XFILLER_41_1386 VPWR VGND sg13g2_fill_2
XFILLER_55_863 VPWR VGND sg13g2_fill_1
XFILLER_104_98 VPWR VGND sg13g2_decap_8
X_21966_ _21966_/Y _23978_/Q _21976_/B VPWR VGND sg13g2_nand2_1
XFILLER_55_874 VPWR VGND sg13g2_fill_1
X_23705_ _23705_/Q _23966_/CLK _23705_/D fanout2783/X VPWR VGND sg13g2_dfrbpq_1
XFILLER_82_682 VPWR VGND sg13g2_decap_8
XFILLER_15_727 VPWR VGND sg13g2_decap_8
XFILLER_14_204 VPWR VGND sg13g2_fill_1
XFILLER_27_587 VPWR VGND sg13g2_decap_4
X_20917_ _23506_/D _21980_/A1 _20919_/B _20916_/Y VPWR VGND sg13g2_o21ai_1
XFILLER_110_1790 VPWR VGND sg13g2_fill_2
XFILLER_81_192 VPWR VGND sg13g2_fill_1
XFILLER_70_855 VPWR VGND sg13g2_fill_2
XFILLER_93_1763 VPWR VGND sg13g2_decap_8
XFILLER_74_1140 VPWR VGND sg13g2_fill_2
XFILLER_19_1834 VPWR VGND sg13g2_decap_4
X_20848_ _23472_/D _22445_/A1 _20847_/B _20847_/Y VPWR VGND sg13g2_o21ai_1
XFILLER_58_1883 VPWR VGND sg13g2_fill_2
X_23636_ _23636_/Q clkload32/A _23636_/D fanout2671/X VPWR VGND sg13g2_dfrbpq_1
XFILLER_19_1845 VPWR VGND sg13g2_fill_1
XFILLER_39_1271 VPWR VGND sg13g2_decap_8
XFILLER_54_1725 VPWR VGND sg13g2_decap_8
XFILLER_106_1804 VPWR VGND sg13g2_fill_2
XFILLER_54_1736 VPWR VGND sg13g2_fill_2
XFILLER_35_1124 VPWR VGND sg13g2_decap_8
XFILLER_74_1184 VPWR VGND sg13g2_decap_8
X_11581_ _11581_/Y _11633_/C _11579_/Y _11580_/Y VPWR VGND sg13g2_o21ai_1
XFILLER_54_1769 VPWR VGND sg13g2_fill_1
X_23567_ _23567_/Q clkload47/A _23567_/D fanout2661/X VPWR VGND sg13g2_dfrbpq_1
X_20779_ _23440_/D _22445_/A1 _20778_/B _20778_/Y VPWR VGND sg13g2_o21ai_1
XFILLER_22_292 VPWR VGND sg13g2_decap_8
XFILLER_35_1179 VPWR VGND sg13g2_decap_8
X_13320_ _13320_/X _13315_/X _13316_/X _13317_/X _13318_/X _13681_/S _12050_/B VPWR
+ VGND sg13g2_mux4_1
X_22518_ _22518_/Q clkload11/A _22518_/D fanout2837/X VPWR VGND sg13g2_dfrbpq_1
XFILLER_10_454 VPWR VGND sg13g2_decap_8
X_23498_ _23498_/Q _24196_/CLK _23498_/D fanout2704/X VPWR VGND sg13g2_dfrbpq_1
XFILLER_109_843 VPWR VGND sg13g2_fill_2
X_22449_ _24211_/D _24211_/Q _22449_/A1 _22449_/S VPWR VGND sg13g2_mux2_1
X_13251_ _13251_/Y _24138_/Q _13251_/B VPWR VGND sg13g2_nand2b_1
XFILLER_6_447 VPWR VGND sg13g2_decap_8
XFILLER_89_33 VPWR VGND sg13g2_decap_8
X_12202_ _12209_/A _12473_/A _12202_/B VPWR VGND sg13g2_nor2_1
X_13182_ _13373_/D _23176_/Q _12640_/B _13181_/X _13182_/B2 VPWR VGND sg13g2_a22oi_1
XFILLER_108_375 VPWR VGND sg13g2_decap_4
XFILLER_100_1458 VPWR VGND sg13g2_decap_8
XFILLER_100_1469 VPWR VGND sg13g2_decap_8
X_12133_ _12133_/Y _12193_/S _23580_/Q _12132_/Y VPWR VGND sg13g2_o21ai_1
X_24119_ _24119_/Q clkload48/A _24119_/D fanout2688/X VPWR VGND sg13g2_dfrbpq_1
XFILLER_8_0 VPWR VGND sg13g2_fill_2
X_17990_ _18155_/A _18560_/S _17986_/X _17989_/Y VPWR VGND sg13g2_a21o_1
XFILLER_81_1100 VPWR VGND sg13g2_decap_8
XFILLER_65_1843 VPWR VGND sg13g2_decap_8
XFILLER_46_1231 VPWR VGND sg13g2_decap_8
Xfanout2623 fanout2623/X fanout2624/X VPWR VGND sg13g2_buf_1
XFILLER_78_911 VPWR VGND sg13g2_decap_4
Xfanout2634 fanout2634/X fanout2637/X VPWR VGND sg13g2_buf_1
XFILLER_65_1854 VPWR VGND sg13g2_fill_1
X_16941_ _22698_/D _16940_/X _17130_/A _16946_/S VPWR VGND sg13g2_mux2_1
X_12064_ _12065_/D _13624_/A _12064_/B VPWR VGND sg13g2_nor2_1
Xfanout2645 fanout2645/X fanout2646/X VPWR VGND sg13g2_buf_1
Xfanout2656 fanout2656/X fanout2660/X VPWR VGND sg13g2_buf_1
Xfanout2667 fanout2667/X fanout2668/X VPWR VGND sg13g2_buf_1
XFILLER_61_1729 VPWR VGND sg13g2_decap_8
Xfanout2678 fanout2678/X fanout2692/X VPWR VGND sg13g2_buf_1
XFILLER_42_1117 VPWR VGND sg13g2_fill_1
XFILLER_113_1808 VPWR VGND sg13g2_decap_8
Xfanout2689 fanout2689/X fanout2690/X VPWR VGND sg13g2_buf_1
XFILLER_38_808 VPWR VGND sg13g2_fill_1
X_18611_ _18611_/Y _18623_/A _18666_/A _14828_/A VPWR VGND sg13g2_o21ai_1
X_15823_ _15823_/Y _15981_/S _16165_/A VPWR VGND sg13g2_nor2_1
X_19591_ _19591_/Y _19634_/B _19700_/B VPWR VGND sg13g2_nor2_1
XFILLER_37_329 VPWR VGND sg13g2_fill_1
XFILLER_4_1656 VPWR VGND sg13g2_decap_8
XFILLER_24_1584 VPWR VGND sg13g2_decap_4
XFILLER_93_969 VPWR VGND sg13g2_decap_8
X_18542_ _18542_/Y _18542_/A _18542_/B VPWR VGND sg13g2_nand2_1
XFILLER_92_468 VPWR VGND sg13g2_decap_8
XFILLER_59_1614 VPWR VGND sg13g2_decap_8
X_15754_ _15754_/Y _15905_/A _20168_/A VPWR VGND sg13g2_nor2_1
XFILLER_94_1505 VPWR VGND sg13g2_fill_2
X_12966_ _12966_/X _12966_/A _12966_/B VPWR VGND sg13g2_or2_1
XFILLER_18_554 VPWR VGND sg13g2_decap_8
XFILLER_61_811 VPWR VGND sg13g2_fill_1
XFILLER_94_1538 VPWR VGND sg13g2_decap_8
X_14705_ _14705_/Y _13217_/B _14718_/B _14704_/Y VPWR VGND sg13g2_a21oi_1
X_11917_ _11921_/B _11917_/A _11917_/B VPWR VGND sg13g2_nor2_1
X_18473_ _18473_/X _18049_/B _18828_/B _18473_/S VPWR VGND sg13g2_mux2_1
X_15685_ _15688_/B _14217_/A _15804_/B1 _16004_/B1 _22821_/Q VPWR VGND sg13g2_a22oi_1
XFILLER_33_524 VPWR VGND sg13g2_decap_8
XFILLER_61_833 VPWR VGND sg13g2_decap_8
X_12897_ _12897_/Y _12897_/A _12897_/B _12897_/C _12897_/D VPWR VGND sg13g2_nor4_2
XFILLER_33_535 VPWR VGND sg13g2_fill_2
XFILLER_18_1300 VPWR VGND sg13g2_decap_8
X_17424_ _22831_/D _16504_/Y _17425_/B _17423_/Y VPWR VGND sg13g2_o21ai_1
XFILLER_18_1311 VPWR VGND sg13g2_fill_2
XFILLER_60_343 VPWR VGND sg13g2_decap_8
X_11848_ _11848_/Y _13234_/B2 _11847_/Y _12606_/A VPWR VGND sg13g2_a21oi_1
XFILLER_18_1333 VPWR VGND sg13g2_fill_2
Xplace4207 _13961_/S0 _12577_/C VPWR VGND sg13g2_buf_2
X_17355_ _22804_/D _17175_/A _22804_/Q _17369_/B VPWR VGND sg13g2_mux2_1
X_14567_ _24229_/D _14561_/Y _16233_/B _16215_/A VPWR VGND sg13g2_a21oi_1
Xplace4218 _11688_/A _22984_/Q VPWR VGND sg13g2_buf_1
X_11779_ _11781_/C _12959_/A _12075_/B VPWR VGND sg13g2_xnor2_1
Xplace4229 _13578_/S1 _13582_/A VPWR VGND sg13g2_buf_1
XFILLER_109_1494 VPWR VGND sg13g2_fill_2
Xrebuffer5219 _14064_/A _12940_/X VPWR VGND sg13g2_buf_8
X_16306_ _16324_/C _16304_/X _16305_/Y _15043_/B _22534_/Q VPWR VGND sg13g2_a22oi_1
Xplace3506 _20201_/B _19311_/A VPWR VGND sg13g2_buf_1
XFILLER_18_1399 VPWR VGND sg13g2_fill_1
Xplace3517 _19209_/S _19229_/S VPWR VGND sg13g2_buf_1
X_13518_ _13522_/C _13518_/A1 _13514_/B _13517_/Y VPWR VGND sg13g2_o21ai_1
XFILLER_105_1358 VPWR VGND sg13g2_fill_2
X_17286_ _22772_/D _17902_/B2 _22772_/Q _17293_/B VPWR VGND sg13g2_mux2_1
XFILLER_105_1369 VPWR VGND sg13g2_fill_1
X_14498_ _14508_/A _22595_/Q _23006_/Q VPWR VGND sg13g2_xnor2_1
Xplace3528 _16007_/B _15945_/B1 VPWR VGND sg13g2_buf_1
Xplace3539 _19171_/S _19176_/B VPWR VGND sg13g2_buf_1
X_19025_ _19025_/Y _19045_/B _23091_/Q _19047_/C VPWR VGND sg13g2_nand3_1
X_16237_ _16237_/Y _22518_/Q _16241_/A _16241_/B _16237_/D VPWR VGND sg13g2_nand4_1
Xclkload11 clkload11/X clkload11/A VPWR VGND sg13g2_buf_8
Xclkload22 clkload22/X clkload22/A VPWR VGND sg13g2_buf_16
X_13449_ _13449_/Y _13449_/A _13449_/B VPWR VGND sg13g2_xnor2_1
Xclkload33 clkload33/Y clkload33/A VPWR VGND sg13g2_inv_2
XFILLER_31_1566 VPWR VGND sg13g2_decap_4
Xclkload44 clkload44/Y clkload44/A VPWR VGND sg13g2_inv_2
Xclkload55 clkload55/Y clkload55/A VPWR VGND sg13g2_inv_1
XFILLER_115_824 VPWR VGND sg13g2_decap_8
XFILLER_114_301 VPWR VGND sg13g2_fill_2
XFILLER_66_1629 VPWR VGND sg13g2_fill_2
XFILLER_83_1910 VPWR VGND sg13g2_fill_1
X_15119_ _16333_/A _15112_/Y _14918_/B _18756_/A VPWR VGND sg13g2_o21ai_1
XFILLER_47_1039 VPWR VGND sg13g2_decap_4
X_16099_ _16099_/Y _16099_/A _16209_/B VPWR VGND sg13g2_nand2_1
XFILLER_69_900 VPWR VGND sg13g2_decap_4
XFILLER_83_1954 VPWR VGND sg13g2_fill_1
X_19927_ _19927_/X _19803_/B _20162_/A _19928_/B VPWR VGND sg13g2_mux2_1
XFILLER_44_1916 VPWR VGND sg13g2_fill_2
XFILLER_69_933 VPWR VGND sg13g2_decap_4
XFILLER_9_1556 VPWR VGND sg13g2_decap_8
XFILLER_29_1484 VPWR VGND sg13g2_fill_2
XFILLER_69_955 VPWR VGND sg13g2_decap_8
XFILLER_69_966 VPWR VGND sg13g2_fill_1
XFILLER_69_977 VPWR VGND sg13g2_decap_8
X_19858_ _23227_/D _19857_/B _22403_/A1 _19857_/Y VPWR VGND sg13g2_o21ai_1
XFILLER_112_1307 VPWR VGND sg13g2_decap_8
XFILLER_25_1359 VPWR VGND sg13g2_decap_8
XFILLER_99_1427 VPWR VGND sg13g2_fill_1
XFILLER_28_318 VPWR VGND sg13g2_decap_8
XFILLER_56_627 VPWR VGND sg13g2_decap_8
X_18809_ _18809_/Y _18866_/A _18809_/B VPWR VGND sg13g2_nand2_1
XFILLER_7_1291 VPWR VGND sg13g2_decap_8
XFILLER_110_1031 VPWR VGND sg13g2_decap_8
X_21820_ _21820_/Y _21820_/A _21833_/B VPWR VGND sg13g2_nand2_1
XFILLER_77_1725 VPWR VGND sg13g2_decap_8
XFILLER_77_1747 VPWR VGND sg13g2_decap_4
X_21751_ _21751_/Y _23878_/Q _21751_/B VPWR VGND sg13g2_nand2_1
XFILLER_52_833 VPWR VGND sg13g2_decap_8
XFILLER_64_693 VPWR VGND sg13g2_decap_8
XFILLER_34_17 VPWR VGND sg13g2_fill_2
XFILLER_91_490 VPWR VGND sg13g2_fill_1
XFILLER_52_855 VPWR VGND sg13g2_decap_8
X_20702_ _23404_/D _20702_/A1 _20713_/B _20701_/Y VPWR VGND sg13g2_o21ai_1
XFILLER_52_877 VPWR VGND sg13g2_fill_2
X_21682_ _23854_/D _21974_/A1 _21690_/B _21681_/Y VPWR VGND sg13g2_o21ai_1
XFILLER_75_1460 VPWR VGND sg13g2_decap_8
XFILLER_71_1313 VPWR VGND sg13g2_decap_8
X_23421_ _23421_/Q clkload53/A _23421_/D fanout2777/X VPWR VGND sg13g2_dfrbpq_1
X_20633_ _20633_/Y _20633_/A _20647_/B VPWR VGND sg13g2_nand2_1
X_23352_ _23352_/Q clkload54/A _23352_/D fanout2761/X VPWR VGND sg13g2_dfrbpq_1
Xclkload5 clkload5/X clkload5/A VPWR VGND sg13g2_buf_8
X_20564_ _23337_/D _23337_/Q _22433_/A1 _20580_/S VPWR VGND sg13g2_mux2_1
X_22303_ _24139_/D _20217_/Y _22310_/B _22302_/Y VPWR VGND sg13g2_o21ai_1
XFILLER_105_1870 VPWR VGND sg13g2_decap_8
XFILLER_20_796 VPWR VGND sg13g2_fill_2
X_23283_ _23283_/Q clkload50/A _23283_/D fanout2661/X VPWR VGND sg13g2_dfrbpq_1
X_20495_ _23307_/D _20700_/A1 _20512_/B _20494_/Y VPWR VGND sg13g2_o21ai_1
XFILLER_30_1065 VPWR VGND sg13g2_decap_4
XFILLER_49_1805 VPWR VGND sg13g2_fill_1
X_22234_ _22234_/Y _22234_/A _22241_/B VPWR VGND sg13g2_nand2_1
XFILLER_105_323 VPWR VGND sg13g2_decap_8
XFILLER_101_1789 VPWR VGND sg13g2_decap_8
XFILLER_30_1098 VPWR VGND sg13g2_fill_2
XFILLER_69_1275 VPWR VGND sg13g2_decap_8
XFILLER_105_334 VPWR VGND sg13g2_fill_1
Xhold4720 _22339_/A _24157_/Q VPWR VGND sg13g2_dlygate4sd3_1
XFILLER_105_345 VPWR VGND sg13g2_fill_1
Xhold4731 _21284_/A _23666_/Q VPWR VGND sg13g2_dlygate4sd3_1
XFILLER_1_7 VPWR VGND sg13g2_decap_8
Xhold4742 _22108_/A _24046_/Q VPWR VGND sg13g2_dlygate4sd3_1
Xhold4753 _20729_/A _23416_/Q VPWR VGND sg13g2_dlygate4sd3_1
XFILLER_47_1540 VPWR VGND sg13g2_fill_1
Xhold4764 _19894_/A _23228_/Q VPWR VGND sg13g2_dlygate4sd3_1
X_21116_ _23583_/D _21317_/A1 _21121_/B _21115_/Y VPWR VGND sg13g2_o21ai_1
Xhold4775 _20662_/A _23385_/Q VPWR VGND sg13g2_dlygate4sd3_1
Xhold4786 _17248_/A _22755_/Q VPWR VGND sg13g2_dlygate4sd3_1
X_22096_ _24039_/D _22296_/A1 _22095_/B _22095_/Y VPWR VGND sg13g2_o21ai_1
Xhold4797 _22383_/A _24180_/Q VPWR VGND sg13g2_dlygate4sd3_1
XFILLER_115_42 VPWR VGND sg13g2_decap_8
XFILLER_101_551 VPWR VGND sg13g2_decap_8
XFILLER_5_1910 VPWR VGND sg13g2_decap_8
XFILLER_47_605 VPWR VGND sg13g2_decap_8
XFILLER_75_914 VPWR VGND sg13g2_decap_8
XFILLER_86_262 VPWR VGND sg13g2_decap_4
XFILLER_60_1751 VPWR VGND sg13g2_decap_8
XFILLER_74_413 VPWR VGND sg13g2_fill_1
XFILLER_75_947 VPWR VGND sg13g2_fill_2
XFILLER_5_1954 VPWR VGND sg13g2_fill_1
XFILLER_46_137 VPWR VGND sg13g2_fill_1
XFILLER_1_1818 VPWR VGND sg13g2_decap_8
X_12820_ _12820_/X _12818_/X _12819_/X _12820_/S VPWR VGND sg13g2_mux2_1
XFILLER_60_1795 VPWR VGND sg13g2_decap_4
X_22998_ _22998_/Q clkload5/A _22998_/D fanout2843/X VPWR VGND sg13g2_dfrbpq_1
XFILLER_112_1896 VPWR VGND sg13g2_decap_8
XFILLER_61_118 VPWR VGND sg13g2_fill_2
XFILLER_27_384 VPWR VGND sg13g2_decap_8
X_12751_ _12751_/Y _15629_/A _20035_/B _20009_/B VPWR VGND sg13g2_a21oi_1
XFILLER_42_310 VPWR VGND sg13g2_fill_1
X_21949_ _21949_/Y _21949_/A _21951_/B VPWR VGND sg13g2_nand2_1
XFILLER_91_34 VPWR VGND sg13g2_decap_4
X_11702_ _11705_/A _12128_/A _11708_/B VPWR VGND sg13g2_nand2b_1
XFILLER_70_652 VPWR VGND sg13g2_fill_2
X_15470_ _17087_/A _15470_/A VPWR VGND sg13g2_inv_1
XFILLER_91_67 VPWR VGND sg13g2_decap_8
X_12682_ _12682_/X _23554_/Q _24002_/Q _22985_/Q VPWR VGND sg13g2_mux2_1
XFILLER_70_685 VPWR VGND sg13g2_fill_1
XFILLER_91_89 VPWR VGND sg13g2_fill_1
X_14421_ _18616_/D _18339_/A _14421_/B VPWR VGND sg13g2_nand2_1
X_23619_ _23619_/Q clkload42/A _23619_/D fanout2718/X VPWR VGND sg13g2_dfrbpq_1
X_11633_ _14087_/B _22978_/Q _14591_/A _11633_/C _14119_/B VPWR VGND sg13g2_nand4_1
X_17140_ _17140_/Y _22732_/Q _17140_/B VPWR VGND sg13g2_xnor2_1
XFILLER_11_752 VPWR VGND sg13g2_decap_8
X_14352_ _15191_/B _15447_/B _14369_/D VPWR VGND sg13g2_and2_1
X_11564_ _14117_/B _14133_/A _14133_/B VPWR VGND sg13g2_and2_1
XFILLER_102_1509 VPWR VGND sg13g2_fill_1
XFILLER_32_1842 VPWR VGND sg13g2_decap_8
X_13303_ _13303_/Y _13303_/A VPWR VGND sg13g2_inv_1
X_17071_ _22719_/D _17080_/B _17069_/Y _17070_/Y VPWR VGND sg13g2_a21oi_1
X_11495_ _11495_/X _21087_/A _14342_/B _12550_/A _12668_/B VPWR VGND sg13g2_or4_1
XFILLER_6_244 VPWR VGND sg13g2_fill_1
XFILLER_13_1263 VPWR VGND sg13g2_fill_2
X_16022_ _16022_/Y _23029_/Q VPWR VGND sg13g2_inv_1
XFILLER_32_1897 VPWR VGND sg13g2_decap_8
X_13234_ _13234_/Y _13587_/B2 _13229_/Y _13231_/Y _13234_/B2 _13233_/Y VPWR VGND sg13g2_a221oi_1
XFILLER_108_161 VPWR VGND sg13g2_decap_8
X_13165_ _13165_/Y _13165_/A1 _13160_/Y _13162_/Y _13675_/B2 _13164_/Y VPWR VGND sg13g2_a221oi_1
XFILLER_112_838 VPWR VGND sg13g2_decap_8
XFILLER_97_527 VPWR VGND sg13g2_decap_8
XFILLER_65_1651 VPWR VGND sg13g2_decap_4
XFILLER_69_218 VPWR VGND sg13g2_decap_8
X_17973_ _17974_/B _19119_/A1 _23033_/Q _18029_/S VPWR VGND sg13g2_mux2_1
XFILLER_34_7 VPWR VGND sg13g2_fill_1
X_13096_ _13096_/Y _13092_/Y _13093_/Y _13095_/Y VPWR VGND sg13g2_o21ai_1
XFILLER_69_229 VPWR VGND sg13g2_fill_1
XFILLER_6_1707 VPWR VGND sg13g2_decap_8
XFILLER_2_494 VPWR VGND sg13g2_fill_2
X_19712_ _19712_/Y _19548_/X _19712_/B VPWR VGND sg13g2_nand2b_1
X_12047_ _12047_/X _24155_/Q _24187_/Q _23291_/Q _23323_/Q _12401_/B _11423_/B VPWR
+ VGND sg13g2_mux4_1
XFILLER_78_763 VPWR VGND sg13g2_decap_8
XFILLER_38_616 VPWR VGND sg13g2_decap_8
XFILLER_78_796 VPWR VGND sg13g2_decap_8
XFILLER_1_21 VPWR VGND sg13g2_decap_8
XFILLER_37_104 VPWR VGND sg13g2_decap_4
X_19643_ _19643_/Y _19986_/A _19637_/Y _19642_/Y VPWR VGND sg13g2_a21oi_1
X_16855_ _17042_/D _22585_/Q _16855_/B VPWR VGND sg13g2_nor2_1
XFILLER_4_1431 VPWR VGND sg13g2_decap_8
XFILLER_20_1201 VPWR VGND sg13g2_decap_8
XFILLER_4_1442 VPWR VGND sg13g2_fill_1
XFILLER_65_446 VPWR VGND sg13g2_decap_8
XFILLER_66_969 VPWR VGND sg13g2_decap_4
X_15806_ _15807_/D _22772_/Q _15940_/B VPWR VGND sg13g2_nand2_1
XFILLER_4_1453 VPWR VGND sg13g2_decap_8
XFILLER_20_1223 VPWR VGND sg13g2_fill_2
X_19574_ _19574_/Y _19634_/B _19574_/B VPWR VGND sg13g2_nor2_1
XFILLER_24_1392 VPWR VGND sg13g2_fill_2
XFILLER_59_1400 VPWR VGND sg13g2_fill_2
X_16786_ _16787_/C _16786_/A _16786_/B _16786_/C VPWR VGND sg13g2_nand3_1
XFILLER_0_1317 VPWR VGND sg13g2_decap_4
X_13998_ _14005_/B _13530_/A _13530_/B _13743_/Y VPWR VGND sg13g2_o21ai_1
XFILLER_59_1422 VPWR VGND sg13g2_fill_2
XFILLER_19_885 VPWR VGND sg13g2_decap_8
XFILLER_34_811 VPWR VGND sg13g2_fill_1
XFILLER_80_427 VPWR VGND sg13g2_decap_8
X_18525_ _22991_/D _18524_/B _18523_/Y _18524_/Y VPWR VGND sg13g2_o21ai_1
XFILLER_52_129 VPWR VGND sg13g2_decap_8
X_12949_ _12949_/X _12949_/A _15690_/A VPWR VGND sg13g2_or2_1
XFILLER_73_490 VPWR VGND sg13g2_decap_4
X_18456_ _18456_/Y _18172_/Y _18450_/Y _18455_/Y VPWR VGND sg13g2_o21ai_1
XFILLER_59_1488 VPWR VGND sg13g2_decap_8
X_15668_ _15669_/C _15668_/A _15668_/B _15668_/C _15668_/D VPWR VGND sg13g2_nand4_1
X_17407_ _22822_/D _17887_/A _17425_/B _17406_/Y VPWR VGND sg13g2_o21ai_1
X_18387_ _18790_/B _19119_/A1 _23065_/Q _18462_/S VPWR VGND sg13g2_mux2_1
Xplace4004 _11917_/A _11915_/S VPWR VGND sg13g2_buf_2
Xplace4015 _13770_/A _13158_/S VPWR VGND sg13g2_buf_2
X_15599_ _15599_/Y _22875_/Q VPWR VGND sg13g2_inv_1
Xplace4026 _14758_/A _13640_/S VPWR VGND sg13g2_buf_2
XFILLER_33_1617 VPWR VGND sg13g2_fill_1
XFILLER_72_1666 VPWR VGND sg13g2_fill_2
Xplace4037 _14098_/A _14461_/A VPWR VGND sg13g2_buf_1
X_17338_ _22796_/D _17878_/A _17341_/B _17337_/Y VPWR VGND sg13g2_o21ai_1
XFILLER_72_1688 VPWR VGND sg13g2_fill_2
Xplace3303 _22401_/A1 _19817_/Y VPWR VGND sg13g2_buf_1
Xplace4048 _18548_/S _18446_/S VPWR VGND sg13g2_buf_1
XFILLER_50_1920 VPWR VGND sg13g2_decap_8
Xplace4059 _18053_/S _17965_/A VPWR VGND sg13g2_buf_1
Xplace3314 _17902_/B2 _17175_/A VPWR VGND sg13g2_buf_1
XFILLER_105_1155 VPWR VGND sg13g2_decap_4
Xplace3325 _21974_/A1 _21345_/A1 VPWR VGND sg13g2_buf_1
Xplace3336 _22427_/A1 _20141_/Y VPWR VGND sg13g2_buf_1
XFILLER_53_1098 VPWR VGND sg13g2_decap_8
XFILLER_88_1117 VPWR VGND sg13g2_fill_1
XFILLER_105_1188 VPWR VGND sg13g2_fill_2
X_17269_ _22764_/D _17878_/A _17284_/B _17268_/Y VPWR VGND sg13g2_o21ai_1
Xplace3347 _21587_/A1 _19997_/Y VPWR VGND sg13g2_buf_1
Xplace3358 _21938_/A1 _22272_/A1 VPWR VGND sg13g2_buf_1
Xplace3369 _20929_/A1 _19628_/Y VPWR VGND sg13g2_buf_1
XFILLER_60_0 VPWR VGND sg13g2_decap_8
XFILLER_11_1937 VPWR VGND sg13g2_decap_8
X_19008_ _19008_/Y _19008_/A _19008_/B _19008_/C VPWR VGND sg13g2_nand3_1
X_20280_ _20280_/Y _20277_/Y _20280_/B VPWR VGND sg13g2_nand2b_1
XFILLER_115_621 VPWR VGND sg13g2_decap_8
XFILLER_88_505 VPWR VGND sg13g2_decap_8
XFILLER_115_698 VPWR VGND sg13g2_decap_8
XFILLER_114_175 VPWR VGND sg13g2_decap_8
XFILLER_88_549 VPWR VGND sg13g2_decap_8
XFILLER_83_1773 VPWR VGND sg13g2_fill_2
XFILLER_69_730 VPWR VGND sg13g2_fill_1
XFILLER_29_28 VPWR VGND sg13g2_decap_8
X_23970_ _23970_/Q clkload39/A _23970_/D fanout2732/X VPWR VGND sg13g2_dfrbpq_1
XFILLER_96_571 VPWR VGND sg13g2_decap_8
XFILLER_29_627 VPWR VGND sg13g2_decap_8
X_22921_ _22921_/Q clkload26/A _22921_/D fanout2826/X VPWR VGND sg13g2_dfrbpq_1
XFILLER_79_1809 VPWR VGND sg13g2_fill_2
XFILLER_110_381 VPWR VGND sg13g2_decap_8
XFILLER_42_1481 VPWR VGND sg13g2_decap_8
XFILLER_42_1492 VPWR VGND sg13g2_fill_2
XFILLER_28_159 VPWR VGND sg13g2_decap_4
X_22852_ _22852_/Q _22893_/CLK _22852_/D fanout2819/X VPWR VGND sg13g2_dfrbpq_1
XFILLER_71_416 VPWR VGND sg13g2_decap_8
XFILLER_45_49 VPWR VGND sg13g2_fill_2
X_21803_ _23899_/D _22270_/A1 _21802_/B _21802_/Y VPWR VGND sg13g2_o21ai_1
XFILLER_25_822 VPWR VGND sg13g2_decap_8
XFILLER_77_1544 VPWR VGND sg13g2_decap_8
X_22783_ _22783_/Q clkload25/A _22783_/D fanout2898/X VPWR VGND sg13g2_dfrbpq_1
XFILLER_51_140 VPWR VGND sg13g2_fill_2
XFILLER_55_1820 VPWR VGND sg13g2_fill_1
XFILLER_94_1880 VPWR VGND sg13g2_decap_8
XFILLER_51_151 VPWR VGND sg13g2_fill_2
XFILLER_24_376 VPWR VGND sg13g2_decap_8
XFILLER_52_685 VPWR VGND sg13g2_fill_1
XFILLER_90_1733 VPWR VGND sg13g2_decap_8
XFILLER_12_527 VPWR VGND sg13g2_decap_8
XFILLER_71_1110 VPWR VGND sg13g2_fill_1
XFILLER_101_77 VPWR VGND sg13g2_decap_8
XFILLER_40_847 VPWR VGND sg13g2_fill_2
X_21665_ _23845_/D _21958_/A1 _21674_/B _21664_/Y VPWR VGND sg13g2_o21ai_1
X_23404_ _23404_/Q _24214_/CLK _23404_/D fanout2629/X VPWR VGND sg13g2_dfrbpq_1
X_20616_ _20616_/Y _23362_/Q _20616_/B VPWR VGND sg13g2_nand2_1
X_21596_ _21596_/Y _21596_/A _21600_/B VPWR VGND sg13g2_nand2_1
Xrebuffer5550 rebuffer5550/X rebuffer5551/X VPWR VGND sg13g2_buf_1
X_23335_ _23335_/Q clkload35/A _23335_/D fanout2696/X VPWR VGND sg13g2_dfrbpq_1
X_20547_ _23329_/D _22416_/A1 _20548_/B _20546_/Y VPWR VGND sg13g2_o21ai_1
XFILLER_14_1561 VPWR VGND sg13g2_fill_2
Xrebuffer5561 _13186_/C _12551_/C VPWR VGND sg13g2_buf_1
Xplace3870 _15936_/S _15718_/S VPWR VGND sg13g2_buf_1
X_11280_ _11280_/Y _13213_/S _11280_/B VPWR VGND sg13g2_nor2_1
Xplace3881 _19298_/S _19300_/S VPWR VGND sg13g2_buf_1
X_20478_ _20478_/Y _23300_/Q _20482_/B VPWR VGND sg13g2_nand2_1
X_23266_ _23266_/Q _24196_/CLK _23266_/D fanout2703/X VPWR VGND sg13g2_dfrbpq_1
Xplace3892 _18485_/A _18351_/B VPWR VGND sg13g2_buf_1
XFILLER_106_643 VPWR VGND sg13g2_decap_8
XFILLER_84_1526 VPWR VGND sg13g2_fill_1
X_22217_ _22217_/Y _24097_/Q _22219_/B VPWR VGND sg13g2_nand2_1
X_23197_ _23197_/Q _23215_/CLK _23197_/D fanout2926/X VPWR VGND sg13g2_dfrbpq_1
XFILLER_49_1679 VPWR VGND sg13g2_fill_2
XFILLER_27_1911 VPWR VGND sg13g2_decap_8
X_22148_ _24064_/D _22282_/A1 _22151_/B _22147_/Y VPWR VGND sg13g2_o21ai_1
XFILLER_105_175 VPWR VGND sg13g2_decap_8
XFILLER_10_96 VPWR VGND sg13g2_fill_1
XFILLER_62_1802 VPWR VGND sg13g2_fill_1
XFILLER_105_186 VPWR VGND sg13g2_fill_1
XFILLER_43_1223 VPWR VGND sg13g2_decap_8
X_14970_ _14970_/Y _24261_/A _14880_/Y _14969_/Y _14965_/Y VPWR VGND sg13g2_a22oi_1
X_22079_ _24031_/D _22280_/A1 _22084_/B _22078_/Y VPWR VGND sg13g2_o21ai_1
XFILLER_94_519 VPWR VGND sg13g2_fill_2
XFILLER_75_700 VPWR VGND sg13g2_fill_2
XFILLER_43_1245 VPWR VGND sg13g2_decap_8
XFILLER_48_925 VPWR VGND sg13g2_decap_8
XFILLER_62_1868 VPWR VGND sg13g2_fill_1
XFILLER_87_571 VPWR VGND sg13g2_decap_4
XFILLER_0_998 VPWR VGND sg13g2_fill_1
X_13921_ _13921_/Y _13920_/X _13921_/B VPWR VGND sg13g2_nand2b_1
XFILLER_87_582 VPWR VGND sg13g2_decap_8
XFILLER_87_593 VPWR VGND sg13g2_fill_2
XFILLER_59_295 VPWR VGND sg13g2_decap_8
XFILLER_74_221 VPWR VGND sg13g2_decap_4
XFILLER_47_457 VPWR VGND sg13g2_decap_8
X_16640_ _16641_/B _16654_/B _16648_/C VPWR VGND sg13g2_nand2_1
X_13852_ _13854_/C _20292_/A _20290_/B VPWR VGND sg13g2_xnor2_1
XFILLER_5_1784 VPWR VGND sg13g2_decap_8
XFILLER_21_1554 VPWR VGND sg13g2_fill_2
XFILLER_95_1611 VPWR VGND sg13g2_fill_2
XFILLER_63_939 VPWR VGND sg13g2_decap_8
XFILLER_112_1682 VPWR VGND sg13g2_decap_8
X_12803_ _12803_/Y _12802_/B _23364_/Q _12802_/Y VPWR VGND sg13g2_o21ai_1
X_16571_ _16572_/B _22629_/Q _16571_/B VPWR VGND sg13g2_xnor2_1
XFILLER_90_747 VPWR VGND sg13g2_decap_8
XFILLER_1_1659 VPWR VGND sg13g2_fill_1
XFILLER_27_170 VPWR VGND sg13g2_decap_8
XFILLER_95_1677 VPWR VGND sg13g2_fill_1
X_19290_ _23207_/D _23207_/Q _20278_/A3 _19298_/S VPWR VGND sg13g2_mux2_1
X_12734_ _12734_/Y _23907_/Q _12889_/C _12733_/X _11688_/A _12567_/A VPWR VGND sg13g2_a221oi_1
XFILLER_42_140 VPWR VGND sg13g2_decap_8
XFILLER_71_983 VPWR VGND sg13g2_fill_2
XFILLER_15_387 VPWR VGND sg13g2_fill_1
Xinput4460 _14222_/A irqs_i[6] VPWR VGND sg13g2_buf_1
X_18241_ _18242_/B _18290_/A _18322_/C VPWR VGND sg13g2_nand2_1
XFILLER_93_1390 VPWR VGND sg13g2_fill_2
XFILLER_54_1341 VPWR VGND sg13g2_decap_8
X_18172_ _18172_/Y _18301_/A _18476_/B VPWR VGND sg13g2_nand2_1
XFILLER_54_1374 VPWR VGND sg13g2_decap_8
X_11616_ _13538_/B _19489_/B _19487_/A VPWR VGND sg13g2_nor2b_1
X_15384_ _22454_/D _15695_/S _15379_/X _15383_/Y VPWR VGND sg13g2_a21oi_1
X_12596_ _12596_/Y _12813_/S _24097_/Q _12595_/Y VPWR VGND sg13g2_o21ai_1
XFILLER_89_1404 VPWR VGND sg13g2_fill_2
X_17123_ _17123_/Y _22729_/Q _17123_/B VPWR VGND sg13g2_xnor2_1
X_14335_ _14383_/C _15447_/A _15447_/B _14372_/C VPWR VGND sg13g2_and3_1
X_11547_ _11548_/C _23541_/Q _13911_/A2 _11546_/X _11920_/C1 _13774_/A VPWR VGND sg13g2_a221oi_1
XFILLER_13_1060 VPWR VGND sg13g2_decap_8
X_17054_ _17055_/B _17090_/A _17083_/B VPWR VGND sg13g2_nor2_1
XFILLER_7_575 VPWR VGND sg13g2_fill_2
X_14266_ _14267_/B _16365_/A _24239_/D VPWR VGND sg13g2_nor2_1
X_16005_ _16008_/B _22871_/Q _16005_/B VPWR VGND sg13g2_nand2_1
XFILLER_67_1735 VPWR VGND sg13g2_decap_8
X_13217_ _13217_/Y _13970_/A _13217_/B VPWR VGND sg13g2_nor2_1
XFILLER_83_1025 VPWR VGND sg13g2_decap_4
XFILLER_48_1145 VPWR VGND sg13g2_fill_1
XFILLER_3_770 VPWR VGND sg13g2_decap_8
XFILLER_44_1009 VPWR VGND sg13g2_fill_1
X_13148_ _13148_/Y _12899_/S _12584_/B _13147_/Y VPWR VGND sg13g2_o21ai_1
XFILLER_112_635 VPWR VGND sg13g2_decap_8
XFILLER_111_112 VPWR VGND sg13g2_decap_8
XFILLER_98_869 VPWR VGND sg13g2_decap_8
XFILLER_26_1410 VPWR VGND sg13g2_decap_8
XFILLER_48_1189 VPWR VGND sg13g2_decap_4
XFILLER_97_346 VPWR VGND sg13g2_decap_8
XFILLER_2_280 VPWR VGND sg13g2_decap_4
XFILLER_39_903 VPWR VGND sg13g2_decap_8
XFILLER_6_1515 VPWR VGND sg13g2_fill_2
X_17956_ _18187_/A _18331_/A _17956_/B VPWR VGND sg13g2_nor2_1
XFILLER_39_914 VPWR VGND sg13g2_fill_1
X_13079_ _13748_/C _14053_/A _14046_/A VPWR VGND sg13g2_nor2_2
XFILLER_41_1919 VPWR VGND sg13g2_decap_8
XFILLER_111_189 VPWR VGND sg13g2_decap_8
X_16907_ _16954_/B _22691_/Q _22690_/Q _16907_/C _16907_/D VPWR VGND sg13g2_nand4_1
X_17887_ _17887_/Y _17887_/A _17917_/B VPWR VGND sg13g2_nor2_1
XFILLER_65_243 VPWR VGND sg13g2_decap_4
X_16838_ _16838_/Y _22680_/Q _16838_/B VPWR VGND sg13g2_xnor2_1
XFILLER_20_1020 VPWR VGND sg13g2_decap_8
XFILLER_66_788 VPWR VGND sg13g2_decap_8
XFILLER_4_1261 VPWR VGND sg13g2_fill_2
XFILLER_53_416 VPWR VGND sg13g2_decap_8
XFILLER_4_1283 VPWR VGND sg13g2_decap_8
XFILLER_53_438 VPWR VGND sg13g2_fill_1
X_19557_ _19557_/X _19587_/A _19483_/B _19483_/A VPWR VGND sg13g2_a21o_1
X_16769_ _22669_/D _17480_/A1 _16818_/A _16768_/Y VPWR VGND sg13g2_a21oi_1
XFILLER_46_490 VPWR VGND sg13g2_decap_8
XFILLER_74_1706 VPWR VGND sg13g2_decap_4
XFILLER_0_1158 VPWR VGND sg13g2_fill_1
XFILLER_39_1837 VPWR VGND sg13g2_decap_4
XFILLER_59_1263 VPWR VGND sg13g2_fill_1
X_18508_ _18840_/B _19128_/A1 _23073_/Q _18548_/S VPWR VGND sg13g2_mux2_1
XFILLER_33_140 VPWR VGND sg13g2_decap_8
XFILLER_33_151 VPWR VGND sg13g2_decap_8
XFILLER_62_983 VPWR VGND sg13g2_fill_2
X_19488_ _19603_/B _19835_/B VPWR VGND sg13g2_inv_1
X_18439_ _18440_/C _18297_/B _18363_/A _18363_/Y _18530_/A VPWR VGND sg13g2_a22oi_1
X_21450_ _21450_/Y _21450_/A _21456_/B VPWR VGND sg13g2_nand2_1
Xplace3100 _21380_/B _21374_/B VPWR VGND sg13g2_buf_1
Xplace3111 _21347_/B _21353_/B VPWR VGND sg13g2_buf_1
X_20401_ _23264_/D _22414_/A1 _20404_/B _20400_/Y VPWR VGND sg13g2_o21ai_1
XFILLER_30_880 VPWR VGND sg13g2_fill_2
Xplace3122 _21266_/B _21287_/B VPWR VGND sg13g2_buf_1
X_21381_ _23710_/D _21943_/A1 _21380_/B _21380_/Y VPWR VGND sg13g2_o21ai_1
Xplace3133 _20930_/B _20990_/B VPWR VGND sg13g2_buf_1
Xplace3144 _20888_/B _20896_/B VPWR VGND sg13g2_buf_1
Xplace3155 _20751_/B _20772_/B VPWR VGND sg13g2_buf_1
XFILLER_15_1892 VPWR VGND sg13g2_decap_8
Xplace3166 _20666_/B _20712_/S VPWR VGND sg13g2_buf_1
X_23120_ _23120_/Q _23215_/CLK _23120_/D fanout2924/X VPWR VGND sg13g2_dfrbpq_1
X_20332_ _20332_/Y _23250_/Q _20365_/B VPWR VGND sg13g2_nand2_1
XFILLER_11_1745 VPWR VGND sg13g2_decap_4
Xplace3177 _20539_/B _20533_/B VPWR VGND sg13g2_buf_1
Xplace3188 _20473_/B _20482_/B VPWR VGND sg13g2_buf_1
Xplace3199 _21606_/A1 _22033_/A1 VPWR VGND sg13g2_buf_1
XFILLER_102_1884 VPWR VGND sg13g2_decap_8
X_23051_ _23051_/Q clkload12/A _23051_/D fanout2912/X VPWR VGND sg13g2_dfrbpq_1
X_20263_ _20263_/Y _20307_/A _20263_/B VPWR VGND sg13g2_nor2_1
XFILLER_66_1223 VPWR VGND sg13g2_fill_1
XFILLER_85_1857 VPWR VGND sg13g2_fill_2
X_22002_ _23995_/D _22270_/A1 _22001_/B _22001_/Y VPWR VGND sg13g2_o21ai_1
XFILLER_66_1245 VPWR VGND sg13g2_decap_8
XFILLER_115_495 VPWR VGND sg13g2_decap_8
X_20194_ _20195_/B _20193_/B _20233_/A2 _20193_/Y VPWR VGND sg13g2_a21oi_1
XFILLER_103_646 VPWR VGND sg13g2_decap_8
XFILLER_102_123 VPWR VGND sg13g2_decap_8
XFILLER_103_668 VPWR VGND sg13g2_fill_1
X_23953_ _23953_/Q clkload51/A _23953_/D fanout2683/X VPWR VGND sg13g2_dfrbpq_1
XFILLER_40_1418 VPWR VGND sg13g2_decap_4
XFILLER_79_1606 VPWR VGND sg13g2_decap_4
XFILLER_79_1617 VPWR VGND sg13g2_fill_2
XFILLER_84_552 VPWR VGND sg13g2_decap_8
XFILLER_5_1069 VPWR VGND sg13g2_decap_8
X_22904_ _22904_/Q clkload8/A _22904_/D fanout2799/X VPWR VGND sg13g2_dfrbpq_1
XFILLER_17_619 VPWR VGND sg13g2_decap_4
X_23884_ _23884_/Q clkload49/A _23884_/D fanout2641/X VPWR VGND sg13g2_dfrbpq_1
XFILLER_112_21 VPWR VGND sg13g2_decap_8
XFILLER_2_1946 VPWR VGND sg13g2_decap_8
XFILLER_22_1885 VPWR VGND sg13g2_fill_2
XFILLER_38_980 VPWR VGND sg13g2_fill_1
XFILLER_96_1953 VPWR VGND sg13g2_fill_2
X_22835_ _22835_/Q _22869_/CLK _22835_/D fanout2799/X VPWR VGND sg13g2_dfrbpq_1
XFILLER_22_1896 VPWR VGND sg13g2_decap_8
XFILLER_56_298 VPWR VGND sg13g2_decap_8
XFILLER_57_1937 VPWR VGND sg13g2_fill_1
XFILLER_112_98 VPWR VGND sg13g2_decap_8
XFILLER_0_1670 VPWR VGND sg13g2_fill_1
X_22766_ _22766_/Q _22893_/CLK _22766_/D fanout2818/X VPWR VGND sg13g2_dfrbpq_1
XFILLER_24_173 VPWR VGND sg13g2_decap_8
XFILLER_40_622 VPWR VGND sg13g2_fill_1
XFILLER_73_1249 VPWR VGND sg13g2_fill_1
X_21717_ _23867_/D _21936_/A1 _21716_/B _21716_/Y VPWR VGND sg13g2_o21ai_1
X_22697_ _22697_/Q _22733_/CLK _22697_/D fanout2881/X VPWR VGND sg13g2_dfrbpq_1
XFILLER_12_346 VPWR VGND sg13g2_decap_8
X_12450_ _12461_/A _12450_/A _12450_/B _12450_/C _12450_/D VPWR VGND sg13g2_nor4_1
X_21648_ _21648_/Y _21648_/A _21648_/B VPWR VGND sg13g2_nand2_1
XFILLER_55_1694 VPWR VGND sg13g2_decap_8
XFILLER_40_699 VPWR VGND sg13g2_decap_4
X_11401_ _11402_/B _23702_/Q _23734_/Q _11406_/S VPWR VGND sg13g2_mux2_1
X_12381_ _12381_/Y _12487_/S _12381_/B VPWR VGND sg13g2_nand2_1
X_21579_ _21579_/Y _23805_/Q _21581_/B VPWR VGND sg13g2_nand2_1
XFILLER_10_1200 VPWR VGND sg13g2_fill_2
X_14120_ _14120_/Y _11614_/B _14120_/B _14120_/C VPWR VGND sg13g2_nand3b_1
X_11332_ _11332_/X _23287_/Q _23319_/Q _23351_/Q _23383_/Q _11924_/S0 _11538_/S1 VPWR
+ VGND sg13g2_mux4_1
X_23318_ _23318_/Q clkload54/A _23318_/D fanout2751/X VPWR VGND sg13g2_dfrbpq_1
XFILLER_10_1211 VPWR VGND sg13g2_decap_4
Xrebuffer5380 _13526_/C _12529_/Y VPWR VGND sg13g2_buf_1
XFILLER_21_51 VPWR VGND sg13g2_fill_2
XFILLER_84_1301 VPWR VGND sg13g2_decap_8
XFILLER_108_0 VPWR VGND sg13g2_decap_8
X_14051_ _14059_/C _14051_/A _14051_/B _14051_/C _14051_/D VPWR VGND sg13g2_and4_1
X_23249_ _23249_/Q clkload47/A _23249_/D fanout2679/X VPWR VGND sg13g2_dfrbpq_1
X_11263_ _11500_/S _13186_/B _12551_/B _12551_/C VPWR VGND sg13g2_nor3_2
Xhold5070 _20520_/A _23317_/Q VPWR VGND sg13g2_dlygate4sd3_1
XFILLER_49_1454 VPWR VGND sg13g2_decap_8
Xhold5081 _22093_/A _24038_/Q VPWR VGND sg13g2_dlygate4sd3_1
X_13002_ _13002_/X _12996_/X _12999_/Y _13000_/X _13001_/X _13244_/S _12042_/B VPWR
+ VGND sg13g2_mux4_1
Xhold5092 _17406_/A _22822_/Q VPWR VGND sg13g2_dlygate4sd3_1
X_11194_ _14461_/A _22964_/Q _22965_/Q VPWR VGND sg13g2_nand2_2
XFILLER_97_77 VPWR VGND sg13g2_decap_8
XFILLER_7_1813 VPWR VGND sg13g2_decap_8
X_17810_ _17810_/Y _17215_/A _17810_/A2 _17810_/B1 _17809_/Y VPWR VGND sg13g2_a22oi_1
X_18790_ _18790_/Y _18822_/A _18790_/B VPWR VGND sg13g2_nand2_1
XFILLER_95_828 VPWR VGND sg13g2_decap_4
XFILLER_62_1643 VPWR VGND sg13g2_fill_1
XFILLER_67_519 VPWR VGND sg13g2_decap_8
XFILLER_114_1722 VPWR VGND sg13g2_decap_8
XFILLER_23_1616 VPWR VGND sg13g2_fill_1
XFILLER_48_711 VPWR VGND sg13g2_decap_8
X_17741_ _17741_/Y _23176_/Q _17815_/A2 _17815_/B1 _14852_/A VPWR VGND sg13g2_a22oi_1
XFILLER_94_338 VPWR VGND sg13g2_decap_4
X_14953_ _14953_/Y _14953_/A _23138_/Q VPWR VGND sg13g2_nand2_1
XFILLER_62_1676 VPWR VGND sg13g2_decap_4
XFILLER_43_1075 VPWR VGND sg13g2_decap_4
XFILLER_47_221 VPWR VGND sg13g2_decap_4
XFILLER_75_541 VPWR VGND sg13g2_decap_4
X_13904_ _13904_/Y _14438_/B _13904_/B VPWR VGND sg13g2_nand2_1
XFILLER_48_777 VPWR VGND sg13g2_decap_8
X_17672_ _22890_/D _17702_/B _17670_/Y _17671_/Y VPWR VGND sg13g2_a21oi_1
XFILLER_48_788 VPWR VGND sg13g2_fill_1
X_14884_ _14885_/D _16438_/B _17540_/A _14837_/B VPWR VGND sg13g2_o21ai_1
XFILLER_75_585 VPWR VGND sg13g2_decap_8
X_13835_ _13835_/Y _13835_/A VPWR VGND sg13g2_inv_1
XFILLER_63_747 VPWR VGND sg13g2_decap_8
X_19342_ _19342_/Y _20085_/A _19412_/B VPWR VGND sg13g2_nand2_1
X_16554_ _22625_/D _16063_/A _16561_/A _16553_/Y VPWR VGND sg13g2_a21oi_1
X_13766_ _13766_/X _13762_/X _13763_/X _13764_/X _13765_/X _13615_/S _11418_/A VPWR
+ VGND sg13g2_mux4_1
XFILLER_91_1338 VPWR VGND sg13g2_decap_8
XFILLER_17_1409 VPWR VGND sg13g2_fill_1
X_15505_ _15506_/B _22848_/Q _17439_/A _16161_/A _22490_/Q VPWR VGND sg13g2_a22oi_1
X_19273_ _23195_/D _14699_/B _19274_/B _19272_/Y VPWR VGND sg13g2_o21ai_1
X_12717_ _12717_/X _24035_/Q _24067_/Q _12721_/S VPWR VGND sg13g2_mux2_1
X_16485_ _16485_/Y _22605_/Q _16506_/B VPWR VGND sg13g2_nand2_1
XFILLER_43_493 VPWR VGND sg13g2_decap_8
XFILLER_31_644 VPWR VGND sg13g2_decap_8
X_13697_ _13698_/B _23856_/Q _23888_/Q _23952_/Q _23984_/Q _12577_/C _11493_/A VPWR
+ VGND sg13g2_mux4_1
X_18224_ _18224_/Y _18415_/B _18224_/B _18224_/C VPWR VGND sg13g2_nor3_1
X_15436_ _15436_/Y _15436_/A _15690_/B VPWR VGND sg13g2_nor2_1
XFILLER_54_1160 VPWR VGND sg13g2_decap_4
X_12648_ _12648_/Y _12647_/X _12707_/S VPWR VGND sg13g2_nand2b_1
XFILLER_30_165 VPWR VGND sg13g2_decap_8
XFILLER_15_1144 VPWR VGND sg13g2_decap_8
XFILLER_7_20 VPWR VGND sg13g2_fill_2
X_18155_ _18479_/D _18155_/A _18155_/B VPWR VGND sg13g2_nor2_1
XFILLER_30_198 VPWR VGND sg13g2_decap_8
XFILLER_11_390 VPWR VGND sg13g2_decap_8
X_12579_ _12580_/B _23457_/Q _23521_/Q _23617_/Q _23681_/Q _12478_/S _12377_/S VPWR
+ VGND sg13g2_mux4_1
X_17106_ _17106_/Y _22726_/Q _17106_/B VPWR VGND sg13g2_xnor2_1
X_14318_ _14318_/Y _14318_/A VPWR VGND sg13g2_inv_1
XFILLER_50_1079 VPWR VGND sg13g2_decap_8
XFILLER_89_1278 VPWR VGND sg13g2_decap_4
XFILLER_67_1510 VPWR VGND sg13g2_fill_2
X_17037_ _17037_/Y _22716_/Q _17222_/C VPWR VGND sg13g2_nand2b_1
X_14249_ _14249_/Y _24219_/Q _14400_/C VPWR VGND sg13g2_nor2_1
XFILLER_63_1418 VPWR VGND sg13g2_fill_1
XFILLER_67_1587 VPWR VGND sg13g2_fill_2
XFILLER_113_999 VPWR VGND sg13g2_fill_1
XFILLER_100_616 VPWR VGND sg13g2_decap_4
X_18988_ _18988_/Y _18999_/A _18988_/B VPWR VGND sg13g2_nand2_1
XFILLER_97_176 VPWR VGND sg13g2_decap_8
XFILLER_23_0 VPWR VGND sg13g2_decap_8
XFILLER_6_1334 VPWR VGND sg13g2_decap_8
X_17939_ _17939_/X _19006_/A _23058_/Q _17992_/S VPWR VGND sg13g2_mux2_1
XFILLER_38_221 VPWR VGND sg13g2_fill_2
XFILLER_26_1295 VPWR VGND sg13g2_decap_8
XFILLER_22_1137 VPWR VGND sg13g2_decap_4
XFILLER_96_1205 VPWR VGND sg13g2_fill_1
X_20950_ _20950_/Y _23520_/Q _20954_/B VPWR VGND sg13g2_nand2_1
XFILLER_93_393 VPWR VGND sg13g2_decap_8
XFILLER_54_758 VPWR VGND sg13g2_fill_2
XFILLER_78_1650 VPWR VGND sg13g2_fill_1
XFILLER_39_1601 VPWR VGND sg13g2_fill_2
X_22620_ _22620_/Q clkload24/A _22620_/D fanout2899/X VPWR VGND sg13g2_dfrbpq_1
XFILLER_59_1060 VPWR VGND sg13g2_decap_4
XFILLER_22_611 VPWR VGND sg13g2_decap_8
XFILLER_50_931 VPWR VGND sg13g2_decap_8
X_22551_ _22551_/Q clkload26/A _22551_/D fanout2850/X VPWR VGND sg13g2_dfrbpq_1
XFILLER_50_942 VPWR VGND sg13g2_fill_2
XFILLER_52_1812 VPWR VGND sg13g2_fill_1
X_21502_ _21502_/Y _23768_/Q _21502_/B VPWR VGND sg13g2_nand2_1
XFILLER_52_1834 VPWR VGND sg13g2_fill_2
XFILLER_21_165 VPWR VGND sg13g2_decap_8
X_22482_ _22482_/Q _23029_/CLK _22482_/D fanout2808/X VPWR VGND sg13g2_dfrbpq_1
X_24221_ _24221_/Q clkload27/A _24221_/D fanout2856/X VPWR VGND sg13g2_dfrbpq_1
X_21433_ _23735_/D _21928_/A1 _21489_/B _21432_/Y VPWR VGND sg13g2_o21ai_1
XFILLER_13_1829 VPWR VGND sg13g2_decap_8
XFILLER_52_1878 VPWR VGND sg13g2_decap_8
XFILLER_52_1889 VPWR VGND sg13g2_fill_2
Xclkbuf_4_14__f_clk_i clkbuf_leaf_42_clk_i/A clkbuf_3_7_0_clk_i/X VPWR VGND sg13g2_buf_8
X_21364_ _23702_/D _21926_/A1 _21363_/B _21363_/Y VPWR VGND sg13g2_o21ai_1
X_24152_ _24152_/Q clkload56/A _24152_/D fanout2752/X VPWR VGND sg13g2_dfrbpq_1
XFILLER_33_1299 VPWR VGND sg13g2_fill_2
X_20315_ _23249_/D _22246_/A0 _23249_/Q _20365_/B VPWR VGND sg13g2_mux2_1
X_23103_ _23103_/Q _23114_/CLK _23103_/D fanout2904/X VPWR VGND sg13g2_dfrbpq_1
XFILLER_101_7 VPWR VGND sg13g2_decap_8
XFILLER_89_1790 VPWR VGND sg13g2_fill_2
X_21295_ _23669_/D _21295_/A1 _21349_/S _21294_/Y VPWR VGND sg13g2_o21ai_1
X_24083_ _24083_/Q clkload51/A _24083_/D fanout2665/X VPWR VGND sg13g2_dfrbpq_1
XFILLER_85_1654 VPWR VGND sg13g2_fill_1
XFILLER_66_1031 VPWR VGND sg13g2_decap_8
XFILLER_107_21 VPWR VGND sg13g2_decap_8
X_20246_ _20247_/D _20062_/B _19866_/Y _19878_/Y _19325_/X VPWR VGND sg13g2_a22oi_1
X_23034_ _23034_/Q clkload13/A _23034_/D fanout2908/X VPWR VGND sg13g2_dfrbpq_1
XFILLER_46_1627 VPWR VGND sg13g2_decap_4
XFILLER_89_644 VPWR VGND sg13g2_fill_1
X_20177_ _20182_/B _20177_/A _20177_/B VPWR VGND sg13g2_nand2_1
XFILLER_107_98 VPWR VGND sg13g2_decap_8
XFILLER_27_1059 VPWR VGND sg13g2_decap_8
XFILLER_77_839 VPWR VGND sg13g2_decap_8
XFILLER_76_327 VPWR VGND sg13g2_fill_1
XFILLER_67_69 VPWR VGND sg13g2_decap_4
XFILLER_24_1947 VPWR VGND sg13g2_decap_8
XFILLER_29_221 VPWR VGND sg13g2_decap_8
XFILLER_111_1906 VPWR VGND sg13g2_decap_8
XFILLER_85_861 VPWR VGND sg13g2_decap_8
XFILLER_79_1414 VPWR VGND sg13g2_decap_4
XFILLER_85_872 VPWR VGND sg13g2_fill_1
XFILLER_29_254 VPWR VGND sg13g2_decap_8
XFILLER_57_563 VPWR VGND sg13g2_decap_4
X_23936_ _23936_/Q clkload43/A _23936_/D fanout2734/X VPWR VGND sg13g2_dfrbpq_1
X_11950_ _11951_/C _12128_/A _11950_/B VPWR VGND sg13g2_nand2_1
XFILLER_91_319 VPWR VGND sg13g2_decap_4
XFILLER_17_405 VPWR VGND sg13g2_decap_8
XFILLER_45_714 VPWR VGND sg13g2_fill_2
XFILLER_83_13 VPWR VGND sg13g2_fill_2
XFILLER_45_725 VPWR VGND sg13g2_fill_1
XFILLER_2_1743 VPWR VGND sg13g2_decap_8
XFILLER_72_533 VPWR VGND sg13g2_fill_2
X_23867_ _23867_/Q _23966_/CLK _23867_/D fanout2766/X VPWR VGND sg13g2_dfrbpq_1
X_11881_ _11882_/C _19437_/A _19727_/S VPWR VGND sg13g2_nor2_1
XFILLER_17_449 VPWR VGND sg13g2_decap_4
XFILLER_72_544 VPWR VGND sg13g2_fill_2
XFILLER_96_1750 VPWR VGND sg13g2_fill_1
XFILLER_83_68 VPWR VGND sg13g2_decap_8
X_13620_ _13620_/Y _13617_/B _24047_/Q _13619_/Y VPWR VGND sg13g2_o21ai_1
XFILLER_26_972 VPWR VGND sg13g2_decap_4
XFILLER_44_268 VPWR VGND sg13g2_fill_2
X_22818_ _22818_/Q _22917_/CLK _22818_/D fanout2892/X VPWR VGND sg13g2_dfrbpq_1
XFILLER_96_1794 VPWR VGND sg13g2_fill_2
XFILLER_16_51 VPWR VGND sg13g2_fill_1
X_23798_ _23798_/Q clkload58/A _23798_/D fanout2758/X VPWR VGND sg13g2_dfrbpq_1
XFILLER_109_1813 VPWR VGND sg13g2_decap_8
XFILLER_16_62 VPWR VGND sg13g2_decap_8
XFILLER_60_739 VPWR VGND sg13g2_decap_8
XFILLER_73_1013 VPWR VGND sg13g2_fill_1
XFILLER_16_73 VPWR VGND sg13g2_fill_2
XFILLER_92_1647 VPWR VGND sg13g2_fill_2
XFILLER_57_1767 VPWR VGND sg13g2_decap_4
XFILLER_73_1024 VPWR VGND sg13g2_decap_4
X_13551_ _13552_/B _23854_/Q _23886_/Q _23950_/Q _23982_/Q _13551_/S0 _11493_/A VPWR
+ VGND sg13g2_mux4_1
X_22749_ _22749_/Q clkload27/A _22749_/D fanout2894/X VPWR VGND sg13g2_dfrbpq_1
X_12502_ _12502_/X _23264_/Q _23392_/Q _12502_/S VPWR VGND sg13g2_mux2_1
X_16270_ _16270_/Y _22526_/Q _16269_/B _14962_/A VPWR VGND sg13g2_a21oi_1
X_13482_ _13482_/X _23597_/Q _23629_/Q _23661_/Q _23693_/Q _13614_/S0 _13614_/S1 VPWR
+ VGND sg13g2_mux4_1
XFILLER_90_1360 VPWR VGND sg13g2_fill_2
XFILLER_51_1322 VPWR VGND sg13g2_decap_8
XFILLER_103_1401 VPWR VGND sg13g2_fill_1
X_15221_ _16357_/A _15221_/A VPWR VGND sg13g2_inv_1
X_12433_ _12433_/Y _12435_/B _12436_/A VPWR VGND sg13g2_nor2b_1
X_12364_ _12365_/B _23743_/Q _23871_/Q _12485_/S VPWR VGND sg13g2_mux2_1
XFILLER_4_320 VPWR VGND sg13g2_fill_1
X_14103_ _14103_/Y _14103_/A _14104_/B _14104_/C VPWR VGND sg13g2_nor3_1
XFILLER_99_408 VPWR VGND sg13g2_fill_1
X_11315_ _11316_/C _14120_/C _14629_/A _14120_/B _11315_/D VPWR VGND sg13g2_nand4_1
X_19960_ _19960_/Y _20033_/A1 _19799_/Y _19959_/Y VPWR VGND sg13g2_o21ai_1
XFILLER_10_1052 VPWR VGND sg13g2_fill_1
X_15083_ _15083_/Y _15082_/A _16324_/A _15082_/Y VPWR VGND sg13g2_a21oi_1
X_12295_ _12300_/C _11423_/B _12291_/X _12292_/X _13165_/A1 _12294_/Y VPWR VGND sg13g2_a221oi_1
XFILLER_107_771 VPWR VGND sg13g2_fill_2
XFILLER_101_1191 VPWR VGND sg13g2_decap_8
XFILLER_84_1131 VPWR VGND sg13g2_decap_8
XFILLER_64_1705 VPWR VGND sg13g2_decap_8
X_18911_ _18911_/Y _18955_/A _18911_/B VPWR VGND sg13g2_nand2_1
X_14034_ _14036_/C _19494_/A _14034_/B VPWR VGND sg13g2_xnor2_1
X_11246_ _11247_/B _22966_/Q VPWR VGND sg13g2_inv_1
X_19891_ _19891_/Y _20329_/B2 _19880_/Y _19890_/Y VPWR VGND sg13g2_a21oi_1
XFILLER_79_154 VPWR VGND sg13g2_fill_1
X_18842_ _18844_/B _18840_/Y _18841_/Y _18868_/S VPWR VGND sg13g2_mux2_1
X_11177_ _16855_/B _19306_/B _14459_/A VPWR VGND sg13g2_nor2_1
XFILLER_67_305 VPWR VGND sg13g2_decap_8
XFILLER_7_1643 VPWR VGND sg13g2_decap_8
XFILLER_94_135 VPWR VGND sg13g2_fill_2
X_15985_ _15995_/B _22940_/Q _15289_/X _15306_/B VPWR VGND sg13g2_a21oi_1
XFILLER_7_1676 VPWR VGND sg13g2_decap_8
XFILLER_3_1518 VPWR VGND sg13g2_decap_8
XFILLER_23_1446 VPWR VGND sg13g2_decap_4
XFILLER_23_1457 VPWR VGND sg13g2_fill_2
X_14936_ _14939_/B _14936_/A _14936_/B VPWR VGND sg13g2_nand2_1
X_17724_ _17724_/X _22566_/Q _17724_/B VPWR VGND sg13g2_xor2_1
XFILLER_48_574 VPWR VGND sg13g2_decap_8
XFILLER_63_511 VPWR VGND sg13g2_decap_8
XFILLER_36_747 VPWR VGND sg13g2_decap_8
X_14867_ _14867_/Y _22518_/Q _14828_/A _16231_/B _14866_/Y VPWR VGND sg13g2_a22oi_1
X_17655_ _17655_/Y _22559_/Q _17663_/B VPWR VGND sg13g2_xnor2_1
XFILLER_90_330 VPWR VGND sg13g2_fill_1
XFILLER_91_875 VPWR VGND sg13g2_decap_8
XFILLER_35_257 VPWR VGND sg13g2_fill_1
X_16606_ _16606_/Y _16610_/A _16606_/B VPWR VGND sg13g2_nor2_1
X_13818_ _13818_/X _24178_/Q _24210_/Q _23314_/Q _23346_/Q _13978_/S0 _13978_/S1 VPWR
+ VGND sg13g2_mux4_1
XFILLER_23_419 VPWR VGND sg13g2_decap_8
X_17586_ _17586_/Y _17586_/A _17586_/B VPWR VGND sg13g2_nor2_1
XFILLER_91_1102 VPWR VGND sg13g2_fill_2
X_14798_ _14798_/Y _24247_/A _14879_/A _14797_/Y VPWR VGND sg13g2_a21oi_1
XFILLER_50_216 VPWR VGND sg13g2_decap_8
X_16537_ _16538_/B _22622_/Q _16537_/B VPWR VGND sg13g2_xnor2_1
XFILLER_50_238 VPWR VGND sg13g2_decap_8
X_19325_ _19325_/X _19331_/A _19325_/B _19331_/C _19480_/C VPWR VGND sg13g2_and4_1
XFILLER_17_1206 VPWR VGND sg13g2_decap_8
X_13749_ _13947_/A _13856_/A _13856_/B _13877_/B VPWR VGND sg13g2_and3_1
XFILLER_31_430 VPWR VGND sg13g2_fill_1
XFILLER_32_964 VPWR VGND sg13g2_decap_4
XFILLER_56_1277 VPWR VGND sg13g2_decap_4
XFILLER_52_1119 VPWR VGND sg13g2_fill_2
X_19256_ _19256_/Y _19263_/A _19257_/B VPWR VGND sg13g2_nor2b_1
X_16468_ _16468_/Y _22597_/Q _16514_/B VPWR VGND sg13g2_nand2_1
X_19187_ _19190_/B _19266_/A _19261_/B VPWR VGND sg13g2_nor2_1
X_16399_ _22567_/D _23017_/Q _22567_/Q _16421_/S VPWR VGND sg13g2_mux2_1
XFILLER_69_1605 VPWR VGND sg13g2_decap_8
X_18138_ _22962_/D _18524_/B _18290_/A _18137_/Y VPWR VGND sg13g2_o21ai_1
Xoutput4468 data_addr_o[10] _24255_/X VPWR VGND sg13g2_buf_1
Xoutput4479 data_addr_o[21] _24266_/X VPWR VGND sg13g2_buf_1
XFILLER_12_1862 VPWR VGND sg13g2_decap_8
XFILLER_7_191 VPWR VGND sg13g2_fill_1
X_18069_ _18069_/Y _18069_/A _18501_/S _18189_/B VPWR VGND sg13g2_nand3_1
X_20100_ _20100_/Y _20100_/A1 _20097_/Y _20099_/Y _20317_/B _20100_/C1 VPWR VGND sg13g2_a221oi_1
XFILLER_99_942 VPWR VGND sg13g2_fill_2
X_21080_ _23570_/D _22314_/A1 _21079_/B _21079_/Y VPWR VGND sg13g2_o21ai_1
X_20031_ _20031_/Y _20031_/A _20031_/B VPWR VGND sg13g2_nand2_1
XFILLER_67_1395 VPWR VGND sg13g2_decap_8
XFILLER_59_828 VPWR VGND sg13g2_decap_4
XFILLER_115_1327 VPWR VGND sg13g2_fill_1
XFILLER_113_785 VPWR VGND sg13g2_decap_8
XFILLER_100_413 VPWR VGND sg13g2_decap_8
XFILLER_85_113 VPWR VGND sg13g2_decap_4
XFILLER_45_1660 VPWR VGND sg13g2_fill_1
XFILLER_86_647 VPWR VGND sg13g2_decap_4
XFILLER_45_1693 VPWR VGND sg13g2_decap_4
XFILLER_85_146 VPWR VGND sg13g2_fill_1
XFILLER_6_1142 VPWR VGND sg13g2_fill_2
Xclkbuf_leaf_50_clk_i clkload39/A clkbuf_leaf_55_clk_i/A VPWR VGND sg13g2_buf_16
XFILLER_67_861 VPWR VGND sg13g2_decap_4
XFILLER_113_1040 VPWR VGND sg13g2_fill_2
XFILLER_85_179 VPWR VGND sg13g2_fill_2
XFILLER_41_1568 VPWR VGND sg13g2_decap_4
X_21982_ _21982_/Y _21982_/A _21982_/B VPWR VGND sg13g2_nand2_1
XFILLER_67_883 VPWR VGND sg13g2_fill_1
XFILLER_2_1028 VPWR VGND sg13g2_decap_8
X_23721_ _23721_/Q _24113_/CLK _23721_/D fanout2682/X VPWR VGND sg13g2_dfrbpq_1
X_20933_ _23512_/D _22396_/A1 _20936_/B _20932_/Y VPWR VGND sg13g2_o21ai_1
XFILLER_54_533 VPWR VGND sg13g2_decap_8
XFILLER_66_393 VPWR VGND sg13g2_decap_8
XFILLER_110_1950 VPWR VGND sg13g2_decap_4
XFILLER_82_875 VPWR VGND sg13g2_fill_1
X_23652_ _23652_/Q clkload41/A _23652_/D fanout2703/X VPWR VGND sg13g2_dfrbpq_1
X_20864_ _20864_/Y _20864_/A _20902_/S VPWR VGND sg13g2_nand2_1
XFILLER_93_1934 VPWR VGND sg13g2_decap_8
XFILLER_54_588 VPWR VGND sg13g2_decap_8
XFILLER_74_1311 VPWR VGND sg13g2_decap_8
XFILLER_81_385 VPWR VGND sg13g2_decap_8
Xclkbuf_leaf_65_clk_i _23187_/CLK clkbuf_4_2__f_clk_i/X VPWR VGND sg13g2_buf_16
XFILLER_54_599 VPWR VGND sg13g2_fill_1
XFILLER_54_1907 VPWR VGND sg13g2_decap_8
X_22603_ _22603_/Q clkload10/A _22603_/D fanout2811/X VPWR VGND sg13g2_dfrbpq_1
X_23583_ _23583_/Q clkload40/A _23583_/D fanout2736/X VPWR VGND sg13g2_dfrbpq_1
X_20795_ _23447_/D _20931_/A1 _20794_/B _20794_/Y VPWR VGND sg13g2_o21ai_1
XFILLER_39_1497 VPWR VGND sg13g2_decap_8
XFILLER_70_1208 VPWR VGND sg13g2_decap_8
XFILLER_35_1339 VPWR VGND sg13g2_decap_8
X_22534_ _22534_/Q clkload6/A _22534_/D fanout2803/X VPWR VGND sg13g2_dfrbpq_1
XFILLER_108_1890 VPWR VGND sg13g2_decap_8
XFILLER_72_1090 VPWR VGND sg13g2_decap_8
XFILLER_10_658 VPWR VGND sg13g2_fill_1
X_22465_ _22465_/Q clkload18/A _22465_/D fanout2827/X VPWR VGND sg13g2_dfrbpq_1
XFILLER_33_1063 VPWR VGND sg13g2_decap_8
X_24204_ _24204_/Q clkload38/A _24204_/D fanout2631/X VPWR VGND sg13g2_dfrbpq_1
XFILLER_108_524 VPWR VGND sg13g2_decap_8
X_21416_ _21416_/Y _23728_/Q _21416_/B VPWR VGND sg13g2_nand2_1
X_22396_ _24184_/D _22396_/A1 _22402_/B _22395_/Y VPWR VGND sg13g2_o21ai_1
X_24135_ _24135_/Q _24170_/CLK _24135_/D fanout2698/X VPWR VGND sg13g2_dfrbpq_1
XFILLER_11_1361 VPWR VGND sg13g2_decap_8
XFILLER_2_802 VPWR VGND sg13g2_decap_8
X_21347_ _21347_/Y _21347_/A _21347_/B VPWR VGND sg13g2_nand2_1
Xfanout2805 fanout2805/X fanout2810/X VPWR VGND sg13g2_buf_1
XFILLER_1_312 VPWR VGND sg13g2_fill_2
X_12080_ _12080_/Y _19322_/A _19728_/B _15319_/A VPWR VGND sg13g2_a21oi_1
XFILLER_85_1462 VPWR VGND sg13g2_fill_2
X_24066_ _24066_/Q _24131_/CLK _24066_/D fanout2716/X VPWR VGND sg13g2_dfrbpq_1
Xfanout2816 fanout2816/X fanout2822/X VPWR VGND sg13g2_buf_1
X_21278_ _21278_/Y _23662_/Q _21281_/B VPWR VGND sg13g2_nand2_1
XFILLER_2_857 VPWR VGND sg13g2_fill_1
Xfanout2827 fanout2827/X fanout2830/X VPWR VGND sg13g2_buf_1
Xfanout2838 fanout2838/X fanout2839/X VPWR VGND sg13g2_buf_1
XFILLER_78_79 VPWR VGND sg13g2_fill_2
X_23017_ _23017_/Q clkload6/A _23017_/D fanout2804/X VPWR VGND sg13g2_dfrbpq_1
Xfanout2849 fanout2849/X fanout2902/X VPWR VGND sg13g2_buf_1
X_20229_ _20229_/Y _20229_/A _20229_/B VPWR VGND sg13g2_nor2_1
XFILLER_81_1348 VPWR VGND sg13g2_fill_2
XFILLER_104_785 VPWR VGND sg13g2_fill_1
XFILLER_103_262 VPWR VGND sg13g2_fill_2
XFILLER_8_1930 VPWR VGND sg13g2_decap_8
XFILLER_46_1479 VPWR VGND sg13g2_decap_8
XFILLER_77_636 VPWR VGND sg13g2_decap_8
XFILLER_63_1771 VPWR VGND sg13g2_decap_8
XFILLER_63_1782 VPWR VGND sg13g2_fill_2
XFILLER_115_1861 VPWR VGND sg13g2_decap_8
Xclkbuf_leaf_18_clk_i clkload24/A clkbuf_4_5__f_clk_i/X VPWR VGND sg13g2_buf_16
XFILLER_4_1816 VPWR VGND sg13g2_decap_8
XFILLER_65_809 VPWR VGND sg13g2_fill_1
XFILLER_76_157 VPWR VGND sg13g2_decap_4
XFILLER_98_1823 VPWR VGND sg13g2_decap_8
X_15770_ _15771_/D _22860_/Q _15989_/A2 _15873_/B _22607_/Q VPWR VGND sg13g2_a22oi_1
XFILLER_98_1834 VPWR VGND sg13g2_fill_2
X_12982_ _12983_/C _23430_/Q _23494_/Q _23590_/Q _23654_/Q _12733_/S _12982_/S1 VPWR
+ VGND sg13g2_mux4_1
XFILLER_100_991 VPWR VGND sg13g2_fill_2
X_14721_ _14721_/Y _14295_/B _14715_/B _14720_/Y VPWR VGND sg13g2_a21oi_1
XFILLER_73_831 VPWR VGND sg13g2_decap_8
X_23919_ _23919_/Q clkload47/A _23919_/D fanout2661/X VPWR VGND sg13g2_dfrbpq_1
X_11933_ _11933_/Y _11911_/X _11927_/Y _11929_/Y _11932_/Y VPWR VGND sg13g2_a22oi_1
XFILLER_73_853 VPWR VGND sg13g2_fill_1
XFILLER_2_1573 VPWR VGND sg13g2_fill_2
X_14652_ _14652_/X _14650_/Y _14651_/X _14726_/S VPWR VGND sg13g2_mux2_1
XFILLER_45_588 VPWR VGND sg13g2_decap_8
XFILLER_72_374 VPWR VGND sg13g2_decap_4
XFILLER_72_385 VPWR VGND sg13g2_fill_2
X_13603_ _13604_/A _14103_/A _13742_/A VPWR VGND sg13g2_xnor2_1
XFILLER_60_536 VPWR VGND sg13g2_fill_2
XFILLER_72_396 VPWR VGND sg13g2_fill_1
X_17371_ _22813_/D _17228_/B _22813_/Q _17371_/S VPWR VGND sg13g2_mux2_1
XFILLER_32_249 VPWR VGND sg13g2_fill_1
X_14583_ _14584_/C _24242_/Q _14583_/B VPWR VGND sg13g2_nand2b_1
X_11795_ _11796_/B _23417_/Q _23481_/Q _11797_/S VPWR VGND sg13g2_mux2_1
XFILLER_92_1477 VPWR VGND sg13g2_decap_4
X_19110_ _19110_/X _19017_/A _23123_/Q _19114_/S VPWR VGND sg13g2_mux2_1
X_16322_ _16324_/B _16322_/A _16322_/B _16322_/C _16322_/D VPWR VGND sg13g2_nand4_1
XFILLER_53_1428 VPWR VGND sg13g2_decap_8
X_13534_ _13534_/Y _13406_/A _13533_/X _20243_/A _20243_/B _13861_/A VPWR VGND sg13g2_a221oi_1
XFILLER_14_997 VPWR VGND sg13g2_decap_8
XFILLER_43_71 VPWR VGND sg13g2_decap_4
XFILLER_40_260 VPWR VGND sg13g2_decap_8
XFILLER_40_271 VPWR VGND sg13g2_fill_2
X_19041_ _19041_/Y _19041_/A _19041_/B _19041_/C VPWR VGND sg13g2_nand3_1
X_16253_ _16273_/C _16253_/A _16262_/A _16253_/C _16253_/D VPWR VGND sg13g2_nor4_2
X_13465_ _13465_/X _23565_/Q _24013_/Q _13466_/A VPWR VGND sg13g2_mux2_1
XFILLER_51_1141 VPWR VGND sg13g2_decap_8
X_15204_ _15204_/Y _22545_/Q VPWR VGND sg13g2_inv_1
X_12416_ _19955_/B _12412_/Y _11331_/Y _12415_/X VPWR VGND sg13g2_o21ai_1
XFILLER_103_1253 VPWR VGND sg13g2_fill_1
X_16184_ _16184_/Y _17197_/A _16161_/X _16183_/X VPWR VGND sg13g2_a21oi_1
X_13396_ _13403_/C _13641_/A _13396_/B VPWR VGND sg13g2_nor2_1
XFILLER_64_7 VPWR VGND sg13g2_decap_8
XFILLER_86_1215 VPWR VGND sg13g2_decap_8
XFILLER_103_1286 VPWR VGND sg13g2_fill_1
X_12347_ _12352_/A _19428_/A _12347_/B VPWR VGND sg13g2_nand2_1
XFILLER_99_205 VPWR VGND sg13g2_decap_8
X_15066_ _15068_/B _22477_/Q _15006_/B _15066_/B1 _22936_/Q VPWR VGND sg13g2_a22oi_1
X_19943_ _19943_/Y _20071_/A _19943_/B VPWR VGND sg13g2_nand2_1
XFILLER_4_21 VPWR VGND sg13g2_decap_4
XFILLER_4_172 VPWR VGND sg13g2_decap_8
XFILLER_64_1502 VPWR VGND sg13g2_decap_8
XFILLER_68_1671 VPWR VGND sg13g2_decap_4
XFILLER_107_590 VPWR VGND sg13g2_decap_8
X_12278_ _12278_/X _12278_/A _12278_/B VPWR VGND sg13g2_xor2_1
XFILLER_64_1513 VPWR VGND sg13g2_decap_8
XFILLER_4_65 VPWR VGND sg13g2_fill_2
XFILLER_9_1738 VPWR VGND sg13g2_decap_8
X_11229_ _19360_/A _22943_/Q _24234_/Q VPWR VGND sg13g2_nor2b_2
X_19874_ _19874_/Y _19874_/A _19874_/B VPWR VGND sg13g2_nand2_1
XFILLER_95_400 VPWR VGND sg13g2_decap_8
XFILLER_9_1749 VPWR VGND sg13g2_fill_1
XFILLER_4_76 VPWR VGND sg13g2_decap_4
XFILLER_110_711 VPWR VGND sg13g2_decap_8
XFILLER_110_722 VPWR VGND sg13g2_fill_2
XFILLER_42_1811 VPWR VGND sg13g2_decap_8
X_18825_ _18826_/C _23070_/Q _18825_/B VPWR VGND sg13g2_nand2_1
XFILLER_110_755 VPWR VGND sg13g2_decap_8
XFILLER_7_1451 VPWR VGND sg13g2_fill_2
XFILLER_110_766 VPWR VGND sg13g2_decap_8
XFILLER_62_1281 VPWR VGND sg13g2_fill_2
XFILLER_83_617 VPWR VGND sg13g2_decap_8
X_18756_ _18757_/B _18756_/A _18756_/B VPWR VGND sg13g2_nand2_1
X_15968_ _15976_/C _22834_/Q _15359_/Y _15349_/Y VPWR VGND sg13g2_a21oi_1
XFILLER_23_1265 VPWR VGND sg13g2_decap_8
XFILLER_76_680 VPWR VGND sg13g2_decap_8
XFILLER_82_138 VPWR VGND sg13g2_decap_4
X_14919_ _16265_/A _14919_/A _14919_/B VPWR VGND sg13g2_or2_1
X_18687_ _23015_/D _18685_/A _18683_/Y _18686_/Y VPWR VGND sg13g2_a21oi_1
X_15899_ _15904_/B _15944_/A _15899_/B VPWR VGND sg13g2_or2_1
XFILLER_64_875 VPWR VGND sg13g2_decap_4
XFILLER_93_1219 VPWR VGND sg13g2_decap_8
XFILLER_51_503 VPWR VGND sg13g2_decap_4
XFILLER_63_363 VPWR VGND sg13g2_decap_4
X_17638_ _17638_/Y _22050_/A _17697_/A _17637_/Y VPWR VGND sg13g2_o21ai_1
XFILLER_91_694 VPWR VGND sg13g2_fill_2
XFILLER_51_536 VPWR VGND sg13g2_decap_4
XFILLER_51_547 VPWR VGND sg13g2_fill_1
XFILLER_95_1090 VPWR VGND sg13g2_decap_8
XFILLER_51_558 VPWR VGND sg13g2_decap_8
X_17569_ _17569_/Y _17569_/A _17569_/B VPWR VGND sg13g2_nand2_1
XFILLER_90_0 VPWR VGND sg13g2_decap_8
XFILLER_108_1142 VPWR VGND sg13g2_decap_4
X_19308_ _19308_/Y _11602_/Y _11305_/B _14240_/A _11258_/B _11243_/A VPWR VGND sg13g2_a221oi_1
X_20580_ _23347_/D _23347_/Q _22449_/A1 _20580_/S VPWR VGND sg13g2_mux2_1
XFILLER_71_1539 VPWR VGND sg13g2_decap_8
XFILLER_17_1047 VPWR VGND sg13g2_decap_8
XFILLER_104_1017 VPWR VGND sg13g2_decap_8
X_19239_ _19240_/B _14629_/Y _14631_/B _19238_/Y VPWR VGND sg13g2_o21ai_1
XFILLER_20_967 VPWR VGND sg13g2_fill_1
XFILLER_104_1039 VPWR VGND sg13g2_decap_4
XFILLER_14_1935 VPWR VGND sg13g2_decap_8
XFILLER_34_1372 VPWR VGND sg13g2_decap_4
XFILLER_20_989 VPWR VGND sg13g2_fill_1
XFILLER_34_1383 VPWR VGND sg13g2_fill_2
X_22250_ _22250_/Y _22250_/A _22250_/B VPWR VGND sg13g2_nand2_1
X_21201_ _21220_/S _22430_/B _21201_/B VPWR VGND sg13g2_nor2_1
X_22181_ _22181_/Y _22181_/A _22184_/B VPWR VGND sg13g2_nand2_1
Xhold4902 _17356_/A _22805_/Q VPWR VGND sg13g2_dlygate4sd3_1
XFILLER_105_516 VPWR VGND sg13g2_decap_8
Xhold4913 _21526_/A _23779_/Q VPWR VGND sg13g2_dlygate4sd3_1
Xhold4924 _20393_/A _23261_/Q VPWR VGND sg13g2_dlygate4sd3_1
Xhold4935 _21506_/A _23770_/Q VPWR VGND sg13g2_dlygate4sd3_1
X_21132_ _21132_/Y _23591_/Q _21138_/B VPWR VGND sg13g2_nand2_1
Xhold4946 _20740_/A _23421_/Q VPWR VGND sg13g2_dlygate4sd3_1
Xhold4957 _21951_/A _23970_/Q VPWR VGND sg13g2_dlygate4sd3_1
XFILLER_67_1170 VPWR VGND sg13g2_decap_8
Xhold4968 _21467_/A _23751_/Q VPWR VGND sg13g2_dlygate4sd3_1
Xhold4979 _20408_/A _23268_/Q VPWR VGND sg13g2_dlygate4sd3_1
XFILLER_101_711 VPWR VGND sg13g2_decap_8
XFILLER_115_1124 VPWR VGND sg13g2_decap_8
XFILLER_113_582 VPWR VGND sg13g2_decap_8
XFILLER_82_1679 VPWR VGND sg13g2_decap_4
XFILLER_58_113 VPWR VGND sg13g2_fill_1
X_20014_ _20015_/C _20014_/A _20117_/C VPWR VGND sg13g2_nor2_1
XFILLER_98_293 VPWR VGND sg13g2_decap_4
XFILLER_47_809 VPWR VGND sg13g2_decap_4
XFILLER_80_1392 VPWR VGND sg13g2_decap_4
XFILLER_21_1917 VPWR VGND sg13g2_decap_8
XFILLER_101_799 VPWR VGND sg13g2_decap_4
XFILLER_104_77 VPWR VGND sg13g2_decap_8
XFILLER_73_149 VPWR VGND sg13g2_decap_8
X_21965_ _23977_/D _21965_/A0 _23977_/Q _21965_/S VPWR VGND sg13g2_mux2_1
XFILLER_82_650 VPWR VGND sg13g2_decap_8
XFILLER_27_566 VPWR VGND sg13g2_decap_8
XFILLER_70_801 VPWR VGND sg13g2_decap_8
X_23704_ _23704_/Q clkload52/A _23704_/D fanout2688/X VPWR VGND sg13g2_dfrbpq_1
X_20916_ _20916_/Y _23506_/Q _20919_/B VPWR VGND sg13g2_nand2_1
XFILLER_93_1720 VPWR VGND sg13g2_decap_8
XFILLER_70_823 VPWR VGND sg13g2_decap_8
X_21896_ _23943_/D _21962_/A1 _21900_/B _21895_/Y VPWR VGND sg13g2_o21ai_1
XFILLER_42_536 VPWR VGND sg13g2_decap_8
XFILLER_19_1813 VPWR VGND sg13g2_decap_8
X_23635_ _23635_/Q clkload51/A _23635_/D fanout2664/X VPWR VGND sg13g2_dfrbpq_1
XFILLER_39_1250 VPWR VGND sg13g2_fill_1
XFILLER_74_1130 VPWR VGND sg13g2_decap_4
X_20847_ _20847_/Y _23472_/Q _20847_/B VPWR VGND sg13g2_nand2_1
XFILLER_35_1103 VPWR VGND sg13g2_decap_8
XFILLER_58_1895 VPWR VGND sg13g2_decap_4
XFILLER_70_878 VPWR VGND sg13g2_decap_8
XFILLER_70_889 VPWR VGND sg13g2_fill_2
XFILLER_23_772 VPWR VGND sg13g2_decap_8
XFILLER_22_260 VPWR VGND sg13g2_fill_2
X_23566_ _23566_/Q _24170_/CLK _23566_/D fanout2638/X VPWR VGND sg13g2_dfrbpq_1
X_11580_ _11580_/Y _15407_/A _15216_/A VPWR VGND sg13g2_nand2_1
X_20778_ _20778_/Y _23440_/Q _20778_/B VPWR VGND sg13g2_nand2_1
XFILLER_70_1027 VPWR VGND sg13g2_decap_4
XFILLER_22_271 VPWR VGND sg13g2_fill_1
X_22517_ _22517_/Q clkload11/A _22517_/D fanout2846/X VPWR VGND sg13g2_dfrbpq_1
XFILLER_17_1570 VPWR VGND sg13g2_fill_2
X_23497_ _23497_/Q clkload47/A _23497_/D fanout2679/X VPWR VGND sg13g2_dfrbpq_1
XFILLER_17_1581 VPWR VGND sg13g2_decap_8
XFILLER_13_1423 VPWR VGND sg13g2_fill_1
X_13250_ _13250_/Y _13253_/S _24042_/Q _13249_/Y VPWR VGND sg13g2_o21ai_1
XFILLER_108_321 VPWR VGND sg13g2_decap_8
XFILLER_10_488 VPWR VGND sg13g2_decap_8
X_22448_ _24210_/D _22448_/A1 _22450_/B _22447_/Y VPWR VGND sg13g2_o21ai_1
X_12201_ _12202_/B _24157_/Q _23229_/Q _12203_/S VPWR VGND sg13g2_mux2_1
XFILLER_109_877 VPWR VGND sg13g2_fill_2
XFILLER_13_1489 VPWR VGND sg13g2_decap_8
X_13181_ _13181_/X _22568_/Q _13181_/B VPWR VGND sg13g2_or2_1
X_22379_ _24177_/D _24177_/Q _22446_/A1 _22382_/S VPWR VGND sg13g2_mux2_1
XFILLER_89_56 VPWR VGND sg13g2_fill_2
XFILLER_48_1508 VPWR VGND sg13g2_fill_2
XFILLER_87_1568 VPWR VGND sg13g2_fill_1
X_12132_ _12132_/Y _23644_/Q _12193_/S VPWR VGND sg13g2_nand2b_1
X_24118_ _24118_/Q clkload46/A _24118_/D fanout2677/X VPWR VGND sg13g2_dfrbpq_1
XFILLER_65_1811 VPWR VGND sg13g2_decap_8
Xfanout2624 fanout2624/X fanout2625/X VPWR VGND sg13g2_buf_1
X_24049_ _24049_/Q clkload50/A _24049_/D fanout2666/X VPWR VGND sg13g2_dfrbpq_1
X_12063_ _12064_/B _12059_/X _12060_/X _12061_/X _12062_/X _13158_/S _11917_/A VPWR
+ VGND sg13g2_mux4_1
X_16940_ _16940_/X _22698_/Q _16940_/B VPWR VGND sg13g2_xor2_1
XFILLER_1_142 VPWR VGND sg13g2_decap_4
Xfanout2635 fanout2635/X fanout2636/X VPWR VGND sg13g2_buf_1
XFILLER_65_1866 VPWR VGND sg13g2_decap_8
XFILLER_78_923 VPWR VGND sg13g2_fill_1
Xfanout2646 fanout2646/X fanout2647/X VPWR VGND sg13g2_buf_1
Xfanout2657 fanout2657/X fanout2660/X VPWR VGND sg13g2_buf_1
XFILLER_89_271 VPWR VGND sg13g2_decap_8
XFILLER_65_1877 VPWR VGND sg13g2_fill_1
XFILLER_104_582 VPWR VGND sg13g2_decap_8
Xfanout2668 fanout2668/X fanout2693/X VPWR VGND sg13g2_buf_1
Xfanout2679 fanout2679/X fanout2681/X VPWR VGND sg13g2_buf_1
XFILLER_89_282 VPWR VGND sg13g2_fill_1
XFILLER_49_124 VPWR VGND sg13g2_decap_8
X_16871_ _16921_/S _16871_/A _16871_/B _16871_/C VPWR VGND sg13g2_nor3_1
XFILLER_46_1298 VPWR VGND sg13g2_decap_8
XFILLER_49_135 VPWR VGND sg13g2_fill_2
XFILLER_77_444 VPWR VGND sg13g2_decap_8
XFILLER_37_308 VPWR VGND sg13g2_decap_8
X_15822_ _16165_/A _23020_/Q _22570_/Q _15889_/S VPWR VGND sg13g2_mux2_1
X_19590_ _19700_/B _19589_/A _19429_/Y _19589_/Y VPWR VGND sg13g2_o21ai_1
XFILLER_4_1635 VPWR VGND sg13g2_decap_8
XFILLER_93_948 VPWR VGND sg13g2_decap_8
XFILLER_77_499 VPWR VGND sg13g2_fill_2
XFILLER_98_1631 VPWR VGND sg13g2_decap_8
XFILLER_46_831 VPWR VGND sg13g2_fill_1
XFILLER_92_447 VPWR VGND sg13g2_decap_8
X_18541_ _18542_/B _18541_/A1 _18538_/X _18479_/X VPWR VGND sg13g2_o21ai_1
X_15753_ _20168_/A _15753_/A _15753_/B _15753_/C _15753_/D VPWR VGND sg13g2_and4_1
XFILLER_98_1664 VPWR VGND sg13g2_decap_8
X_12965_ _12965_/X _12965_/A _12965_/B _19446_/A VPWR VGND sg13g2_and3_1
XFILLER_46_853 VPWR VGND sg13g2_decap_4
XFILLER_98_1675 VPWR VGND sg13g2_decap_8
XFILLER_46_864 VPWR VGND sg13g2_decap_8
XFILLER_79_1063 VPWR VGND sg13g2_decap_8
X_11916_ _11917_/B _23898_/Q _23994_/Q _24090_/Q _24122_/Q _11919_/S _12039_/A VPWR
+ VGND sg13g2_mux4_1
X_14704_ _14704_/Y _14704_/A _14718_/B VPWR VGND sg13g2_nor2_1
XFILLER_33_503 VPWR VGND sg13g2_decap_8
X_18472_ _18828_/B _19126_/A1 _23071_/Q _18548_/S VPWR VGND sg13g2_mux2_1
X_15684_ _15688_/A _22894_/Q _15684_/B VPWR VGND sg13g2_nand2_1
X_12896_ _12897_/D _12740_/A _12888_/X _12895_/Y VPWR VGND sg13g2_o21ai_1
XFILLER_2_1392 VPWR VGND sg13g2_decap_8
XFILLER_37_1902 VPWR VGND sg13g2_decap_8
XFILLER_60_311 VPWR VGND sg13g2_fill_2
XFILLER_61_845 VPWR VGND sg13g2_decap_8
X_17423_ _17423_/Y _17423_/A _17425_/B VPWR VGND sg13g2_nand2_1
XFILLER_60_333 VPWR VGND sg13g2_decap_4
XFILLER_61_856 VPWR VGND sg13g2_fill_2
X_11847_ _11847_/Y _12235_/S _23641_/Q _11846_/Y VPWR VGND sg13g2_o21ai_1
XFILLER_14_772 VPWR VGND sg13g2_decap_8
Xplace4208 _12123_/A _13701_/S0 VPWR VGND sg13g2_buf_2
XFILLER_14_783 VPWR VGND sg13g2_fill_2
X_17354_ _22803_/D _16154_/X _17369_/B _17353_/Y VPWR VGND sg13g2_o21ai_1
X_11778_ _12075_/B _11778_/A _11983_/D VPWR VGND sg13g2_xnor2_1
Xplace4219 _11477_/A _22984_/Q VPWR VGND sg13g2_buf_1
XFILLER_72_1859 VPWR VGND sg13g2_decap_8
XFILLER_18_1367 VPWR VGND sg13g2_fill_2
XFILLER_105_1326 VPWR VGND sg13g2_decap_8
XFILLER_18_1378 VPWR VGND sg13g2_fill_2
XFILLER_105_1337 VPWR VGND sg13g2_fill_2
X_16305_ _16305_/Y _18712_/A VPWR VGND sg13g2_inv_1
X_13517_ _13517_/Y _13854_/A _13517_/B VPWR VGND sg13g2_nand2_1
X_17285_ _22771_/D _16154_/X _17284_/B _17284_/Y VPWR VGND sg13g2_o21ai_1
Xplace3507 _17835_/B _17399_/A VPWR VGND sg13g2_buf_1
XFILLER_105_1348 VPWR VGND sg13g2_fill_2
X_14497_ _14519_/A _14497_/A _14497_/B _14497_/C _14497_/D VPWR VGND sg13g2_nand4_1
Xplace3518 _15947_/A1 _16014_/A VPWR VGND sg13g2_buf_1
Xplace3529 _15992_/B1 _15945_/B1 VPWR VGND sg13g2_buf_1
X_19024_ _19024_/Y _17992_/S _19024_/B _19024_/C VPWR VGND sg13g2_nand3b_1
XFILLER_16_1080 VPWR VGND sg13g2_decap_8
X_16236_ _22517_/D _16241_/B _16236_/B VPWR VGND sg13g2_xnor2_1
Xclkload12 clkload12/Y clkload12/A VPWR VGND sg13g2_inv_8
XFILLER_31_1545 VPWR VGND sg13g2_decap_8
X_13448_ _13449_/A _14005_/A _13999_/A VPWR VGND sg13g2_nand2_1
Xclkload23 clkload23/X clkload23/A VPWR VGND sg13g2_buf_16
Xclkload34 clkload34/Y clkload34/A VPWR VGND sg13g2_inv_4
XFILLER_115_803 VPWR VGND sg13g2_decap_8
Xclkload45 clkload45/Y clkload45/A VPWR VGND sg13g2_inv_2
Xclkload56 clkload56/Y clkload56/A VPWR VGND sg13g2_inv_2
X_16167_ _16169_/A _15839_/A _15838_/Y _15839_/Y VPWR VGND sg13g2_a21oi_1
X_13379_ _13379_/X _13379_/A _13379_/B VPWR VGND sg13g2_or2_1
XFILLER_6_993 VPWR VGND sg13g2_fill_1
XFILLER_83_1922 VPWR VGND sg13g2_fill_1
X_16098_ _16098_/Y _22493_/Q _16207_/B _16097_/Y VPWR VGND sg13g2_a21oi_1
XFILLER_88_709 VPWR VGND sg13g2_fill_1
XFILLER_86_1089 VPWR VGND sg13g2_decap_8
XFILLER_9_1502 VPWR VGND sg13g2_decap_8
XFILLER_102_519 VPWR VGND sg13g2_decap_8
XFILLER_87_208 VPWR VGND sg13g2_fill_1
X_15049_ _15050_/B _17908_/A1 _15107_/A2 _15070_/B VPWR VGND sg13g2_o21ai_1
X_19926_ _23229_/D _19950_/B _22407_/A1 _19925_/Y VPWR VGND sg13g2_o21ai_1
XFILLER_68_411 VPWR VGND sg13g2_fill_1
XFILLER_96_731 VPWR VGND sg13g2_fill_2
XFILLER_60_1207 VPWR VGND sg13g2_decap_8
XFILLER_96_742 VPWR VGND sg13g2_decap_4
X_19857_ _19857_/Y _19857_/A _19857_/B VPWR VGND sg13g2_nand2_1
XFILLER_99_1406 VPWR VGND sg13g2_decap_8
XFILLER_60_1229 VPWR VGND sg13g2_fill_1
XFILLER_84_915 VPWR VGND sg13g2_decap_4
XFILLER_56_606 VPWR VGND sg13g2_decap_8
XFILLER_96_775 VPWR VGND sg13g2_fill_1
X_18808_ _18814_/A _23036_/Q _18821_/B _18821_/C VPWR VGND sg13g2_nand3_1
XFILLER_96_797 VPWR VGND sg13g2_decap_8
XFILLER_110_585 VPWR VGND sg13g2_decap_8
X_19788_ _19788_/Y _20329_/B2 _19779_/Y _19787_/Y VPWR VGND sg13g2_a21oi_1
XFILLER_55_138 VPWR VGND sg13g2_fill_2
X_18739_ _18739_/Y _15089_/Y _18741_/B VPWR VGND sg13g2_nand2b_1
XFILLER_55_149 VPWR VGND sg13g2_fill_1
XFILLER_97_1141 VPWR VGND sg13g2_decap_8
XFILLER_23_1095 VPWR VGND sg13g2_fill_2
X_20701_ _20701_/Y _20701_/A _20713_/B VPWR VGND sg13g2_nand2_1
XFILLER_90_1904 VPWR VGND sg13g2_fill_2
XFILLER_24_569 VPWR VGND sg13g2_decap_8
XFILLER_51_344 VPWR VGND sg13g2_fill_1
X_21681_ _21681_/Y _21681_/A _21687_/B VPWR VGND sg13g2_nand2_1
XFILLER_75_1450 VPWR VGND sg13g2_fill_1
X_23420_ _23420_/Q clkload53/A _23420_/D fanout2787/X VPWR VGND sg13g2_dfrbpq_1
XFILLER_90_1948 VPWR VGND sg13g2_decap_8
X_20632_ _23370_/D _22435_/A1 _20638_/B _20631_/Y VPWR VGND sg13g2_o21ai_1
XFILLER_51_388 VPWR VGND sg13g2_decap_4
XFILLER_71_1358 VPWR VGND sg13g2_decap_8
X_23351_ _23351_/Q clkload58/A _23351_/D fanout2754/X VPWR VGND sg13g2_dfrbpq_1
Xclkload6 clkload6/X clkload6/A VPWR VGND sg13g2_buf_8
X_20563_ _23336_/D _23336_/Q _21964_/A0 _20580_/S VPWR VGND sg13g2_mux2_1
XFILLER_18_1890 VPWR VGND sg13g2_decap_8
X_22302_ _22302_/Y _24139_/Q _22310_/B VPWR VGND sg13g2_nand2_1
Xclkbuf_4_2__f_clk_i clkbuf_4_2__f_clk_i/X clkbuf_3_1_0_clk_i/X VPWR VGND sg13g2_buf_8
X_23282_ _23282_/Q _24212_/CLK _23282_/D fanout2934/X VPWR VGND sg13g2_dfrbpq_1
X_20494_ _20494_/Y _20494_/A _20504_/B VPWR VGND sg13g2_nand2_1
XFILLER_4_908 VPWR VGND sg13g2_decap_4
XFILLER_30_1044 VPWR VGND sg13g2_decap_8
XFILLER_69_1210 VPWR VGND sg13g2_fill_1
X_22233_ _24105_/D _22233_/A0 _24105_/Q _22243_/S VPWR VGND sg13g2_mux2_1
XFILLER_101_1757 VPWR VGND sg13g2_fill_2
XFILLER_105_302 VPWR VGND sg13g2_decap_8
XFILLER_3_429 VPWR VGND sg13g2_fill_2
Xhold4710 _17360_/A _22807_/Q VPWR VGND sg13g2_dlygate4sd3_1
Xhold4721 _17482_/A _22858_/Q VPWR VGND sg13g2_dlygate4sd3_1
XFILLER_65_1107 VPWR VGND sg13g2_decap_4
X_22164_ _22183_/S _22430_/B _22252_/B VPWR VGND sg13g2_nor2b_1
XFILLER_106_869 VPWR VGND sg13g2_decap_4
Xhold4732 _21271_/A _23658_/Q VPWR VGND sg13g2_dlygate4sd3_1
XFILLER_59_37 VPWR VGND sg13g2_decap_8
Xhold4743 _21818_/A _23906_/Q VPWR VGND sg13g2_dlygate4sd3_1
Xhold4754 _20943_/A _23517_/Q VPWR VGND sg13g2_dlygate4sd3_1
Xhold4765 _22346_/A _24160_/Q VPWR VGND sg13g2_dlygate4sd3_1
X_21115_ _21115_/Y _21115_/A _21121_/B VPWR VGND sg13g2_nand2_1
XFILLER_105_379 VPWR VGND sg13g2_decap_4
Xhold4776 _22304_/A _24140_/Q VPWR VGND sg13g2_dlygate4sd3_1
X_22095_ _22095_/Y _24039_/Q _22095_/B VPWR VGND sg13g2_nand2_1
Xhold4787 _21262_/A _23653_/Q VPWR VGND sg13g2_dlygate4sd3_1
XFILLER_115_21 VPWR VGND sg13g2_decap_8
Xhold4798 _21003_/A _23543_/Q VPWR VGND sg13g2_dlygate4sd3_1
XFILLER_87_731 VPWR VGND sg13g2_fill_2
XFILLER_101_530 VPWR VGND sg13g2_decap_8
X_21046_ _23556_/D _22356_/A1 _21051_/B _21045_/Y VPWR VGND sg13g2_o21ai_1
XFILLER_8_1067 VPWR VGND sg13g2_decap_4
XFILLER_43_1449 VPWR VGND sg13g2_fill_2
XFILLER_87_775 VPWR VGND sg13g2_decap_4
XFILLER_59_466 VPWR VGND sg13g2_fill_1
XFILLER_87_797 VPWR VGND sg13g2_decap_8
XFILLER_115_98 VPWR VGND sg13g2_decap_8
XFILLER_99_1951 VPWR VGND sg13g2_decap_4
XFILLER_21_1747 VPWR VGND sg13g2_decap_8
XFILLER_112_1875 VPWR VGND sg13g2_decap_8
X_22997_ _22997_/Q clkload5/A _22997_/D fanout2843/X VPWR VGND sg13g2_dfrbpq_1
XFILLER_21_1758 VPWR VGND sg13g2_fill_1
XFILLER_28_886 VPWR VGND sg13g2_fill_2
XFILLER_28_897 VPWR VGND sg13g2_fill_2
X_12750_ _15629_/A _12843_/A VPWR VGND sg13g2_inv_1
XFILLER_43_823 VPWR VGND sg13g2_decap_8
X_21948_ _23968_/D _21948_/A1 _21951_/B _21947_/Y VPWR VGND sg13g2_o21ai_1
XFILLER_95_1859 VPWR VGND sg13g2_fill_1
XFILLER_43_834 VPWR VGND sg13g2_fill_1
XFILLER_54_171 VPWR VGND sg13g2_fill_2
XFILLER_55_694 VPWR VGND sg13g2_decap_8
X_11701_ _11731_/D _11701_/A _11701_/B _11701_/C _11701_/D VPWR VGND sg13g2_nor4_1
XFILLER_54_182 VPWR VGND sg13g2_fill_2
XFILLER_54_193 VPWR VGND sg13g2_decap_8
X_12681_ _12692_/C _12873_/A _12681_/B VPWR VGND sg13g2_or2_1
XFILLER_54_1501 VPWR VGND sg13g2_fill_1
XFILLER_58_1670 VPWR VGND sg13g2_fill_2
X_21879_ _21879_/Y _23935_/Q _21885_/B VPWR VGND sg13g2_nand2_1
XFILLER_93_1572 VPWR VGND sg13g2_fill_1
X_14420_ _14421_/B _14418_/Y _14419_/Y _18573_/A VPWR VGND sg13g2_mux2_1
X_23618_ _23618_/Q clkload41/A _23618_/D fanout2727/X VPWR VGND sg13g2_dfrbpq_1
X_11632_ _11635_/A _14119_/B _14117_/C _14086_/A1 VPWR VGND sg13g2_a21oi_1
XFILLER_30_539 VPWR VGND sg13g2_decap_8
XFILLER_19_1676 VPWR VGND sg13g2_fill_2
XFILLER_11_731 VPWR VGND sg13g2_decap_8
XFILLER_19_1698 VPWR VGND sg13g2_decap_8
XFILLER_32_1810 VPWR VGND sg13g2_fill_1
X_11563_ _14133_/B _14143_/C _22990_/Q _22991_/Q VPWR VGND sg13g2_nor3_1
X_23549_ _23549_/Q clkload44/A _23549_/D fanout2745/X VPWR VGND sg13g2_dfrbpq_1
X_13302_ _13303_/A _13528_/A _13300_/X _13301_/Y VPWR VGND sg13g2_a21oi_1
X_17070_ _17070_/Y _17080_/B _15375_/Y VPWR VGND sg13g2_nor2b_1
X_14282_ _19360_/B _19605_/A _15257_/A VPWR VGND sg13g2_and2_1
XFILLER_6_223 VPWR VGND sg13g2_fill_1
XFILLER_52_1291 VPWR VGND sg13g2_decap_4
X_11494_ _21087_/A _22972_/Q VPWR VGND sg13g2_inv_1
XFILLER_104_1370 VPWR VGND sg13g2_decap_8
XFILLER_100_1201 VPWR VGND sg13g2_decap_8
XFILLER_7_768 VPWR VGND sg13g2_fill_2
X_16021_ _16021_/Y _16020_/B _17929_/B2 _16020_/Y VPWR VGND sg13g2_o21ai_1
XFILLER_108_140 VPWR VGND sg13g2_decap_8
X_13233_ _13233_/Y _23562_/Q _13233_/A2 _13232_/X _12050_/C _12443_/A VPWR VGND sg13g2_a221oi_1
XFILLER_40_61 VPWR VGND sg13g2_decap_8
XFILLER_109_685 VPWR VGND sg13g2_decap_8
XFILLER_87_1365 VPWR VGND sg13g2_fill_1
X_13164_ _13164_/Y _13674_/A _13164_/B VPWR VGND sg13g2_nor2_1
XFILLER_87_1398 VPWR VGND sg13g2_fill_2
XFILLER_97_506 VPWR VGND sg13g2_decap_4
XFILLER_65_1630 VPWR VGND sg13g2_decap_8
XFILLER_112_817 VPWR VGND sg13g2_decap_8
XFILLER_111_305 VPWR VGND sg13g2_fill_1
XFILLER_2_451 VPWR VGND sg13g2_fill_2
X_17972_ _17972_/Y _18015_/S _23049_/Q _17971_/Y VPWR VGND sg13g2_a21oi_1
X_13095_ _13095_/Y _13736_/A _13095_/B VPWR VGND sg13g2_nand2_1
XFILLER_2_473 VPWR VGND sg13g2_decap_8
XFILLER_3_996 VPWR VGND sg13g2_decap_8
XFILLER_111_338 VPWR VGND sg13g2_decap_4
X_19711_ _19711_/Y _20028_/A _19708_/X _19710_/Y VPWR VGND sg13g2_o21ai_1
XFILLER_111_349 VPWR VGND sg13g2_fill_2
X_12046_ _12065_/A _13608_/A1 _12041_/X _12045_/X VPWR VGND sg13g2_o21ai_1
X_16923_ _16954_/C _22694_/Q _22693_/Q _22692_/Q VPWR VGND sg13g2_nand3_1
XFILLER_26_1669 VPWR VGND sg13g2_decap_8
X_19642_ _19642_/Y _20058_/A _19642_/B VPWR VGND sg13g2_nor2_1
XFILLER_92_200 VPWR VGND sg13g2_fill_1
XFILLER_8_1590 VPWR VGND sg13g2_decap_8
XFILLER_38_639 VPWR VGND sg13g2_fill_1
XFILLER_37_127 VPWR VGND sg13g2_decap_8
XFILLER_92_222 VPWR VGND sg13g2_fill_1
X_15805_ _15807_/C _22862_/Q _15966_/B1 _15872_/B1 _22827_/Q VPWR VGND sg13g2_a22oi_1
X_19573_ _19574_/B _19572_/X _19413_/Y _19573_/S VPWR VGND sg13g2_mux2_1
XFILLER_93_767 VPWR VGND sg13g2_decap_4
X_16785_ _16785_/Y _16785_/A _16785_/B _16785_/C _16785_/D VPWR VGND sg13g2_nor4_1
XFILLER_1_77 VPWR VGND sg13g2_decap_4
XFILLER_59_1412 VPWR VGND sg13g2_fill_1
XFILLER_98_1472 VPWR VGND sg13g2_decap_4
XFILLER_94_1303 VPWR VGND sg13g2_decap_8
XFILLER_92_266 VPWR VGND sg13g2_fill_2
XFILLER_18_363 VPWR VGND sg13g2_decap_8
X_18524_ _18524_/Y _22991_/Q _18524_/B VPWR VGND sg13g2_nand2_1
XFILLER_52_108 VPWR VGND sg13g2_decap_8
XFILLER_33_300 VPWR VGND sg13g2_decap_8
X_15736_ _17153_/A _15735_/A _14434_/Y _15735_/Y VPWR VGND sg13g2_a21o_1
XFILLER_59_1445 VPWR VGND sg13g2_fill_2
X_12948_ _12955_/A _15690_/A _12948_/B VPWR VGND sg13g2_nand2_1
XFILLER_73_480 VPWR VGND sg13g2_fill_2
XFILLER_94_1358 VPWR VGND sg13g2_fill_1
XFILLER_94_1369 VPWR VGND sg13g2_decap_8
X_18455_ _18455_/Y _18198_/X _18447_/X _18453_/X _18297_/A _18454_/Y VPWR VGND sg13g2_a221oi_1
X_15667_ _15668_/D _15666_/Y _15667_/B VPWR VGND sg13g2_nand2b_1
X_12879_ _12879_/Y _23973_/Q _12884_/B VPWR VGND sg13g2_nand2b_1
XFILLER_53_1000 VPWR VGND sg13g2_decap_8
X_17406_ _17406_/Y _17406_/A _17425_/B VPWR VGND sg13g2_nand2_1
XFILLER_61_686 VPWR VGND sg13g2_decap_8
X_14618_ _14618_/Y _14618_/A _14618_/B VPWR VGND sg13g2_xnor2_1
XFILLER_60_174 VPWR VGND sg13g2_decap_8
XFILLER_92_1071 VPWR VGND sg13g2_decap_8
X_15598_ _15606_/A _16785_/C _15593_/Y _15597_/Y VPWR VGND sg13g2_a21oi_1
X_18386_ _18386_/Y _18253_/B _18384_/Y _18385_/Y VPWR VGND sg13g2_o21ai_1
XFILLER_37_1765 VPWR VGND sg13g2_decap_8
XFILLER_72_1645 VPWR VGND sg13g2_decap_4
XFILLER_53_1033 VPWR VGND sg13g2_fill_2
Xplace4005 _14129_/B _11915_/S VPWR VGND sg13g2_buf_1
Xplace4016 _13158_/S _11926_/S VPWR VGND sg13g2_buf_2
Xplace4027 _13640_/S _12126_/A VPWR VGND sg13g2_buf_4
XFILLER_105_1123 VPWR VGND sg13g2_fill_1
Xplace4038 _11316_/B _14122_/C VPWR VGND sg13g2_buf_1
X_17337_ _17337_/Y _17337_/A _17341_/B VPWR VGND sg13g2_nand2_1
Xplace3304 _21305_/A1 _19817_/Y VPWR VGND sg13g2_buf_1
Xplace4049 _18926_/A _18890_/B VPWR VGND sg13g2_buf_1
Xplace3315 _22318_/B _20719_/A VPWR VGND sg13g2_buf_1
Xplace3326 _21345_/A1 _20266_/Y VPWR VGND sg13g2_buf_1
XFILLER_88_1107 VPWR VGND sg13g2_fill_1
Xplace3337 _22294_/A1 _21960_/A1 VPWR VGND sg13g2_buf_1
Xplace3348 _21943_/A1 _22211_/A1 VPWR VGND sg13g2_buf_1
XFILLER_50_1954 VPWR VGND sg13g2_fill_1
X_17268_ _17268_/Y _17268_/A _17284_/B VPWR VGND sg13g2_nand2_1
Xplace3359 _22272_/A1 _19891_/Y VPWR VGND sg13g2_buf_1
XFILLER_11_1916 VPWR VGND sg13g2_decap_8
X_19007_ _19008_/C _19047_/A _23090_/Q VPWR VGND sg13g2_nand2_1
X_16219_ _16219_/X _14778_/Y _14798_/Y _16240_/A VPWR VGND sg13g2_a21o_1
XFILLER_115_600 VPWR VGND sg13g2_decap_8
X_17199_ _17205_/B _22742_/Q _22741_/Q _22740_/Q _22739_/Q VPWR VGND sg13g2_nand4_1
XFILLER_31_1386 VPWR VGND sg13g2_decap_4
XFILLER_53_0 VPWR VGND sg13g2_decap_8
XFILLER_115_677 VPWR VGND sg13g2_decap_8
XFILLER_114_154 VPWR VGND sg13g2_decap_8
XFILLER_100_1790 VPWR VGND sg13g2_decap_8
XFILLER_88_517 VPWR VGND sg13g2_decap_8
XFILLER_48_1850 VPWR VGND sg13g2_decap_8
XFILLER_102_316 VPWR VGND sg13g2_decap_8
XFILLER_48_1894 VPWR VGND sg13g2_fill_1
XFILLER_102_349 VPWR VGND sg13g2_decap_8
X_19909_ _19909_/X _24213_/Q _23188_/Q VPWR VGND sg13g2_and2_1
XFILLER_25_1135 VPWR VGND sg13g2_fill_1
XFILLER_9_1387 VPWR VGND sg13g2_decap_8
XFILLER_44_1769 VPWR VGND sg13g2_fill_2
XFILLER_64_1195 VPWR VGND sg13g2_decap_8
XFILLER_69_775 VPWR VGND sg13g2_decap_4
X_22920_ _22920_/Q clkload9/A _22920_/D fanout2823/X VPWR VGND sg13g2_dfrbpq_1
XFILLER_110_360 VPWR VGND sg13g2_decap_8
XFILLER_57_937 VPWR VGND sg13g2_decap_8
XFILLER_69_797 VPWR VGND sg13g2_fill_1
XFILLER_25_1179 VPWR VGND sg13g2_decap_8
XFILLER_56_425 VPWR VGND sg13g2_decap_8
XFILLER_84_745 VPWR VGND sg13g2_decap_4
XFILLER_56_447 VPWR VGND sg13g2_decap_4
X_22851_ _22851_/Q clkload21/A _22851_/D fanout2874/X VPWR VGND sg13g2_dfrbpq_1
XFILLER_83_255 VPWR VGND sg13g2_decap_8
XFILLER_83_266 VPWR VGND sg13g2_decap_8
XFILLER_25_801 VPWR VGND sg13g2_decap_8
XFILLER_37_661 VPWR VGND sg13g2_decap_8
X_21802_ _21802_/Y _21802_/A _21802_/B VPWR VGND sg13g2_nand2_1
XFILLER_77_1534 VPWR VGND sg13g2_fill_1
X_22782_ _22782_/Q clkload25/A _22782_/D fanout2900/X VPWR VGND sg13g2_dfrbpq_1
XFILLER_77_1578 VPWR VGND sg13g2_fill_1
X_21733_ _23872_/D _22282_/A1 _21738_/B _21732_/Y VPWR VGND sg13g2_o21ai_1
XFILLER_51_130 VPWR VGND sg13g2_fill_1
XFILLER_0_1885 VPWR VGND sg13g2_decap_4
XFILLER_24_355 VPWR VGND sg13g2_fill_1
XFILLER_55_1832 VPWR VGND sg13g2_decap_4
XFILLER_101_56 VPWR VGND sg13g2_decap_8
XFILLER_52_697 VPWR VGND sg13g2_decap_8
X_21664_ _21664_/Y _23845_/Q _21674_/B VPWR VGND sg13g2_nand2_1
XFILLER_75_1291 VPWR VGND sg13g2_fill_1
XFILLER_107_1944 VPWR VGND sg13g2_decap_8
XFILLER_40_859 VPWR VGND sg13g2_decap_4
XFILLER_51_196 VPWR VGND sg13g2_decap_8
XFILLER_61_38 VPWR VGND sg13g2_fill_1
X_23403_ _23403_/Q _24214_/CLK _23403_/D fanout2626/X VPWR VGND sg13g2_dfrbpq_1
XFILLER_71_1144 VPWR VGND sg13g2_fill_1
X_20615_ _23361_/D _22416_/A1 _20616_/B _20614_/Y VPWR VGND sg13g2_o21ai_1
XFILLER_32_1106 VPWR VGND sg13g2_fill_2
XFILLER_16_1849 VPWR VGND sg13g2_decap_8
X_21595_ _23812_/D _21956_/A1 _21605_/B _21594_/Y VPWR VGND sg13g2_o21ai_1
XFILLER_103_1819 VPWR VGND sg13g2_decap_8
XFILLER_14_1540 VPWR VGND sg13g2_decap_4
X_23334_ _23334_/Q clkload33/A _23334_/D fanout2694/X VPWR VGND sg13g2_dfrbpq_1
Xrebuffer5540 rebuffer5540/X rebuffer5541/X VPWR VGND sg13g2_buf_1
XFILLER_20_572 VPWR VGND sg13g2_decap_4
Xrebuffer5551 rebuffer5551/X rebuffer5552/X VPWR VGND sg13g2_buf_1
X_20546_ _20546_/Y _23329_/Q _20548_/B VPWR VGND sg13g2_nand2_1
Xrebuffer5562 _12551_/C _11217_/Y VPWR VGND sg13g2_buf_2
XFILLER_105_1690 VPWR VGND sg13g2_decap_8
XFILLER_4_705 VPWR VGND sg13g2_fill_2
Xplace3860 _13923_/A2 _13181_/B VPWR VGND sg13g2_buf_1
Xplace3871 _15981_/S _16025_/A VPWR VGND sg13g2_buf_1
X_23265_ _23265_/Q _23682_/CLK _23265_/D fanout2722/X VPWR VGND sg13g2_dfrbpq_1
X_20477_ _23299_/D _20685_/A1 _20500_/B _20476_/Y VPWR VGND sg13g2_o21ai_1
Xplace3882 _19303_/S _19299_/S VPWR VGND sg13g2_buf_1
XFILLER_106_622 VPWR VGND sg13g2_decap_8
XFILLER_101_1554 VPWR VGND sg13g2_fill_1
Xplace3893 _18253_/B _18351_/B VPWR VGND sg13g2_buf_1
XFILLER_3_226 VPWR VGND sg13g2_decap_8
X_22216_ _24096_/D _22282_/A1 _22219_/B _22215_/Y VPWR VGND sg13g2_o21ai_1
XFILLER_69_1062 VPWR VGND sg13g2_fill_2
XFILLER_3_237 VPWR VGND sg13g2_fill_1
X_23196_ _23196_/Q _23215_/CLK _23196_/D fanout2927/X VPWR VGND sg13g2_dfrbpq_1
XFILLER_106_666 VPWR VGND sg13g2_decap_8
XFILLER_79_506 VPWR VGND sg13g2_fill_1
XFILLER_105_154 VPWR VGND sg13g2_decap_8
X_22147_ _22147_/Y _22147_/A _22151_/B VPWR VGND sg13g2_nand2_1
XFILLER_0_933 VPWR VGND sg13g2_fill_1
XFILLER_43_1202 VPWR VGND sg13g2_decap_8
XFILLER_82_1262 VPWR VGND sg13g2_fill_2
XFILLER_47_1393 VPWR VGND sg13g2_decap_4
X_22078_ _22078_/Y _22078_/A _22084_/B VPWR VGND sg13g2_nand2_1
XFILLER_86_57 VPWR VGND sg13g2_decap_8
XFILLER_102_861 VPWR VGND sg13g2_fill_1
XFILLER_86_68 VPWR VGND sg13g2_decap_8
XFILLER_114_1937 VPWR VGND sg13g2_decap_8
XFILLER_47_403 VPWR VGND sg13g2_decap_4
X_13920_ _13920_/X _13916_/X _13917_/X _13918_/X _13919_/X _13615_/S _11774_/A VPWR
+ VGND sg13g2_mux4_1
XFILLER_19_105 VPWR VGND sg13g2_decap_8
X_21029_ _21029_/Y _23551_/Q _21029_/B VPWR VGND sg13g2_nand2_1
XFILLER_59_274 VPWR VGND sg13g2_decap_8
XFILLER_19_116 VPWR VGND sg13g2_fill_1
XFILLER_47_436 VPWR VGND sg13g2_decap_8
XFILLER_60_1560 VPWR VGND sg13g2_decap_8
XFILLER_19_84 VPWR VGND sg13g2_decap_8
XFILLER_5_1763 VPWR VGND sg13g2_decap_8
X_13851_ _13880_/A _13931_/A _13931_/B VPWR VGND sg13g2_xnor2_1
XFILLER_90_726 VPWR VGND sg13g2_decap_8
X_12802_ _12802_/Y _23396_/Q _12802_/B VPWR VGND sg13g2_nand2b_1
X_16570_ _16571_/B _22628_/Q _16575_/C VPWR VGND sg13g2_nand2_1
X_13782_ _20304_/C _13864_/A VPWR VGND sg13g2_inv_1
XFILLER_62_439 VPWR VGND sg13g2_decap_4
XFILLER_15_322 VPWR VGND sg13g2_fill_1
XFILLER_76_1044 VPWR VGND sg13g2_decap_8
X_15521_ _16871_/C _16785_/C _15625_/B VPWR VGND sg13g2_nand2_1
X_12733_ _12733_/X _23555_/Q _24003_/Q _12733_/S VPWR VGND sg13g2_mux2_1
Xinput4450 _15920_/A1 irqs_i[11] VPWR VGND sg13g2_buf_1
XFILLER_70_461 VPWR VGND sg13g2_decap_8
X_15452_ _16790_/A _15452_/A _15452_/B _15452_/C VPWR VGND sg13g2_nand3_1
X_18240_ _18240_/Y _18240_/A VPWR VGND sg13g2_inv_1
XFILLER_54_1320 VPWR VGND sg13g2_decap_8
Xinput4461 _15826_/B2 irqs_i[7] VPWR VGND sg13g2_buf_1
X_12664_ _12664_/Y _12640_/Y _12641_/Y _13989_/A1 _12663_/Y VPWR VGND sg13g2_a22oi_1
XFILLER_34_1916 VPWR VGND sg13g2_fill_2
X_14403_ _17044_/A _14399_/B _16036_/A _14402_/Y VPWR VGND sg13g2_a21o_1
XFILLER_54_1353 VPWR VGND sg13g2_decap_8
X_11615_ _19487_/A _11602_/Y _11607_/Y _11611_/Y _11612_/X _11614_/Y VPWR VGND sg13g2_a221oi_1
XFILLER_15_1326 VPWR VGND sg13g2_decap_4
X_18171_ _18476_/B _18363_/A _18479_/D VPWR VGND sg13g2_nand2_1
X_15383_ _15383_/Y _16029_/B _16056_/A VPWR VGND sg13g2_nor2_1
X_12595_ _12595_/Y _24129_/Q _12813_/S VPWR VGND sg13g2_nand2b_1
XFILLER_11_550 VPWR VGND sg13g2_decap_8
XFILLER_54_1397 VPWR VGND sg13g2_fill_1
X_17122_ _17123_/B _17122_/A _17122_/B _17177_/A VPWR VGND sg13g2_nor3_1
X_14334_ _14372_/C _15140_/A _15140_/B _15140_/C VPWR VGND sg13g2_nor3_1
XFILLER_15_1359 VPWR VGND sg13g2_fill_2
X_11546_ _11546_/X _23893_/Q _23989_/Q _11737_/S VPWR VGND sg13g2_mux2_1
XFILLER_7_554 VPWR VGND sg13g2_decap_8
XFILLER_13_1050 VPWR VGND sg13g2_decap_4
X_11477_ _11477_/X _11477_/A _11699_/S VPWR VGND sg13g2_and2_1
XFILLER_109_482 VPWR VGND sg13g2_decap_8
X_16004_ _16008_/A _22781_/Q _15940_/B _16004_/B1 _22836_/Q _16003_/Y VPWR VGND sg13g2_a221oi_1
X_13216_ _13216_/Y _13216_/A _13216_/B _13216_/C _13216_/D VPWR VGND sg13g2_nor4_1
X_14196_ _14782_/B _17532_/A _14196_/B _14274_/A VPWR VGND sg13g2_nand3_1
XFILLER_83_1015 VPWR VGND sg13g2_decap_4
XFILLER_100_1086 VPWR VGND sg13g2_fill_1
XFILLER_112_614 VPWR VGND sg13g2_decap_8
XFILLER_100_1097 VPWR VGND sg13g2_fill_2
X_13147_ _13147_/Y _13383_/A _14659_/A _14659_/B VPWR VGND sg13g2_nand3_1
XFILLER_98_859 VPWR VGND sg13g2_fill_1
XFILLER_26_1433 VPWR VGND sg13g2_decap_8
X_13078_ _14046_/A _13078_/A _13078_/B VPWR VGND sg13g2_nor2_1
XFILLER_78_550 VPWR VGND sg13g2_decap_8
XFILLER_113_1403 VPWR VGND sg13g2_fill_1
XFILLER_111_168 VPWR VGND sg13g2_decap_8
XFILLER_6_1527 VPWR VGND sg13g2_fill_2
X_12029_ _12030_/B _23707_/Q _23771_/Q _23835_/Q _23931_/Q _11960_/S _12146_/S VPWR
+ VGND sg13g2_mux4_1
X_16906_ _22691_/D _16895_/S _16904_/Y _16905_/Y VPWR VGND sg13g2_o21ai_1
XFILLER_113_1425 VPWR VGND sg13g2_fill_2
X_17886_ _22926_/D _17886_/A VPWR VGND sg13g2_inv_1
XFILLER_61_1368 VPWR VGND sg13g2_decap_4
XFILLER_65_211 VPWR VGND sg13g2_decap_8
XFILLER_65_222 VPWR VGND sg13g2_decap_4
X_19625_ _19625_/Y _20255_/A2 _19514_/Y _19621_/Y _20154_/S1 VPWR VGND sg13g2_a22oi_1
XFILLER_96_1409 VPWR VGND sg13g2_decap_8
X_16837_ _16838_/B _22679_/Q _16844_/D VPWR VGND sg13g2_nand2_1
XFILLER_93_575 VPWR VGND sg13g2_decap_8
XFILLER_54_929 VPWR VGND sg13g2_decap_8
XFILLER_81_726 VPWR VGND sg13g2_fill_2
XFILLER_4_1273 VPWR VGND sg13g2_decap_4
X_19556_ _19934_/B _19760_/A _19794_/B _19555_/Y VPWR VGND sg13g2_o21ai_1
XFILLER_47_992 VPWR VGND sg13g2_decap_8
X_16768_ _16768_/Y _16818_/A _16768_/B VPWR VGND sg13g2_nor2_1
XFILLER_98_1291 VPWR VGND sg13g2_fill_1
XFILLER_39_1816 VPWR VGND sg13g2_decap_8
XFILLER_18_182 VPWR VGND sg13g2_decap_8
XFILLER_80_247 VPWR VGND sg13g2_fill_2
X_18507_ _22990_/D _18506_/Y _22990_/Q _18535_/B VPWR VGND sg13g2_mux2_1
X_15719_ _18690_/A _23016_/Q VPWR VGND sg13g2_inv_1
XFILLER_34_653 VPWR VGND sg13g2_decap_4
XFILLER_39_1849 VPWR VGND sg13g2_fill_2
X_19487_ _19835_/B _19487_/A _19721_/A VPWR VGND sg13g2_nand2_1
XFILLER_21_303 VPWR VGND sg13g2_decap_8
XFILLER_62_995 VPWR VGND sg13g2_decap_4
X_18438_ _18438_/Y _18301_/A _18423_/Y _18461_/A VPWR VGND sg13g2_a21oi_1
XFILLER_21_336 VPWR VGND sg13g2_decap_8
XFILLER_33_1404 VPWR VGND sg13g2_decap_8
XFILLER_37_1584 VPWR VGND sg13g2_fill_1
X_18369_ _22981_/D _14129_/D _18432_/B _18368_/Y VPWR VGND sg13g2_a21oi_1
Xplace3101 _21374_/B _21363_/B VPWR VGND sg13g2_buf_1
X_20400_ _20400_/Y _23264_/Q _20404_/B VPWR VGND sg13g2_nand2_1
Xplace3112 _21353_/B _21332_/B VPWR VGND sg13g2_buf_1
Xplace3123 _21013_/B _21019_/B VPWR VGND sg13g2_buf_1
X_21380_ _21380_/Y _21380_/A _21380_/B VPWR VGND sg13g2_nand2_1
Xplace3134 _20990_/B _20921_/Y VPWR VGND sg13g2_buf_1
XFILLER_15_1871 VPWR VGND sg13g2_decap_8
XFILLER_50_1751 VPWR VGND sg13g2_fill_1
Xplace3145 _20896_/B _20903_/B VPWR VGND sg13g2_buf_1
Xplace3156 _20772_/B _20778_/B VPWR VGND sg13g2_buf_1
Xplace3167 _20712_/S _20706_/S VPWR VGND sg13g2_buf_1
XFILLER_11_1724 VPWR VGND sg13g2_decap_8
XFILLER_11_1735 VPWR VGND sg13g2_fill_1
XFILLER_50_1784 VPWR VGND sg13g2_fill_1
Xplace3178 _20533_/B _20578_/B VPWR VGND sg13g2_buf_1
XFILLER_102_1863 VPWR VGND sg13g2_decap_8
XFILLER_31_1172 VPWR VGND sg13g2_fill_1
Xplace3189 _20482_/B _20500_/B VPWR VGND sg13g2_buf_1
XFILLER_85_1814 VPWR VGND sg13g2_fill_1
X_23050_ _23050_/Q clkload12/A _23050_/D fanout2909/X VPWR VGND sg13g2_dfrbpq_1
X_20262_ _20265_/C _13657_/C _20319_/B _19597_/X _20261_/Y VPWR VGND sg13g2_a22oi_1
XFILLER_89_804 VPWR VGND sg13g2_fill_2
XFILLER_1_708 VPWR VGND sg13g2_fill_2
X_22001_ _22001_/Y _22001_/A _22001_/B VPWR VGND sg13g2_nand2_1
XFILLER_115_474 VPWR VGND sg13g2_decap_8
XFILLER_89_837 VPWR VGND sg13g2_fill_1
X_20193_ _20193_/Y _20229_/A _20193_/B VPWR VGND sg13g2_nor2_1
XFILLER_103_625 VPWR VGND sg13g2_decap_8
XFILLER_89_848 VPWR VGND sg13g2_decap_8
XFILLER_0_229 VPWR VGND sg13g2_decap_8
XFILLER_97_881 VPWR VGND sg13g2_decap_8
XFILLER_9_1184 VPWR VGND sg13g2_decap_8
X_23952_ _23952_/Q _24210_/CLK _23952_/D fanout2636/X VPWR VGND sg13g2_dfrbpq_1
XFILLER_56_16 VPWR VGND sg13g2_fill_1
XFILLER_96_380 VPWR VGND sg13g2_fill_2
XFILLER_99_1033 VPWR VGND sg13g2_fill_2
XFILLER_5_1048 VPWR VGND sg13g2_decap_8
XFILLER_22_1820 VPWR VGND sg13g2_fill_2
X_22903_ _22903_/Q clkload8/A _22903_/D fanout2800/X VPWR VGND sg13g2_dfrbpq_1
XFILLER_79_1629 VPWR VGND sg13g2_fill_2
XFILLER_45_918 VPWR VGND sg13g2_decap_4
X_23883_ _23883_/Q clkload49/A _23883_/D fanout2642/X VPWR VGND sg13g2_dfrbpq_1
XFILLER_99_1066 VPWR VGND sg13g2_fill_2
XFILLER_2_1925 VPWR VGND sg13g2_decap_8
XFILLER_45_929 VPWR VGND sg13g2_fill_2
XFILLER_22_1864 VPWR VGND sg13g2_decap_8
XFILLER_96_1932 VPWR VGND sg13g2_decap_8
XFILLER_77_1320 VPWR VGND sg13g2_decap_8
X_22834_ _22834_/Q _22869_/CLK _22834_/D fanout2797/X VPWR VGND sg13g2_dfrbpq_1
XFILLER_56_288 VPWR VGND sg13g2_fill_1
XFILLER_71_214 VPWR VGND sg13g2_decap_4
XFILLER_77_1331 VPWR VGND sg13g2_fill_1
XFILLER_57_1905 VPWR VGND sg13g2_fill_1
XFILLER_57_1916 VPWR VGND sg13g2_decap_8
XFILLER_77_1353 VPWR VGND sg13g2_decap_4
XFILLER_112_77 VPWR VGND sg13g2_decap_8
XFILLER_92_1818 VPWR VGND sg13g2_decap_4
XFILLER_53_962 VPWR VGND sg13g2_decap_8
X_22765_ _22765_/Q _22893_/CLK _22765_/D fanout2819/X VPWR VGND sg13g2_dfrbpq_1
XFILLER_52_450 VPWR VGND sg13g2_decap_4
XFILLER_25_686 VPWR VGND sg13g2_decap_8
X_21716_ _21716_/Y _21716_/A _21716_/B VPWR VGND sg13g2_nand2_1
XFILLER_13_837 VPWR VGND sg13g2_fill_2
XFILLER_0_1693 VPWR VGND sg13g2_decap_4
XFILLER_24_163 VPWR VGND sg13g2_fill_1
XFILLER_12_314 VPWR VGND sg13g2_decap_8
X_22696_ _22696_/Q _22733_/CLK _22696_/D fanout2881/X VPWR VGND sg13g2_dfrbpq_1
XFILLER_9_808 VPWR VGND sg13g2_decap_8
XFILLER_55_1673 VPWR VGND sg13g2_decap_8
X_21647_ _23837_/D _21941_/A1 _21648_/B _21646_/Y VPWR VGND sg13g2_o21ai_1
XFILLER_36_1061 VPWR VGND sg13g2_fill_1
XFILLER_16_1646 VPWR VGND sg13g2_fill_1
XFILLER_12_369 VPWR VGND sg13g2_fill_1
XFILLER_16_1668 VPWR VGND sg13g2_decap_8
XFILLER_21_881 VPWR VGND sg13g2_decap_8
X_12380_ _12381_/B _23583_/Q _23615_/Q _23647_/Q _23679_/Q _12978_/S0 _12474_/S VPWR
+ VGND sg13g2_mux4_1
XFILLER_20_391 VPWR VGND sg13g2_fill_1
X_23317_ _23317_/Q clkload48/A _23317_/D fanout2754/X VPWR VGND sg13g2_dfrbpq_1
X_11331_ _11331_/Y _13123_/A _13179_/B VPWR VGND sg13g2_nand2_1
Xrebuffer5370 _12525_/B _12521_/Y VPWR VGND sg13g2_buf_2
Xrebuffer5381 _12866_/A1 _12529_/Y VPWR VGND sg13g2_buf_1
X_20529_ _20529_/Y _20529_/A _20539_/B VPWR VGND sg13g2_nand2_1
Xplace3690 _12829_/B _12464_/Y VPWR VGND sg13g2_buf_1
X_14050_ _14051_/D _14871_/A _14871_/B _12355_/A _12355_/B VPWR VGND sg13g2_a22oi_1
XFILLER_4_546 VPWR VGND sg13g2_decap_8
X_23248_ _23248_/Q _24214_/CLK _23248_/D fanout2627/X VPWR VGND sg13g2_dfrbpq_1
XFILLER_21_96 VPWR VGND sg13g2_fill_1
XFILLER_49_1433 VPWR VGND sg13g2_decap_8
XFILLER_106_452 VPWR VGND sg13g2_fill_1
X_13001_ _13001_/X _24166_/Q _24198_/Q _23238_/Q _23270_/Q _13001_/S0 _12709_/A VPWR
+ VGND sg13g2_mux4_1
XFILLER_10_1278 VPWR VGND sg13g2_decap_8
Xhold5060 _20888_/A _23490_/Q VPWR VGND sg13g2_dlygate4sd3_1
XFILLER_84_1346 VPWR VGND sg13g2_decap_8
Xhold5071 _20952_/A _23521_/Q VPWR VGND sg13g2_dlygate4sd3_1
Xhold5082 _21528_/A _23780_/Q VPWR VGND sg13g2_dlygate4sd3_1
Xhold5093 _21572_/A _23802_/Q VPWR VGND sg13g2_dlygate4sd3_1
XFILLER_97_56 VPWR VGND sg13g2_decap_8
X_23179_ _23179_/Q clkload17/A _23179_/D fanout2847/X VPWR VGND sg13g2_dfrbpq_1
X_11193_ _11569_/A _11595_/A VPWR VGND sg13g2_inv_2
XFILLER_106_496 VPWR VGND sg13g2_decap_8
XFILLER_82_1070 VPWR VGND sg13g2_decap_8
X_17740_ _17740_/Y _22568_/Q _17754_/C VPWR VGND sg13g2_xnor2_1
X_14952_ _16269_/A _16278_/A _16278_/B VPWR VGND sg13g2_or2_1
XFILLER_23_1628 VPWR VGND sg13g2_fill_2
XFILLER_43_1054 VPWR VGND sg13g2_decap_8
XFILLER_47_200 VPWR VGND sg13g2_decap_8
XFILLER_102_680 VPWR VGND sg13g2_decap_8
XFILLER_7_1869 VPWR VGND sg13g2_decap_8
XFILLER_23_1639 VPWR VGND sg13g2_decap_8
XFILLER_48_756 VPWR VGND sg13g2_decap_8
X_13903_ _13903_/Y _13896_/Y _13966_/B _13902_/Y VPWR VGND sg13g2_o21ai_1
XFILLER_36_918 VPWR VGND sg13g2_fill_1
X_17671_ _17671_/Y _22890_/Q _17702_/B VPWR VGND sg13g2_nor2_1
XFILLER_21_1330 VPWR VGND sg13g2_fill_1
XFILLER_47_255 VPWR VGND sg13g2_decap_8
X_14883_ _14883_/Y _22459_/Q _14883_/B _17932_/B VPWR VGND sg13g2_nor3_1
XFILLER_90_501 VPWR VGND sg13g2_decap_8
XFILLER_78_1117 VPWR VGND sg13g2_decap_8
XFILLER_47_266 VPWR VGND sg13g2_fill_1
X_19410_ _19410_/Y _19410_/A VPWR VGND sg13g2_inv_1
X_16622_ _22639_/D _16142_/A _16626_/A _16621_/Y VPWR VGND sg13g2_a21oi_1
X_13834_ _13835_/A _23922_/Q _14147_/C _13833_/X _13840_/S0 VPWR VGND sg13g2_a22oi_1
XFILLER_35_439 VPWR VGND sg13g2_fill_1
XFILLER_90_556 VPWR VGND sg13g2_decap_8
X_13765_ _13765_/X _23441_/Q _23473_/Q _23505_/Q _23537_/Q _13773_/S0 _13765_/S1 VPWR
+ VGND sg13g2_mux4_1
X_16553_ _16553_/Y _16561_/A _16553_/B VPWR VGND sg13g2_nor2_1
XFILLER_44_962 VPWR VGND sg13g2_decap_8
XFILLER_90_578 VPWR VGND sg13g2_fill_2
XFILLER_31_612 VPWR VGND sg13g2_fill_2
XFILLER_56_1448 VPWR VGND sg13g2_decap_8
X_15504_ _15506_/A _22886_/Q _15182_/X _16334_/A _22548_/Q VPWR VGND sg13g2_a22oi_1
X_12716_ _12716_/X _12714_/X _12715_/X _13681_/S VPWR VGND sg13g2_mux2_1
XFILLER_16_697 VPWR VGND sg13g2_decap_8
X_19272_ _19272_/Y _19514_/A _19274_/B VPWR VGND sg13g2_nand2_1
X_13696_ _13696_/X _23728_/Q _23760_/Q _23792_/Q _23824_/Q _13701_/S0 _12121_/S VPWR
+ VGND sg13g2_mux4_1
XFILLER_15_196 VPWR VGND sg13g2_fill_2
XFILLER_73_1762 VPWR VGND sg13g2_fill_2
X_18223_ _18224_/C _18238_/A _18223_/B VPWR VGND sg13g2_nor2_1
XFILLER_54_1150 VPWR VGND sg13g2_decap_4
X_15435_ _15435_/Y _15435_/A _15435_/B _15435_/C _15435_/D VPWR VGND sg13g2_nand4_1
X_12647_ _12647_/X _23426_/Q _23458_/Q _23490_/Q _23522_/Q _13006_/S0 _13006_/S1 VPWR
+ VGND sg13g2_mux4_1
XFILLER_73_1773 VPWR VGND sg13g2_decap_8
XFILLER_15_1112 VPWR VGND sg13g2_decap_8
XFILLER_54_1172 VPWR VGND sg13g2_decap_4
XFILLER_50_1014 VPWR VGND sg13g2_fill_2
X_18154_ _22964_/D _22964_/Q _18221_/S _18153_/Y VPWR VGND sg13g2_a21o_1
XFILLER_102_1104 VPWR VGND sg13g2_decap_4
XFILLER_50_1047 VPWR VGND sg13g2_fill_1
XFILLER_69_1809 VPWR VGND sg13g2_fill_2
X_17105_ _17106_/B _17122_/B _17110_/B _17110_/C VPWR VGND sg13g2_nor3_1
X_14317_ _14317_/Y _16779_/A _16776_/B _14308_/Y _14312_/Y _14316_/Y VPWR VGND sg13g2_a221oi_1
X_11529_ _14034_/B _11500_/X _11501_/X _11528_/Y VPWR VGND sg13g2_a21oi_2
X_18085_ _18592_/A _24226_/Q VPWR VGND sg13g2_inv_1
XFILLER_8_896 VPWR VGND sg13g2_decap_8
XFILLER_32_1492 VPWR VGND sg13g2_decap_8
X_17036_ _17036_/Y _22716_/Q _17222_/C VPWR VGND sg13g2_nand2_1
X_14248_ _14400_/C _24222_/Q _24220_/Q _24217_/Q VPWR VGND sg13g2_or3_1
XFILLER_113_923 VPWR VGND sg13g2_fill_2
X_14179_ _14782_/C _24237_/Q _14756_/A VPWR VGND sg13g2_nand2b_1
XFILLER_112_422 VPWR VGND sg13g2_decap_4
XFILLER_98_645 VPWR VGND sg13g2_decap_8
XFILLER_97_155 VPWR VGND sg13g2_decap_8
X_18987_ _18988_/B _18986_/Y _23056_/Q _19042_/S VPWR VGND sg13g2_mux2_1
XFILLER_112_488 VPWR VGND sg13g2_decap_8
XFILLER_100_639 VPWR VGND sg13g2_decap_8
XFILLER_26_1263 VPWR VGND sg13g2_decap_8
XFILLER_38_200 VPWR VGND sg13g2_fill_1
XFILLER_39_723 VPWR VGND sg13g2_decap_8
X_17938_ _22943_/D _24241_/D _17938_/B _17938_/C VPWR VGND sg13g2_nand3b_1
XFILLER_85_339 VPWR VGND sg13g2_decap_8
XFILLER_22_1105 VPWR VGND sg13g2_fill_1
XFILLER_26_1274 VPWR VGND sg13g2_decap_8
XFILLER_22_1116 VPWR VGND sg13g2_decap_8
XFILLER_16_0 VPWR VGND sg13g2_decap_4
XFILLER_6_1379 VPWR VGND sg13g2_decap_8
X_17869_ _17869_/Y _17869_/A _17869_/B VPWR VGND sg13g2_nor2_1
X_19608_ _20286_/B _19608_/A _19835_/B VPWR VGND sg13g2_nor2_1
XFILLER_66_586 VPWR VGND sg13g2_fill_1
XFILLER_38_288 VPWR VGND sg13g2_decap_8
X_20880_ _23486_/D _21314_/A1 _20879_/B _20879_/Y VPWR VGND sg13g2_o21ai_1
XFILLER_81_534 VPWR VGND sg13g2_decap_4
XFILLER_38_299 VPWR VGND sg13g2_fill_1
XFILLER_53_225 VPWR VGND sg13g2_decap_4
XFILLER_78_1662 VPWR VGND sg13g2_fill_1
X_19539_ _19824_/B _19757_/A _19636_/B _19538_/Y VPWR VGND sg13g2_o21ai_1
XFILLER_81_567 VPWR VGND sg13g2_fill_2
XFILLER_35_984 VPWR VGND sg13g2_decap_4
XFILLER_50_921 VPWR VGND sg13g2_decap_4
X_22550_ _22550_/Q clkload17/A _22550_/D fanout2846/X VPWR VGND sg13g2_dfrbpq_1
XFILLER_107_1015 VPWR VGND sg13g2_decap_8
X_21501_ _23767_/D _21928_/A1 _21502_/B _21500_/Y VPWR VGND sg13g2_o21ai_1
X_22481_ _22481_/Q clkload9/A _22481_/D fanout2825/X VPWR VGND sg13g2_dfrbpq_1
XFILLER_72_1272 VPWR VGND sg13g2_fill_1
XFILLER_13_1808 VPWR VGND sg13g2_decap_8
X_24220_ _24220_/Q clkload15/A _24220_/D fanout2853/X VPWR VGND sg13g2_dfrbpq_1
X_21432_ _21432_/Y _23735_/Q _21489_/B VPWR VGND sg13g2_nand2_1
XFILLER_104_1936 VPWR VGND sg13g2_decap_8
XFILLER_33_1267 VPWR VGND sg13g2_decap_8
X_24151_ _24151_/Q clkload56/A _24151_/D fanout2747/X VPWR VGND sg13g2_dfrbpq_1
X_21363_ _21363_/Y _21363_/A _21363_/B VPWR VGND sg13g2_nand2_1
XFILLER_11_1532 VPWR VGND sg13g2_fill_1
XFILLER_102_1660 VPWR VGND sg13g2_decap_8
X_23102_ _23102_/Q _23114_/CLK _23102_/D fanout2903/X VPWR VGND sg13g2_dfrbpq_1
X_24082_ _24082_/Q clkload16/A _24082_/D fanout2623/X VPWR VGND sg13g2_dfrbpq_1
X_21294_ _21294_/Y _21294_/A _21349_/S VPWR VGND sg13g2_nand2_1
XFILLER_66_1010 VPWR VGND sg13g2_fill_1
X_23033_ _23033_/Q clkload13/A _23033_/D fanout2908/X VPWR VGND sg13g2_dfrbpq_1
XFILLER_85_1666 VPWR VGND sg13g2_fill_2
X_20245_ _20247_/C _20245_/A _20245_/B _20304_/B VPWR VGND sg13g2_nand3_1
XFILLER_88_122 VPWR VGND sg13g2_fill_1
XFILLER_104_967 VPWR VGND sg13g2_decap_8
XFILLER_89_656 VPWR VGND sg13g2_fill_2
XFILLER_107_77 VPWR VGND sg13g2_decap_8
XFILLER_103_455 VPWR VGND sg13g2_decap_8
XFILLER_88_155 VPWR VGND sg13g2_decap_8
XFILLER_66_1098 VPWR VGND sg13g2_decap_4
X_20176_ _23240_/D _21964_/A0 _23240_/Q _20283_/S VPWR VGND sg13g2_mux2_1
XFILLER_103_477 VPWR VGND sg13g2_decap_4
XFILLER_88_166 VPWR VGND sg13g2_fill_2
XFILLER_83_1390 VPWR VGND sg13g2_decap_4
XFILLER_24_1926 VPWR VGND sg13g2_decap_8
XFILLER_103_499 VPWR VGND sg13g2_decap_8
X_23935_ _23935_/Q clkload43/A _23935_/D fanout2738/X VPWR VGND sg13g2_dfrbpq_1
XFILLER_2_1722 VPWR VGND sg13g2_decap_8
XFILLER_72_512 VPWR VGND sg13g2_decap_8
X_23866_ _23866_/Q clkload58/A _23866_/D fanout2760/X VPWR VGND sg13g2_dfrbpq_1
X_11880_ _11887_/A _14038_/A _14038_/B _11879_/Y VPWR VGND sg13g2_o21ai_1
XFILLER_22_1694 VPWR VGND sg13g2_fill_1
X_22817_ _22817_/Q clkload28/A _22817_/D fanout2828/X VPWR VGND sg13g2_dfrbpq_1
XFILLER_60_707 VPWR VGND sg13g2_decap_8
X_23797_ _23797_/Q clkload52/A _23797_/D fanout2757/X VPWR VGND sg13g2_dfrbpq_1
XFILLER_2_1799 VPWR VGND sg13g2_decap_8
XFILLER_38_1112 VPWR VGND sg13g2_fill_1
XFILLER_77_1172 VPWR VGND sg13g2_decap_4
XFILLER_13_601 VPWR VGND sg13g2_decap_8
XFILLER_25_472 VPWR VGND sg13g2_fill_1
X_13550_ _13550_/X _23726_/Q _23758_/Q _23790_/Q _23822_/Q _13551_/S0 _13398_/S VPWR
+ VGND sg13g2_mux4_1
X_22748_ _22748_/Q clkload27/A _22748_/D fanout2894/X VPWR VGND sg13g2_dfrbpq_1
XFILLER_41_954 VPWR VGND sg13g2_fill_1
XFILLER_52_291 VPWR VGND sg13g2_decap_8
XFILLER_109_1869 VPWR VGND sg13g2_decap_8
X_12501_ _12504_/C _12772_/B _12501_/B VPWR VGND sg13g2_nor2_1
XFILLER_16_1410 VPWR VGND sg13g2_decap_8
X_13481_ _13494_/B _12445_/A _13478_/X _13480_/X VPWR VGND sg13g2_o21ai_1
XFILLER_51_1301 VPWR VGND sg13g2_fill_1
X_22679_ _22679_/Q clkload21/A _22679_/D fanout2866/X VPWR VGND sg13g2_dfrbpq_1
XFILLER_16_1432 VPWR VGND sg13g2_decap_4
XFILLER_9_638 VPWR VGND sg13g2_decap_4
XFILLER_41_998 VPWR VGND sg13g2_decap_8
XFILLER_107_1571 VPWR VGND sg13g2_fill_2
XFILLER_90_1383 VPWR VGND sg13g2_decap_8
X_12432_ _12432_/Y _12435_/A _12435_/B VPWR VGND sg13g2_nor2_1
XFILLER_90_1394 VPWR VGND sg13g2_fill_2
XFILLER_32_51 VPWR VGND sg13g2_decap_4
XFILLER_51_1345 VPWR VGND sg13g2_decap_8
XFILLER_12_199 VPWR VGND sg13g2_fill_2
XFILLER_51_1356 VPWR VGND sg13g2_fill_2
XFILLER_32_73 VPWR VGND sg13g2_decap_8
X_15151_ _15270_/A _15312_/A _15309_/A VPWR VGND sg13g2_nor2_1
XFILLER_16_1498 VPWR VGND sg13g2_fill_1
X_12363_ _12370_/A _12774_/B _12363_/B VPWR VGND sg13g2_nor2_1
X_14102_ _14431_/A _19360_/A _14428_/A _14102_/C _14102_/D VPWR VGND sg13g2_nand4_1
X_11314_ _11314_/X _11314_/A _11314_/B VPWR VGND sg13g2_or2_1
X_15082_ _15082_/Y _15082_/A _23151_/Q VPWR VGND sg13g2_nor2_1
XFILLER_5_866 VPWR VGND sg13g2_decap_8
X_12294_ _12294_/Y _13674_/A _12293_/Y _12294_/B1 VPWR VGND sg13g2_o21ai_1
X_18910_ _18911_/B _18909_/Y _23049_/Q _18957_/C VPWR VGND sg13g2_mux2_1
X_11245_ _11245_/X _17706_/A _11245_/B _13968_/B VPWR VGND sg13g2_and3_1
XFILLER_68_1875 VPWR VGND sg13g2_decap_4
X_19890_ _19890_/Y _19888_/Y _19889_/Y _19946_/C1 VPWR VGND sg13g2_a21oi_1
XFILLER_4_387 VPWR VGND sg13g2_decap_4
XFILLER_10_1097 VPWR VGND sg13g2_decap_8
XFILLER_84_1165 VPWR VGND sg13g2_decap_8
X_18841_ _18841_/Y _18016_/S _23041_/Q _18856_/B _19128_/A1 VPWR VGND sg13g2_a22oi_1
X_11176_ _24235_/D _23189_/Q _19306_/B _14459_/A VPWR VGND sg13g2_nor3_1
XFILLER_68_818 VPWR VGND sg13g2_decap_8
XFILLER_68_829 VPWR VGND sg13g2_fill_2
XFILLER_95_637 VPWR VGND sg13g2_decap_8
X_18772_ _18793_/B _18587_/C _18771_/Y _18884_/B VPWR VGND sg13g2_a21oi_1
X_15984_ _15995_/A _15984_/A _15984_/B VPWR VGND sg13g2_or2_1
XFILLER_7_1655 VPWR VGND sg13g2_fill_1
XFILLER_76_851 VPWR VGND sg13g2_decap_8
X_17723_ _17724_/B _22565_/Q _17732_/C VPWR VGND sg13g2_nand2_1
XFILLER_57_70 VPWR VGND sg13g2_decap_4
X_14935_ _14935_/Y _14935_/A _14935_/B _14956_/C VPWR VGND sg13g2_nand3_1
XFILLER_36_726 VPWR VGND sg13g2_decap_4
XFILLER_110_1439 VPWR VGND sg13g2_decap_8
XFILLER_75_372 VPWR VGND sg13g2_fill_2
X_17654_ _17663_/B _22558_/Q _22557_/Q _22556_/Q _17654_/D VPWR VGND sg13g2_and4_1
X_14866_ _14866_/Y _14866_/A _14866_/B VPWR VGND sg13g2_nand2_1
XFILLER_75_394 VPWR VGND sg13g2_fill_1
XFILLER_17_940 VPWR VGND sg13g2_fill_1
XFILLER_40_1794 VPWR VGND sg13g2_decap_8
X_16605_ _16606_/B _22636_/Q _16605_/B VPWR VGND sg13g2_xnor2_1
X_13817_ _13817_/X _23250_/Q _23282_/Q _23378_/Q _23410_/Q _13978_/S0 _13978_/S1 VPWR
+ VGND sg13g2_mux4_1
XFILLER_16_450 VPWR VGND sg13g2_decap_8
X_17585_ _17586_/B _22552_/Q _17593_/B VPWR VGND sg13g2_xnor2_1
X_14797_ _14797_/Y _18598_/A _14797_/B VPWR VGND sg13g2_nand2_1
XFILLER_36_1808 VPWR VGND sg13g2_decap_8
X_16536_ _16537_/B _22621_/Q _22620_/Q _16559_/C VPWR VGND sg13g2_nand3_1
XFILLER_32_943 VPWR VGND sg13g2_decap_8
X_13748_ _13755_/B _13748_/A _13748_/B _13748_/C _13748_/D VPWR VGND sg13g2_nand4_1
XFILLER_32_954 VPWR VGND sg13g2_fill_1
X_19255_ _23191_/D _19261_/C _19255_/B VPWR VGND sg13g2_and2_1
XFILLER_32_976 VPWR VGND sg13g2_decap_8
XFILLER_31_475 VPWR VGND sg13g2_fill_2
XFILLER_34_1532 VPWR VGND sg13g2_decap_8
X_13679_ _13679_/X _23856_/Q _23888_/Q _23952_/Q _23984_/Q _13910_/S _13983_/S1 VPWR
+ VGND sg13g2_mux4_1
XFILLER_73_1581 VPWR VGND sg13g2_decap_8
XFILLER_108_1379 VPWR VGND sg13g2_decap_4
X_18206_ _18224_/B _18259_/B _18377_/A VPWR VGND sg13g2_nand2b_1
X_15418_ _22455_/D _15497_/S _15415_/X _15417_/Y VPWR VGND sg13g2_a21oi_1
X_19186_ _19186_/Y _19265_/A _19253_/A VPWR VGND sg13g2_nor2_1
X_16398_ _22566_/D _18690_/A _18667_/A _16397_/Y VPWR VGND sg13g2_o21ai_1
XFILLER_30_1407 VPWR VGND sg13g2_fill_1
XFILLER_8_660 VPWR VGND sg13g2_decap_4
X_18137_ _18137_/Y _18137_/A _18524_/B VPWR VGND sg13g2_nand2_1
Xoutput4469 data_addr_o[11] _24256_/X VPWR VGND sg13g2_buf_1
X_15349_ _15349_/Y _15319_/Y _15463_/B VPWR VGND sg13g2_nand2b_1
XFILLER_12_1841 VPWR VGND sg13g2_decap_8
XFILLER_7_170 VPWR VGND sg13g2_decap_8
XFILLER_69_1639 VPWR VGND sg13g2_decap_8
X_17019_ _17020_/B _17019_/A _17023_/B VPWR VGND sg13g2_nor2b_1
XFILLER_82_1817 VPWR VGND sg13g2_decap_8
X_20030_ _20031_/B _19795_/Y _20029_/Y _20030_/S VPWR VGND sg13g2_mux2_1
XFILLER_113_764 VPWR VGND sg13g2_decap_8
XFILLER_101_915 VPWR VGND sg13g2_decap_8
XFILLER_112_252 VPWR VGND sg13g2_decap_8
XFILLER_115_1339 VPWR VGND sg13g2_decap_8
XFILLER_58_328 VPWR VGND sg13g2_decap_8
XFILLER_6_1154 VPWR VGND sg13g2_decap_8
XFILLER_26_1082 VPWR VGND sg13g2_fill_1
XFILLER_39_542 VPWR VGND sg13g2_fill_2
XFILLER_100_469 VPWR VGND sg13g2_decap_8
XFILLER_85_158 VPWR VGND sg13g2_decap_8
X_21981_ _23987_/D _22249_/A0 _23987_/Q _21981_/S VPWR VGND sg13g2_mux2_1
XFILLER_27_704 VPWR VGND sg13g2_fill_2
XFILLER_41_1558 VPWR VGND sg13g2_decap_4
XFILLER_113_1074 VPWR VGND sg13g2_fill_2
XFILLER_96_1014 VPWR VGND sg13g2_decap_8
X_23720_ _23720_/Q clkload31/A _23720_/D fanout2653/X VPWR VGND sg13g2_dfrbpq_1
XFILLER_66_372 VPWR VGND sg13g2_decap_8
X_20932_ _20932_/Y _20932_/A _20936_/B VPWR VGND sg13g2_nand2_1
XFILLER_26_214 VPWR VGND sg13g2_decap_8
XFILLER_54_545 VPWR VGND sg13g2_decap_8
XFILLER_93_191 VPWR VGND sg13g2_fill_1
X_23651_ _23651_/Q _24196_/CLK _23651_/D fanout2719/X VPWR VGND sg13g2_dfrbpq_1
X_20863_ _23478_/D _20929_/A1 _20902_/S _20862_/Y VPWR VGND sg13g2_o21ai_1
XFILLER_82_887 VPWR VGND sg13g2_decap_8
XFILLER_26_269 VPWR VGND sg13g2_fill_1
XFILLER_74_1301 VPWR VGND sg13g2_decap_4
XFILLER_78_1481 VPWR VGND sg13g2_fill_2
XFILLER_23_910 VPWR VGND sg13g2_decap_4
X_22602_ _22602_/Q _22893_/CLK _22602_/D fanout2820/X VPWR VGND sg13g2_dfrbpq_1
XFILLER_53_39 VPWR VGND sg13g2_decap_8
X_23582_ _23582_/Q clkload53/A _23582_/D fanout2778/X VPWR VGND sg13g2_dfrbpq_1
XFILLER_23_943 VPWR VGND sg13g2_decap_8
X_20794_ _20794_/Y _23447_/Q _20794_/B VPWR VGND sg13g2_nand2_1
XFILLER_23_954 VPWR VGND sg13g2_fill_1
X_22533_ _22533_/Q clkload6/A _22533_/D fanout2803/X VPWR VGND sg13g2_dfrbpq_1
XFILLER_22_453 VPWR VGND sg13g2_decap_8
XFILLER_17_1730 VPWR VGND sg13g2_decap_8
XFILLER_56_1790 VPWR VGND sg13g2_decap_4
XFILLER_10_615 VPWR VGND sg13g2_fill_1
XFILLER_50_795 VPWR VGND sg13g2_fill_1
X_22464_ _22464_/Q clkload9/A _22464_/D fanout2823/X VPWR VGND sg13g2_dfrbpq_1
XFILLER_104_1733 VPWR VGND sg13g2_decap_8
XFILLER_52_1665 VPWR VGND sg13g2_decap_8
XFILLER_108_503 VPWR VGND sg13g2_decap_8
XFILLER_104_1755 VPWR VGND sg13g2_decap_8
XFILLER_13_1638 VPWR VGND sg13g2_fill_1
X_24203_ _24203_/Q clkload38/A _24203_/D fanout2631/X VPWR VGND sg13g2_dfrbpq_1
X_21415_ _23727_/D _23727_/Q _21975_/A0 _21421_/S VPWR VGND sg13g2_mux2_1
X_22395_ _22395_/Y _22395_/A _22402_/B VPWR VGND sg13g2_nand2_1
X_24134_ _24134_/Q clkload37/A _24134_/D fanout2713/X VPWR VGND sg13g2_dfrbpq_1
X_21346_ _23695_/D _21346_/A0 _23695_/Q _21352_/S VPWR VGND sg13g2_mux2_1
X_24065_ _24065_/Q clkload45/A _24065_/D fanout2733/X VPWR VGND sg13g2_dfrbpq_1
X_21277_ _23661_/D _22440_/A1 _23661_/Q _21286_/S VPWR VGND sg13g2_mux2_1
Xfanout2806 fanout2806/X fanout2809/X VPWR VGND sg13g2_buf_1
Xfanout2817 fanout2817/X fanout2819/X VPWR VGND sg13g2_buf_1
XFILLER_78_58 VPWR VGND sg13g2_fill_2
Xfanout2828 fanout2828/X fanout2830/X VPWR VGND sg13g2_buf_1
X_23016_ _23016_/Q _23029_/CLK _23016_/D fanout2808/X VPWR VGND sg13g2_dfrbpq_1
XFILLER_89_453 VPWR VGND sg13g2_decap_8
XFILLER_85_1496 VPWR VGND sg13g2_fill_2
Xfanout2839 fanout2839/X fanout2849/X VPWR VGND sg13g2_buf_1
X_20228_ _20228_/Y _20228_/A _20229_/B VPWR VGND sg13g2_nor2_1
XFILLER_103_241 VPWR VGND sg13g2_decap_8
XFILLER_89_464 VPWR VGND sg13g2_fill_1
XFILLER_77_604 VPWR VGND sg13g2_fill_1
XFILLER_46_1458 VPWR VGND sg13g2_decap_8
XFILLER_76_114 VPWR VGND sg13g2_decap_8
XFILLER_115_1840 VPWR VGND sg13g2_decap_8
X_20159_ _20159_/Y _20159_/A _20269_/B VPWR VGND sg13g2_nand2_1
XFILLER_76_125 VPWR VGND sg13g2_fill_2
XFILLER_58_840 VPWR VGND sg13g2_fill_1
X_12981_ _12981_/X _23462_/Q _23526_/Q _23622_/Q _23686_/Q _12733_/S _12982_/S1 VPWR
+ VGND sg13g2_mux4_1
XFILLER_76_169 VPWR VGND sg13g2_fill_1
XFILLER_73_821 VPWR VGND sg13g2_decap_4
XFILLER_111_1748 VPWR VGND sg13g2_fill_1
XFILLER_85_692 VPWR VGND sg13g2_decap_8
XFILLER_18_737 VPWR VGND sg13g2_fill_2
X_14720_ _14720_/Y _14720_/A _14720_/B VPWR VGND sg13g2_nor2_1
XFILLER_91_139 VPWR VGND sg13g2_fill_1
XFILLER_79_1245 VPWR VGND sg13g2_fill_1
X_23918_ _23918_/Q _24170_/CLK _23918_/D fanout2638/X VPWR VGND sg13g2_dfrbpq_1
X_11932_ _11932_/Y _22553_/Q _12413_/B _12824_/B1 VPWR VGND sg13g2_o21ai_1
XFILLER_18_759 VPWR VGND sg13g2_decap_8
XFILLER_72_331 VPWR VGND sg13g2_fill_1
XFILLER_72_342 VPWR VGND sg13g2_fill_2
XFILLER_79_1278 VPWR VGND sg13g2_fill_2
X_11863_ _11863_/Y _22552_/Q _11736_/Y _11993_/A _11993_/B _11862_/Y VPWR VGND sg13g2_a221oi_1
X_14651_ _14651_/X _14691_/A _14689_/A _14701_/B VPWR VGND sg13g2_mux2_1
X_23849_ _23849_/Q _24113_/CLK _23849_/D fanout2682/X VPWR VGND sg13g2_dfrbpq_1
XFILLER_92_1401 VPWR VGND sg13g2_fill_2
XFILLER_57_1521 VPWR VGND sg13g2_decap_4
XFILLER_96_1581 VPWR VGND sg13g2_fill_1
XFILLER_60_515 VPWR VGND sg13g2_decap_8
XFILLER_32_228 VPWR VGND sg13g2_decap_8
XFILLER_57_1543 VPWR VGND sg13g2_decap_8
X_13602_ _13742_/A _13602_/A _13733_/B VPWR VGND sg13g2_xor2_1
X_17370_ _22812_/D _16203_/A _17369_/B _17369_/Y VPWR VGND sg13g2_o21ai_1
X_14582_ _24234_/D _14825_/A _18623_/A _14581_/Y VPWR VGND sg13g2_o21ai_1
X_11794_ _11818_/A _11794_/A _11794_/B _11794_/C _11794_/D VPWR VGND sg13g2_nor4_2
XFILLER_25_291 VPWR VGND sg13g2_decap_4
XFILLER_57_1576 VPWR VGND sg13g2_fill_1
XFILLER_14_976 VPWR VGND sg13g2_decap_8
X_16321_ _16322_/C _16321_/A _16321_/B _16321_/C _16321_/D VPWR VGND sg13g2_nor4_2
XFILLER_43_50 VPWR VGND sg13g2_decap_8
X_13533_ _13533_/X _13651_/A _13533_/B VPWR VGND sg13g2_and2_1
X_19040_ _19041_/C _19047_/A _23093_/Q VPWR VGND sg13g2_nand2_1
XFILLER_70_1743 VPWR VGND sg13g2_decap_8
X_13464_ _13464_/X _24045_/Q _24109_/Q _13466_/A VPWR VGND sg13g2_mux2_1
X_16252_ _22521_/D _16262_/A _16263_/B VPWR VGND sg13g2_xnor2_1
XFILLER_9_446 VPWR VGND sg13g2_decap_8
XFILLER_16_1284 VPWR VGND sg13g2_decap_8
X_12415_ _12415_/X _12824_/B1 _12413_/X _12414_/Y VPWR VGND sg13g2_a21o_1
XFILLER_12_1126 VPWR VGND sg13g2_fill_1
XFILLER_31_1749 VPWR VGND sg13g2_fill_2
X_16183_ _16183_/X _22508_/Q _16183_/B VPWR VGND sg13g2_and2_1
X_13395_ _13396_/B _13393_/X _13394_/X _13560_/S VPWR VGND sg13g2_mux2_1
XFILLER_51_1197 VPWR VGND sg13g2_fill_1
X_12346_ _12355_/A _12531_/A _12531_/B _12345_/X VPWR VGND sg13g2_o21ai_1
XFILLER_4_151 VPWR VGND sg13g2_decap_8
X_19942_ _19943_/B _20255_/A1 _20255_/A3 _20255_/A0 _20255_/A2 _20019_/S0 _20072_/S1
+ VPWR VGND sg13g2_mux4_1
XFILLER_99_239 VPWR VGND sg13g2_decap_8
X_12277_ _12278_/B _12277_/A _12277_/B _12277_/C _12277_/D VPWR VGND sg13g2_nand4_1
XFILLER_29_1623 VPWR VGND sg13g2_decap_8
XFILLER_9_1706 VPWR VGND sg13g2_fill_2
XFILLER_49_1060 VPWR VGND sg13g2_decap_8
XFILLER_9_1717 VPWR VGND sg13g2_decap_8
XFILLER_4_195 VPWR VGND sg13g2_fill_1
X_14016_ _14430_/A _14016_/A _14015_/Y VPWR VGND sg13g2_nor2b_1
XFILLER_49_1082 VPWR VGND sg13g2_fill_1
X_19873_ _19873_/Y _20028_/A _19708_/X _19872_/Y VPWR VGND sg13g2_a21oi_1
XFILLER_68_604 VPWR VGND sg13g2_decap_8
X_18824_ _18826_/B _18822_/Y _18823_/Y _18824_/S VPWR VGND sg13g2_mux2_1
XFILLER_110_734 VPWR VGND sg13g2_decap_8
XFILLER_67_147 VPWR VGND sg13g2_fill_1
XFILLER_81_1894 VPWR VGND sg13g2_fill_2
XFILLER_42_1845 VPWR VGND sg13g2_decap_4
X_18755_ _23028_/D _18753_/A _18752_/Y _18754_/Y VPWR VGND sg13g2_a21oi_1
X_15967_ _15976_/B _15967_/A _15967_/B VPWR VGND sg13g2_and2_1
XFILLER_64_821 VPWR VGND sg13g2_decap_8
X_17706_ _17706_/X _17706_/A _17706_/B VPWR VGND sg13g2_and2_1
X_14918_ _14919_/B _22523_/Q _14918_/B VPWR VGND sg13g2_nor2_1
XFILLER_97_1345 VPWR VGND sg13g2_fill_2
X_18686_ _18686_/Y _18689_/A _18685_/Y _23015_/Q VPWR VGND sg13g2_a21oi_1
X_15898_ _15899_/B _22710_/Q _15898_/A2 _15898_/B1 _22646_/Q VPWR VGND sg13g2_a22oi_1
XFILLER_24_707 VPWR VGND sg13g2_fill_1
X_17637_ _17637_/Y _17697_/A _22957_/Q VPWR VGND sg13g2_nand2_1
XFILLER_91_673 VPWR VGND sg13g2_decap_8
X_14849_ _14883_/B _17838_/B VPWR VGND sg13g2_inv_1
XFILLER_17_770 VPWR VGND sg13g2_decap_8
XFILLER_17_781 VPWR VGND sg13g2_fill_2
X_17568_ _17569_/B _17699_/B1 _17564_/Y _17567_/X _17538_/B VPWR VGND sg13g2_a22oi_1
XFILLER_75_1654 VPWR VGND sg13g2_decap_4
X_16519_ _22619_/D _16519_/A _16519_/B VPWR VGND sg13g2_and2_1
X_17499_ _22866_/D _16504_/Y _17503_/B _17498_/Y VPWR VGND sg13g2_o21ai_1
XFILLER_53_1930 VPWR VGND sg13g2_decap_4
XFILLER_83_0 VPWR VGND sg13g2_decap_8
X_19238_ _19238_/Y _19238_/A _19238_/B VPWR VGND sg13g2_nand2_1
XFILLER_14_1914 VPWR VGND sg13g2_decap_8
XFILLER_20_979 VPWR VGND sg13g2_fill_2
X_19169_ _23141_/D _23141_/Q _14982_/X _19169_/S VPWR VGND sg13g2_mux2_1
X_21200_ _23623_/D _21333_/A1 _21205_/B _21199_/Y VPWR VGND sg13g2_o21ai_1
X_22180_ _24081_/D _24081_/Q _22446_/A1 _22183_/S VPWR VGND sg13g2_mux2_1
Xhold4903 _22168_/A _24074_/Q VPWR VGND sg13g2_dlygate4sd3_1
Xhold4914 _22259_/A _24118_/Q VPWR VGND sg13g2_dlygate4sd3_1
X_21131_ _23590_/D _21331_/A1 _21130_/B _21130_/Y VPWR VGND sg13g2_o21ai_1
XFILLER_86_1761 VPWR VGND sg13g2_decap_8
Xhold4925 _20707_/A _23408_/Q VPWR VGND sg13g2_dlygate4sd3_1
Xhold4936 _20723_/A _23413_/Q VPWR VGND sg13g2_dlygate4sd3_1
XFILLER_99_740 VPWR VGND sg13g2_fill_1
Xhold4947 _22101_/A _24042_/Q VPWR VGND sg13g2_dlygate4sd3_1
Xhold4958 _21095_/A _23574_/Q VPWR VGND sg13g2_dlygate4sd3_1
Xhold4969 _22353_/A _24163_/Q VPWR VGND sg13g2_dlygate4sd3_1
X_21062_ _23562_/D _22033_/A1 _21029_/B _21061_/Y VPWR VGND sg13g2_o21ai_1
XFILLER_63_1013 VPWR VGND sg13g2_fill_1
XFILLER_99_773 VPWR VGND sg13g2_decap_8
XFILLER_67_1193 VPWR VGND sg13g2_fill_2
XFILLER_115_1103 VPWR VGND sg13g2_decap_8
XFILLER_113_561 VPWR VGND sg13g2_decap_8
XFILLER_63_1046 VPWR VGND sg13g2_decap_8
XFILLER_47_1789 VPWR VGND sg13g2_fill_2
X_20013_ _20014_/A _20013_/A _20013_/B VPWR VGND sg13g2_nand2_1
XFILLER_86_434 VPWR VGND sg13g2_fill_2
XFILLER_55_810 VPWR VGND sg13g2_fill_1
XFILLER_104_56 VPWR VGND sg13g2_decap_8
XFILLER_55_821 VPWR VGND sg13g2_fill_1
XFILLER_67_681 VPWR VGND sg13g2_fill_1
X_21964_ _23976_/D _21964_/A0 _23976_/Q _21981_/S VPWR VGND sg13g2_mux2_1
XFILLER_66_191 VPWR VGND sg13g2_fill_1
XFILLER_64_49 VPWR VGND sg13g2_decap_4
X_23703_ _23703_/Q clkload52/A _23703_/D fanout2689/X VPWR VGND sg13g2_dfrbpq_1
X_20915_ _23505_/D _22246_/A0 _23505_/Q _20918_/S VPWR VGND sg13g2_mux2_1
XFILLER_15_707 VPWR VGND sg13g2_decap_4
XFILLER_3_1883 VPWR VGND sg13g2_decap_8
XFILLER_55_887 VPWR VGND sg13g2_decap_8
X_21895_ _21895_/Y _21895_/A _21900_/B VPWR VGND sg13g2_nand2_1
XFILLER_58_1852 VPWR VGND sg13g2_fill_1
X_23634_ _23634_/Q clkload32/A _23634_/D fanout2671/X VPWR VGND sg13g2_dfrbpq_1
X_20846_ _23471_/D _23471_/Q _21346_/A0 _20852_/S VPWR VGND sg13g2_mux2_1
XFILLER_70_857 VPWR VGND sg13g2_fill_1
XFILLER_58_1885 VPWR VGND sg13g2_fill_1
XFILLER_74_1142 VPWR VGND sg13g2_fill_1
XFILLER_106_1806 VPWR VGND sg13g2_fill_1
X_23565_ _23565_/Q clkload47/A _23565_/D fanout2661/X VPWR VGND sg13g2_dfrbpq_1
XFILLER_80_26 VPWR VGND sg13g2_decap_8
XFILLER_11_913 VPWR VGND sg13g2_decap_4
XFILLER_70_1006 VPWR VGND sg13g2_decap_8
X_20777_ _23439_/D _23439_/Q _21346_/A0 _20783_/S VPWR VGND sg13g2_mux2_1
XFILLER_106_1839 VPWR VGND sg13g2_decap_8
X_22516_ _22516_/Q clkload11/A _22516_/D fanout2846/X VPWR VGND sg13g2_dfrbpq_1
XFILLER_35_1159 VPWR VGND sg13g2_decap_8
XFILLER_50_592 VPWR VGND sg13g2_fill_2
X_23496_ _23496_/Q clkload50/A _23496_/D fanout2654/X VPWR VGND sg13g2_dfrbpq_1
X_22447_ _22447_/Y _24210_/Q _22450_/B VPWR VGND sg13g2_nand2_1
XFILLER_100_1405 VPWR VGND sg13g2_fill_2
XFILLER_109_856 VPWR VGND sg13g2_decap_8
X_12200_ _12219_/B _13706_/S _12197_/Y _12199_/Y VPWR VGND sg13g2_a21oi_1
XFILLER_108_344 VPWR VGND sg13g2_decap_4
XFILLER_100_1427 VPWR VGND sg13g2_decap_8
XFILLER_108_355 VPWR VGND sg13g2_fill_1
XFILLER_100_1438 VPWR VGND sg13g2_fill_2
X_22378_ _24176_/D _22445_/A1 _22377_/B _22377_/Y VPWR VGND sg13g2_o21ai_1
X_24117_ _24117_/Q clkload48/A _24117_/D fanout2688/X VPWR VGND sg13g2_dfrbpq_1
X_12131_ _12131_/Y _12134_/S _23420_/Q _12130_/Y VPWR VGND sg13g2_o21ai_1
XFILLER_11_1170 VPWR VGND sg13g2_fill_1
X_21329_ _23685_/D _21329_/A1 _21330_/B _21328_/Y VPWR VGND sg13g2_o21ai_1
XFILLER_8_2 VPWR VGND sg13g2_fill_1
X_12062_ _12062_/X _12062_/A _23547_/Q VPWR VGND sg13g2_and2_1
Xfanout2625 fanout2625/X fanout2792/X VPWR VGND sg13g2_buf_1
X_24048_ _24048_/Q _24210_/CLK _24048_/D fanout2633/X VPWR VGND sg13g2_dfrbpq_1
XFILLER_96_209 VPWR VGND sg13g2_decap_8
Xfanout2636 fanout2636/X fanout2637/X VPWR VGND sg13g2_buf_1
XFILLER_104_561 VPWR VGND sg13g2_decap_8
Xfanout2647 fanout2647/X fanout2693/X VPWR VGND sg13g2_buf_1
XFILLER_2_688 VPWR VGND sg13g2_fill_1
Xfanout2658 fanout2658/X fanout2660/X VPWR VGND sg13g2_buf_1
XFILLER_46_1266 VPWR VGND sg13g2_decap_8
XFILLER_49_103 VPWR VGND sg13g2_fill_2
Xfanout2669 fanout2669/X fanout2670/X VPWR VGND sg13g2_buf_1
X_16870_ _16870_/Y _16877_/A _16870_/B VPWR VGND sg13g2_xnor2_1
XFILLER_1_187 VPWR VGND sg13g2_fill_1
XFILLER_78_968 VPWR VGND sg13g2_decap_4
XFILLER_46_1288 VPWR VGND sg13g2_fill_1
XFILLER_81_1179 VPWR VGND sg13g2_decap_8
X_15821_ _15821_/Y _16020_/B _17902_/B2 _15820_/Y VPWR VGND sg13g2_o21ai_1
XFILLER_63_1591 VPWR VGND sg13g2_fill_2
XFILLER_8_1783 VPWR VGND sg13g2_decap_8
XFILLER_77_478 VPWR VGND sg13g2_decap_8
XFILLER_98_1610 VPWR VGND sg13g2_decap_8
XFILLER_92_426 VPWR VGND sg13g2_fill_1
XFILLER_58_681 VPWR VGND sg13g2_decap_8
XFILLER_111_1534 VPWR VGND sg13g2_fill_2
XFILLER_79_1020 VPWR VGND sg13g2_decap_4
XFILLER_18_523 VPWR VGND sg13g2_decap_8
X_18540_ _18542_/A _18485_/B _18498_/B _18423_/Y _18539_/Y VPWR VGND sg13g2_a22oi_1
XFILLER_38_94 VPWR VGND sg13g2_fill_2
XFILLER_111_1545 VPWR VGND sg13g2_fill_2
X_15752_ _15753_/D _22470_/Q _15945_/A2 _15751_/Y VPWR VGND sg13g2_a21oi_1
X_12964_ _12968_/A _12964_/A _12964_/B _12964_/C VPWR VGND sg13g2_and3_1
X_14703_ _14703_/X _14700_/Y _14702_/Y _14737_/S VPWR VGND sg13g2_mux2_1
XFILLER_45_353 VPWR VGND sg13g2_fill_2
XFILLER_18_578 VPWR VGND sg13g2_decap_4
X_18471_ _22988_/D _18470_/Y _14144_/C _18471_/S VPWR VGND sg13g2_mux2_1
X_11915_ _11915_/X _11912_/X _11913_/X _11915_/S VPWR VGND sg13g2_mux2_1
XFILLER_72_150 VPWR VGND sg13g2_fill_2
XFILLER_73_673 VPWR VGND sg13g2_decap_8
X_15683_ _15689_/C _15683_/A _15667_/B VPWR VGND sg13g2_nor2b_1
X_12895_ _12895_/Y _12895_/A _12895_/B _12895_/C VPWR VGND sg13g2_nand3_1
X_17422_ _22830_/D _16500_/Y _17419_/B _17421_/Y VPWR VGND sg13g2_o21ai_1
X_14634_ _14634_/Y _19494_/A _14634_/B VPWR VGND sg13g2_xnor2_1
X_11846_ _11846_/Y _23673_/Q _12235_/S VPWR VGND sg13g2_nand2b_1
XFILLER_92_1231 VPWR VGND sg13g2_decap_4
XFILLER_37_1947 VPWR VGND sg13g2_decap_8
XFILLER_18_1335 VPWR VGND sg13g2_fill_1
X_17353_ _17353_/Y _17353_/A _17369_/B VPWR VGND sg13g2_nand2_1
XFILLER_13_250 VPWR VGND sg13g2_decap_8
X_14565_ _16215_/A _24228_/Q VPWR VGND sg13g2_inv_1
XFILLER_53_1226 VPWR VGND sg13g2_fill_2
XFILLER_57_1395 VPWR VGND sg13g2_fill_1
XFILLER_53_1237 VPWR VGND sg13g2_decap_8
Xplace4209 _13701_/S0 _13275_/S0 VPWR VGND sg13g2_buf_4
XFILLER_92_1297 VPWR VGND sg13g2_fill_2
X_16304_ _16304_/X _16304_/A _16304_/B _16304_/C VPWR VGND sg13g2_and3_1
XFILLER_53_1259 VPWR VGND sg13g2_decap_8
X_13516_ _13517_/B _20229_/B _20228_/A VPWR VGND sg13g2_nor2b_1
Xplace3508 _17399_/A _17439_/B VPWR VGND sg13g2_buf_1
X_17284_ _17284_/Y _17284_/A _17284_/B VPWR VGND sg13g2_nand2_1
XFILLER_70_1540 VPWR VGND sg13g2_fill_1
X_14496_ _14497_/D _14496_/A _14496_/B _14496_/C _14496_/D VPWR VGND sg13g2_nor4_1
Xplace3519 _15944_/A _16871_/C VPWR VGND sg13g2_buf_1
X_19023_ _19024_/C _23059_/Q _19023_/B _19045_/C VPWR VGND sg13g2_or3_1
XFILLER_31_1524 VPWR VGND sg13g2_decap_8
X_16235_ _16236_/B _16241_/A _16237_/D VPWR VGND sg13g2_nand2_1
XFILLER_70_70 VPWR VGND sg13g2_fill_1
XFILLER_31_1535 VPWR VGND sg13g2_fill_1
Xclkload13 clkload13/Y clkload13/A VPWR VGND sg13g2_inv_8
Xclkload24 clkload24/Y clkload24/A VPWR VGND sg13g2_inv_1
Xclkload35 clkload35/Y clkload35/A VPWR VGND sg13g2_inv_8
Xclkload46 clkload46/X clkload46/A VPWR VGND sg13g2_buf_8
XFILLER_31_1579 VPWR VGND sg13g2_fill_2
X_16166_ _22504_/D _16193_/B _16164_/Y _16165_/Y VPWR VGND sg13g2_o21ai_1
X_13378_ _13379_/B _13370_/Y _13372_/X _13377_/Y VPWR VGND sg13g2_o21ai_1
Xclkload57 clkload57/X clkload57/A VPWR VGND sg13g2_buf_16
XFILLER_86_1024 VPWR VGND sg13g2_fill_2
XFILLER_6_972 VPWR VGND sg13g2_decap_8
X_15117_ _18756_/A _15117_/A _15117_/B VPWR VGND sg13g2_or2_1
X_12329_ _12426_/B _12429_/A _19928_/B VPWR VGND sg13g2_xnor2_1
XFILLER_115_859 VPWR VGND sg13g2_decap_8
XFILLER_5_482 VPWR VGND sg13g2_fill_2
X_16097_ _16097_/Y _17869_/A _16207_/B VPWR VGND sg13g2_nor2_1
X_15048_ _15050_/A _15048_/A1 _18679_/A2 _15047_/Y VPWR VGND sg13g2_a21oi_1
Xclkbuf_leaf_64_clk_i clkload16/A clkload0/A VPWR VGND sg13g2_buf_16
X_19925_ _19925_/Y _23229_/Q _19950_/B VPWR VGND sg13g2_nand2_1
XFILLER_44_1918 VPWR VGND sg13g2_fill_1
XFILLER_64_1344 VPWR VGND sg13g2_decap_4
XFILLER_96_721 VPWR VGND sg13g2_fill_1
XFILLER_29_1486 VPWR VGND sg13g2_fill_1
XFILLER_69_946 VPWR VGND sg13g2_decap_4
XFILLER_29_1497 VPWR VGND sg13g2_fill_1
XFILLER_110_564 VPWR VGND sg13g2_decap_8
X_18807_ _23035_/D _18807_/A _18807_/B _18807_/C VPWR VGND sg13g2_nand3_1
X_19787_ _19787_/Y _19785_/Y _19786_/Y _19946_/C1 VPWR VGND sg13g2_a21oi_1
XFILLER_23_1030 VPWR VGND sg13g2_decap_8
XFILLER_23_1041 VPWR VGND sg13g2_fill_1
X_16999_ _17000_/B _17004_/B _17004_/C VPWR VGND sg13g2_nor2_1
XFILLER_68_489 VPWR VGND sg13g2_decap_8
XFILLER_55_117 VPWR VGND sg13g2_decap_8
XFILLER_83_437 VPWR VGND sg13g2_decap_4
X_18738_ _23025_/D _18732_/Y _18735_/Y _18737_/Y VPWR VGND sg13g2_a21oi_1
XFILLER_49_692 VPWR VGND sg13g2_fill_2
XFILLER_23_1074 VPWR VGND sg13g2_decap_8
XFILLER_42_1697 VPWR VGND sg13g2_decap_8
XFILLER_20_1940 VPWR VGND sg13g2_decap_8
XFILLER_37_865 VPWR VGND sg13g2_decap_8
XFILLER_37_876 VPWR VGND sg13g2_fill_2
XFILLER_3_1179 VPWR VGND sg13g2_decap_8
XFILLER_64_662 VPWR VGND sg13g2_decap_8
X_18669_ _23012_/D _18692_/B _18668_/Y _16278_/B VPWR VGND sg13g2_a21oi_1
XFILLER_24_537 VPWR VGND sg13g2_decap_4
X_20700_ _23403_/D _20700_/A1 _20713_/B _20699_/Y VPWR VGND sg13g2_o21ai_1
XFILLER_34_19 VPWR VGND sg13g2_fill_1
XFILLER_93_1039 VPWR VGND sg13g2_decap_8
X_21680_ _23853_/D _23853_/Q _21972_/A0 _21689_/S VPWR VGND sg13g2_mux2_1
XFILLER_63_194 VPWR VGND sg13g2_fill_2
X_20631_ _20631_/Y _20631_/A _20638_/B VPWR VGND sg13g2_nand2_1
XFILLER_75_1484 VPWR VGND sg13g2_decap_8
X_23350_ _23350_/Q clkload54/A _23350_/D fanout2751/X VPWR VGND sg13g2_dfrbpq_1
XFILLER_20_732 VPWR VGND sg13g2_decap_4
Xclkload7 clkload7/Y clkload7/A VPWR VGND sg13g2_inv_16
XFILLER_109_119 VPWR VGND sg13g2_decap_8
XFILLER_14_1733 VPWR VGND sg13g2_fill_2
X_22301_ _24138_/D _20202_/X _22300_/B _22300_/Y VPWR VGND sg13g2_o21ai_1
Xclkbuf_leaf_17_clk_i clkload23/A clkbuf_4_5__f_clk_i/X VPWR VGND sg13g2_buf_16
X_23281_ _23281_/Q clkload47/A _23281_/D fanout2679/X VPWR VGND sg13g2_dfrbpq_1
XFILLER_30_1012 VPWR VGND sg13g2_fill_2
X_20493_ _23306_/D _22435_/A1 _20500_/B _20492_/Y VPWR VGND sg13g2_o21ai_1
XFILLER_20_798 VPWR VGND sg13g2_fill_1
XFILLER_101_1736 VPWR VGND sg13g2_decap_8
XFILLER_14_1788 VPWR VGND sg13g2_decap_8
X_22232_ _24104_/D _22298_/A0 _24104_/Q _22243_/S VPWR VGND sg13g2_mux2_1
XFILLER_106_815 VPWR VGND sg13g2_decap_8
XFILLER_49_1818 VPWR VGND sg13g2_decap_8
Xhold4700 _17494_/A _22864_/Q VPWR VGND sg13g2_dlygate4sd3_1
Xhold4711 _17500_/A _22867_/Q VPWR VGND sg13g2_dlygate4sd3_1
X_22163_ _24071_/D _22296_/A1 _22175_/B _22162_/Y VPWR VGND sg13g2_o21ai_1
Xhold4722 _22147_/A _24064_/Q VPWR VGND sg13g2_dlygate4sd3_1
Xhold4733 _17484_/A _22859_/Q VPWR VGND sg13g2_dlygate4sd3_1
Xhold4744 _22019_/A _24003_/Q VPWR VGND sg13g2_dlygate4sd3_1
XFILLER_86_1580 VPWR VGND sg13g2_decap_8
Xhold4755 _20734_/A _23418_/Q VPWR VGND sg13g2_dlygate4sd3_1
Xhold4766 _17364_/A _22809_/Q VPWR VGND sg13g2_dlygate4sd3_1
X_22094_ _24038_/D _20141_/Y _22108_/B _22093_/Y VPWR VGND sg13g2_o21ai_1
Xhold4777 _20660_/A _23384_/Q VPWR VGND sg13g2_dlygate4sd3_1
XFILLER_8_1002 VPWR VGND sg13g2_decap_4
Xhold4788 _21748_/A _23877_/Q VPWR VGND sg13g2_dlygate4sd3_1
XFILLER_82_1455 VPWR VGND sg13g2_fill_2
Xhold4799 _21197_/A _23622_/Q VPWR VGND sg13g2_dlygate4sd3_1
X_21045_ _21045_/Y _23556_/Q _21051_/B VPWR VGND sg13g2_nand2_1
XFILLER_86_220 VPWR VGND sg13g2_decap_8
XFILLER_82_1488 VPWR VGND sg13g2_fill_1
XFILLER_59_445 VPWR VGND sg13g2_decap_8
XFILLER_115_77 VPWR VGND sg13g2_decap_8
XFILLER_101_586 VPWR VGND sg13g2_decap_8
XFILLER_99_1930 VPWR VGND sg13g2_decap_8
XFILLER_5_1945 VPWR VGND sg13g2_decap_8
XFILLER_60_1775 VPWR VGND sg13g2_decap_8
XFILLER_112_1854 VPWR VGND sg13g2_decap_8
XFILLER_27_320 VPWR VGND sg13g2_fill_2
XFILLER_28_854 VPWR VGND sg13g2_fill_2
X_22996_ _22996_/Q clkload17/A _22996_/D fanout2847/X VPWR VGND sg13g2_dfrbpq_1
XFILLER_28_865 VPWR VGND sg13g2_fill_1
XFILLER_27_342 VPWR VGND sg13g2_decap_8
XFILLER_83_971 VPWR VGND sg13g2_fill_2
XFILLER_3_1680 VPWR VGND sg13g2_decap_8
X_21947_ _21947_/Y _23968_/Q _21951_/B VPWR VGND sg13g2_nand2_1
XFILLER_76_1248 VPWR VGND sg13g2_fill_2
X_11700_ _11701_/D _13889_/B _11699_/X _11951_/A VPWR VGND sg13g2_o21ai_1
XFILLER_15_537 VPWR VGND sg13g2_fill_2
X_12680_ _12681_/B _23458_/Q _23522_/Q _23618_/Q _23682_/Q _12474_/S _12377_/S VPWR
+ VGND sg13g2_mux4_1
XFILLER_43_857 VPWR VGND sg13g2_decap_8
XFILLER_43_879 VPWR VGND sg13g2_decap_8
XFILLER_70_665 VPWR VGND sg13g2_decap_8
X_11631_ _11636_/B _13535_/A _14154_/B VPWR VGND sg13g2_and2_1
XFILLER_24_41 VPWR VGND sg13g2_fill_2
X_23617_ _23617_/Q _23682_/CLK _23617_/D fanout2726/X VPWR VGND sg13g2_dfrbpq_1
X_20829_ _20829_/Y _23463_/Q _20841_/B VPWR VGND sg13g2_nand2_1
XFILLER_39_1081 VPWR VGND sg13g2_decap_8
XFILLER_54_1535 VPWR VGND sg13g2_decap_8
XFILLER_70_698 VPWR VGND sg13g2_decap_8
XFILLER_106_1614 VPWR VGND sg13g2_decap_8
XFILLER_23_570 VPWR VGND sg13g2_decap_8
XFILLER_54_1568 VPWR VGND sg13g2_fill_1
X_14350_ _15300_/C _15262_/A _15255_/B VPWR VGND sg13g2_and2_1
X_11562_ _14133_/A _14321_/A _13846_/A _14436_/A _14438_/B VPWR VGND sg13g2_nor4_2
X_23548_ _23548_/Q clkload56/A _23548_/D fanout2748/X VPWR VGND sg13g2_dfrbpq_1
XFILLER_10_242 VPWR VGND sg13g2_fill_1
X_13301_ _13301_/Y _13520_/A _13356_/B _13356_/D VPWR VGND sg13g2_nor3_1
X_23479_ _23479_/Q clkload58/A _23479_/D fanout2762/X VPWR VGND sg13g2_dfrbpq_1
XFILLER_13_1232 VPWR VGND sg13g2_decap_8
XFILLER_6_213 VPWR VGND sg13g2_fill_2
X_11493_ _11493_/Y _11493_/A _12550_/A VPWR VGND sg13g2_nand2_1
XFILLER_87_1300 VPWR VGND sg13g2_decap_4
X_16020_ _16020_/Y _22482_/Q _16020_/B VPWR VGND sg13g2_nand2b_1
XFILLER_40_40 VPWR VGND sg13g2_decap_8
X_13232_ _13232_/X _23914_/Q _24010_/Q _13232_/S VPWR VGND sg13g2_mux2_1
XFILLER_109_664 VPWR VGND sg13g2_decap_8
XFILLER_13_1265 VPWR VGND sg13g2_fill_1
XFILLER_40_51 VPWR VGND sg13g2_fill_1
XFILLER_87_1344 VPWR VGND sg13g2_fill_1
X_13163_ _13164_/B _23433_/Q _23465_/Q _13910_/S VPWR VGND sg13g2_mux2_1
XFILLER_48_1328 VPWR VGND sg13g2_decap_8
XFILLER_108_196 VPWR VGND sg13g2_decap_8
X_12114_ _12114_/Y _11669_/Y _11882_/B _12084_/D _12001_/D _12113_/Y VPWR VGND sg13g2_a221oi_1
XFILLER_2_430 VPWR VGND sg13g2_decap_4
X_17971_ _17971_/Y _18015_/S _18907_/B VPWR VGND sg13g2_nor2b_1
X_13094_ _13095_/B _20147_/A _15735_/A _13093_/B VPWR VGND sg13g2_a21oi_1
XFILLER_105_870 VPWR VGND sg13g2_decap_8
X_19710_ _19710_/Y _20028_/A _19710_/B VPWR VGND sg13g2_nand2_1
X_12045_ _12045_/X _12298_/A _12045_/B VPWR VGND sg13g2_or2_1
X_16922_ _16954_/A _22695_/Q VPWR VGND sg13g2_inv_1
XFILLER_2_496 VPWR VGND sg13g2_fill_1
XFILLER_65_1686 VPWR VGND sg13g2_decap_4
XFILLER_61_1539 VPWR VGND sg13g2_decap_4
XFILLER_46_1096 VPWR VGND sg13g2_decap_8
X_19641_ _19642_/B _19638_/X _19822_/B _19702_/A VPWR VGND sg13g2_mux2_1
XFILLER_77_264 VPWR VGND sg13g2_decap_8
X_15804_ _15807_/B _22504_/Q _15767_/B _15804_/B1 _14222_/A VPWR VGND sg13g2_a22oi_1
X_19572_ _19572_/X _19572_/A _19572_/B VPWR VGND sg13g2_and2_1
XFILLER_1_56 VPWR VGND sg13g2_decap_8
X_16784_ _16785_/D _16784_/A _16784_/B VPWR VGND sg13g2_nor2_1
XFILLER_20_1225 VPWR VGND sg13g2_fill_1
XFILLER_46_640 VPWR VGND sg13g2_decap_8
X_13996_ _13996_/Y _13996_/A _14105_/S VPWR VGND sg13g2_xnor2_1
XFILLER_59_1402 VPWR VGND sg13g2_fill_1
XFILLER_93_779 VPWR VGND sg13g2_decap_8
XFILLER_92_256 VPWR VGND sg13g2_fill_2
XFILLER_19_865 VPWR VGND sg13g2_decap_4
X_18523_ _18523_/Y _18515_/Y _18520_/Y _18522_/Y VPWR VGND sg13g2_o21ai_1
XFILLER_46_662 VPWR VGND sg13g2_decap_4
XFILLER_20_1258 VPWR VGND sg13g2_decap_4
X_15735_ _15735_/Y _15735_/A _15930_/A _15735_/C VPWR VGND sg13g2_nor3_1
XFILLER_59_1424 VPWR VGND sg13g2_fill_1
X_12947_ _12947_/Y _12854_/Y _12947_/B VPWR VGND sg13g2_nand2b_1
XFILLER_92_289 VPWR VGND sg13g2_fill_1
XFILLER_94_1348 VPWR VGND sg13g2_decap_4
X_18454_ _18454_/Y _18451_/B _18539_/B _18381_/A VPWR VGND sg13g2_a21oi_1
X_15666_ _15666_/Y _22699_/Q _15708_/A2 _15731_/B1 _22635_/Q VPWR VGND sg13g2_a22oi_1
XFILLER_37_1700 VPWR VGND sg13g2_fill_1
XFILLER_33_345 VPWR VGND sg13g2_decap_4
X_12878_ _12878_/Y _12570_/S _23845_/Q _12877_/Y VPWR VGND sg13g2_o21ai_1
XFILLER_18_1110 VPWR VGND sg13g2_decap_4
XFILLER_76_1782 VPWR VGND sg13g2_fill_2
XFILLER_37_1744 VPWR VGND sg13g2_decap_8
XFILLER_60_153 VPWR VGND sg13g2_fill_2
XFILLER_72_1624 VPWR VGND sg13g2_decap_8
X_18385_ _18385_/Y _18385_/A _18385_/B _18403_/A _18385_/D VPWR VGND sg13g2_nand4_1
XFILLER_53_1012 VPWR VGND sg13g2_fill_2
XFILLER_60_164 VPWR VGND sg13g2_fill_1
X_11829_ _11829_/Y _23321_/Q _11836_/B VPWR VGND sg13g2_nand2b_1
X_15597_ _15597_/Y _16790_/A _15594_/Y _15596_/Y VPWR VGND sg13g2_o21ai_1
Xplace4006 _11363_/B _12039_/B VPWR VGND sg13g2_buf_2
XFILLER_53_1023 VPWR VGND sg13g2_fill_2
Xplace4017 _11926_/S _12406_/A VPWR VGND sg13g2_buf_4
X_17336_ _22795_/D _16109_/A _17341_/B _17335_/Y VPWR VGND sg13g2_o21ai_1
XFILLER_72_1668 VPWR VGND sg13g2_fill_1
X_14548_ _14550_/A _19054_/S VPWR VGND sg13g2_inv_1
Xplace4028 _13560_/S _12126_/A VPWR VGND sg13g2_buf_1
Xplace4039 _17532_/A _14596_/A VPWR VGND sg13g2_buf_1
Xplace3305 _21930_/A1 _22264_/A1 VPWR VGND sg13g2_buf_1
Xplace3316 _21978_/A0 _22246_/A0 VPWR VGND sg13g2_buf_1
XFILLER_53_1078 VPWR VGND sg13g2_decap_8
Xplace3327 _22442_/A1 _20266_/Y VPWR VGND sg13g2_buf_1
XFILLER_53_1089 VPWR VGND sg13g2_fill_1
X_17267_ _22763_/D _16109_/A _17291_/B _17266_/Y VPWR VGND sg13g2_o21ai_1
Xplace3338 _21331_/A1 _21960_/A1 VPWR VGND sg13g2_buf_1
X_14479_ _14481_/C _22607_/Q _23018_/Q VPWR VGND sg13g2_xor2_1
XFILLER_31_1343 VPWR VGND sg13g2_decap_4
Xplace3349 _22409_/A1 _22211_/A1 VPWR VGND sg13g2_buf_1
X_19006_ _19008_/B _19006_/A _19039_/B VPWR VGND sg13g2_nand2_1
X_16218_ _16218_/Y _18607_/A _16241_/C _16244_/B VPWR VGND sg13g2_a21oi_1
X_17198_ _22742_/D _17197_/B _17196_/Y _17197_/Y VPWR VGND sg13g2_a21oi_1
XFILLER_115_656 VPWR VGND sg13g2_decap_8
XFILLER_114_133 VPWR VGND sg13g2_decap_8
XFILLER_46_0 VPWR VGND sg13g2_decap_4
XFILLER_103_829 VPWR VGND sg13g2_decap_8
XFILLER_29_1261 VPWR VGND sg13g2_decap_8
X_19908_ _19921_/A _19904_/Y _19906_/Y _19907_/Y VPWR VGND sg13g2_a21oi_1
XFILLER_44_1748 VPWR VGND sg13g2_fill_1
XFILLER_64_1174 VPWR VGND sg13g2_decap_8
XFILLER_96_551 VPWR VGND sg13g2_fill_1
XFILLER_69_765 VPWR VGND sg13g2_fill_2
XFILLER_25_1147 VPWR VGND sg13g2_decap_4
XFILLER_57_927 VPWR VGND sg13g2_decap_4
XFILLER_111_884 VPWR VGND sg13g2_decap_8
X_19839_ _19839_/Y _12102_/B _19978_/B _20305_/A VPWR VGND sg13g2_o21ai_1
XFILLER_84_724 VPWR VGND sg13g2_decap_8
XFILLER_28_106 VPWR VGND sg13g2_fill_2
XFILLER_83_212 VPWR VGND sg13g2_fill_2
XFILLER_28_117 VPWR VGND sg13g2_fill_2
X_22850_ _22850_/Q clkload21/A _22850_/D fanout2874/X VPWR VGND sg13g2_dfrbpq_1
X_21801_ _23898_/D _22268_/A1 _21802_/B _21800_/Y VPWR VGND sg13g2_o21ai_1
X_22781_ _22781_/Q _22869_/CLK _22781_/D fanout2800/X VPWR VGND sg13g2_dfrbpq_1
XFILLER_25_846 VPWR VGND sg13g2_decap_8
XFILLER_64_481 VPWR VGND sg13g2_fill_2
XFILLER_0_1853 VPWR VGND sg13g2_decap_4
XFILLER_36_183 VPWR VGND sg13g2_decap_8
X_21732_ _21732_/Y _21732_/A _21738_/B VPWR VGND sg13g2_nand2_1
XFILLER_80_963 VPWR VGND sg13g2_decap_8
XFILLER_101_35 VPWR VGND sg13g2_decap_8
XFILLER_25_879 VPWR VGND sg13g2_decap_8
XFILLER_51_142 VPWR VGND sg13g2_fill_1
XFILLER_52_676 VPWR VGND sg13g2_decap_8
X_21663_ _23844_/D _21956_/A1 _21666_/B _21662_/Y VPWR VGND sg13g2_o21ai_1
XFILLER_61_17 VPWR VGND sg13g2_decap_4
XFILLER_107_1923 VPWR VGND sg13g2_decap_8
XFILLER_40_849 VPWR VGND sg13g2_fill_1
X_23402_ _23402_/Q clkload34/A _23402_/D fanout2695/X VPWR VGND sg13g2_dfrbpq_1
XFILLER_16_1828 VPWR VGND sg13g2_decap_8
X_20614_ _20614_/Y _20614_/A _20616_/B VPWR VGND sg13g2_nand2_1
XFILLER_36_1265 VPWR VGND sg13g2_fill_2
X_21594_ _21594_/Y _21594_/A _21605_/B VPWR VGND sg13g2_nand2_1
X_23333_ _23333_/Q clkload33/A _23333_/D fanout2699/X VPWR VGND sg13g2_dfrbpq_1
Xrebuffer5530 rebuffer5530/X rebuffer5531/X VPWR VGND sg13g2_buf_1
X_20545_ _23328_/D _22414_/A1 _20548_/B _20544_/Y VPWR VGND sg13g2_o21ai_1
Xrebuffer5541 rebuffer5541/X rebuffer5542/X VPWR VGND sg13g2_buf_1
Xrebuffer5552 rebuffer5552/X rebuffer5553/X VPWR VGND sg13g2_buf_1
Xrebuffer5563 _16320_/B _14944_/A1 VPWR VGND sg13g2_buf_1
Xplace3850 _20100_/C1 _20367_/A VPWR VGND sg13g2_buf_1
X_23264_ _23264_/Q _23682_/CLK _23264_/D fanout2722/X VPWR VGND sg13g2_dfrbpq_1
Xplace3861 _13181_/B _12413_/B VPWR VGND sg13g2_buf_2
XFILLER_106_601 VPWR VGND sg13g2_decap_8
X_20476_ _20476_/Y _23299_/Q _20500_/B VPWR VGND sg13g2_nand2_1
Xplace3872 _16025_/A _15718_/S VPWR VGND sg13g2_buf_1
Xplace3883 _19299_/S _19300_/S VPWR VGND sg13g2_buf_1
XFILLER_3_205 VPWR VGND sg13g2_fill_2
XFILLER_88_1664 VPWR VGND sg13g2_decap_8
Xplace3894 _18288_/A _18264_/A VPWR VGND sg13g2_buf_1
X_22215_ _22215_/Y _22215_/A _22219_/B VPWR VGND sg13g2_nand2_1
X_23195_ _23195_/Q clkload35/A _23195_/D fanout2927/X VPWR VGND sg13g2_dfrbpq_1
XFILLER_69_1074 VPWR VGND sg13g2_decap_4
XFILLER_105_133 VPWR VGND sg13g2_decap_8
XFILLER_101_1599 VPWR VGND sg13g2_decap_8
X_22146_ _24063_/D _22280_/A1 _22151_/B _22145_/Y VPWR VGND sg13g2_o21ai_1
XFILLER_10_76 VPWR VGND sg13g2_fill_2
XFILLER_0_901 VPWR VGND sg13g2_decap_4
XFILLER_10_87 VPWR VGND sg13g2_decap_8
XFILLER_62_1826 VPWR VGND sg13g2_decap_4
XFILLER_27_1946 VPWR VGND sg13g2_decap_8
XFILLER_114_1916 VPWR VGND sg13g2_decap_8
XFILLER_48_905 VPWR VGND sg13g2_decap_4
XFILLER_102_873 VPWR VGND sg13g2_decap_8
XFILLER_43_1269 VPWR VGND sg13g2_fill_2
XFILLER_5_1742 VPWR VGND sg13g2_decap_8
X_13850_ _13931_/B _13861_/A _20324_/A VPWR VGND sg13g2_xnor2_1
XFILLER_63_919 VPWR VGND sg13g2_decap_8
XFILLER_1_1628 VPWR VGND sg13g2_fill_1
X_12801_ _12801_/Y _12802_/B _23236_/Q _12800_/Y VPWR VGND sg13g2_o21ai_1
XFILLER_16_813 VPWR VGND sg13g2_fill_1
XFILLER_21_1567 VPWR VGND sg13g2_fill_2
XFILLER_74_289 VPWR VGND sg13g2_fill_2
XFILLER_16_835 VPWR VGND sg13g2_decap_8
XFILLER_15_301 VPWR VGND sg13g2_decap_8
X_22979_ _22979_/Q clkload38/A _22979_/D fanout2934/X VPWR VGND sg13g2_dfrbpq_2
XFILLER_55_481 VPWR VGND sg13g2_decap_8
X_15520_ _22459_/D _15718_/S _15517_/X _15519_/Y VPWR VGND sg13g2_a21oi_1
X_12732_ _12732_/Y _12889_/A _12732_/B VPWR VGND sg13g2_nor2_1
XFILLER_56_1619 VPWR VGND sg13g2_decap_8
Xclkbuf_3_6_0_clk_i clkbuf_3_6_0_clk_i/X clkbuf_0_clk_i/X VPWR VGND sg13g2_buf_16
XFILLER_37_1018 VPWR VGND sg13g2_decap_8
Xinput4440 _19119_/A1 instr_rdata_i[3] VPWR VGND sg13g2_buf_1
XFILLER_37_1029 VPWR VGND sg13g2_fill_2
Xinput4451 _14208_/A irqs_i[12] VPWR VGND sg13g2_buf_1
X_15451_ _15466_/A _15451_/A _15451_/B _15451_/C VPWR VGND sg13g2_nand3_1
XFILLER_93_1370 VPWR VGND sg13g2_decap_8
Xinput4462 _14204_/A irqs_i[8] VPWR VGND sg13g2_buf_1
XFILLER_35_95 VPWR VGND sg13g2_fill_1
X_12663_ _12663_/Y _12663_/A _12663_/B _12663_/C _12663_/D VPWR VGND sg13g2_nand4_1
XFILLER_73_1944 VPWR VGND sg13g2_decap_8
X_14402_ _14402_/Y _14445_/B _16856_/B _14172_/B VPWR VGND sg13g2_o21ai_1
X_11614_ _11614_/Y _11614_/A _11614_/B VPWR VGND sg13g2_nor2_1
X_15382_ _16056_/A _23001_/Q _22551_/Q _15591_/S VPWR VGND sg13g2_mux2_1
X_12594_ _12607_/B _13580_/A1 _12591_/X _12593_/X VPWR VGND sg13g2_o21ai_1
XFILLER_50_1207 VPWR VGND sg13g2_decap_8
X_17121_ _17122_/A _22728_/Q VPWR VGND sg13g2_inv_1
XFILLER_15_1349 VPWR VGND sg13g2_fill_2
X_14333_ _15424_/B _15287_/A _16439_/A _15245_/D VPWR VGND sg13g2_o21ai_1
XFILLER_89_1417 VPWR VGND sg13g2_fill_2
XFILLER_51_83 VPWR VGND sg13g2_decap_4
X_17052_ _17083_/B _22715_/Q _22716_/Q _17052_/C VPWR VGND sg13g2_nand3_1
X_11476_ _11476_/Y _11465_/Y _11468_/Y _11953_/A _11471_/Y _11475_/Y VPWR VGND sg13g2_a221oi_1
X_14264_ _24239_/D _16856_/A _14262_/Y _14263_/Y VPWR VGND sg13g2_o21ai_1
XFILLER_7_577 VPWR VGND sg13g2_fill_1
XFILLER_32_1685 VPWR VGND sg13g2_decap_8
XFILLER_100_1021 VPWR VGND sg13g2_decap_8
XFILLER_100_1032 VPWR VGND sg13g2_fill_2
X_16003_ _16003_/Y _16003_/A VPWR VGND sg13g2_inv_1
X_13215_ _13216_/D _13215_/A _13215_/B _13215_/C _13215_/D VPWR VGND sg13g2_nor4_1
XFILLER_13_1095 VPWR VGND sg13g2_fill_2
X_14195_ _14782_/A _14788_/A VPWR VGND sg13g2_inv_1
XFILLER_100_1065 VPWR VGND sg13g2_decap_8
X_13146_ _14659_/B _13146_/A _13146_/B _13146_/C _13146_/D VPWR VGND sg13g2_nor4_2
XFILLER_98_849 VPWR VGND sg13g2_fill_1
XFILLER_2_260 VPWR VGND sg13g2_fill_2
X_17954_ _17956_/B _18393_/S _17951_/Y _17953_/Y VPWR VGND sg13g2_o21ai_1
X_13077_ _13078_/B _13723_/A _13077_/B _13077_/C _13077_/D VPWR VGND sg13g2_nor4_1
XFILLER_61_1303 VPWR VGND sg13g2_fill_1
XFILLER_61_1314 VPWR VGND sg13g2_decap_4
XFILLER_111_147 VPWR VGND sg13g2_decap_8
XFILLER_6_1517 VPWR VGND sg13g2_fill_1
X_12028_ _12028_/Y _12028_/A _12028_/B VPWR VGND sg13g2_nand2_1
X_16905_ _16905_/Y _17092_/A _17032_/B VPWR VGND sg13g2_nand2_1
XFILLER_113_1415 VPWR VGND sg13g2_fill_1
X_17885_ _17886_/A _14966_/A _17929_/A2 _17923_/B _22926_/Q _17884_/Y VPWR VGND sg13g2_a221oi_1
XFILLER_61_1358 VPWR VGND sg13g2_decap_4
XFILLER_93_510 VPWR VGND sg13g2_fill_1
XFILLER_39_949 VPWR VGND sg13g2_decap_8
XFILLER_93_532 VPWR VGND sg13g2_decap_8
X_16836_ _22679_/D _15934_/A _16774_/Y _16835_/Y VPWR VGND sg13g2_o21ai_1
X_19624_ _19624_/Y _19621_/Y _19623_/Y _20350_/A VPWR VGND sg13g2_o21ai_1
XFILLER_76_80 VPWR VGND sg13g2_decap_8
XFILLER_19_651 VPWR VGND sg13g2_fill_1
XFILLER_19_662 VPWR VGND sg13g2_decap_4
X_19555_ _19555_/Y _19869_/A _20028_/B VPWR VGND sg13g2_nand2_1
X_16767_ _16768_/B _22669_/Q _16767_/B VPWR VGND sg13g2_xnor2_1
XFILLER_18_150 VPWR VGND sg13g2_decap_8
XFILLER_19_684 VPWR VGND sg13g2_decap_8
XFILLER_34_610 VPWR VGND sg13g2_fill_2
X_13979_ _13979_/X _13973_/X _13976_/Y _13977_/X _13978_/X _14129_/B _12050_/B VPWR
+ VGND sg13g2_mux4_1
X_18506_ _18506_/Y _18266_/Y _18494_/B _18505_/Y VPWR VGND sg13g2_a21oi_1
X_15718_ _22468_/D _16132_/A _15717_/X _15718_/S VPWR VGND sg13g2_mux2_1
X_19486_ _19486_/Y _19719_/A _19482_/Y _19767_/A VPWR VGND sg13g2_a21oi_1
X_16698_ _16709_/C _22654_/Q _22653_/Q _16698_/C VPWR VGND sg13g2_nand3_1
XFILLER_20_1099 VPWR VGND sg13g2_decap_8
XFILLER_94_1167 VPWR VGND sg13g2_fill_2
XFILLER_61_451 VPWR VGND sg13g2_fill_1
XFILLER_62_985 VPWR VGND sg13g2_fill_1
XFILLER_22_827 VPWR VGND sg13g2_fill_2
X_18437_ _18443_/B _18415_/Y _18436_/Y _18172_/Y VPWR VGND sg13g2_a21oi_1
X_15649_ _15650_/C _15649_/A _15649_/B _15649_/C _15649_/D VPWR VGND sg13g2_nand4_1
XFILLER_22_849 VPWR VGND sg13g2_decap_8
XFILLER_72_1454 VPWR VGND sg13g2_fill_1
X_18368_ _18368_/Y _18564_/A1 _18358_/X _18367_/Y _18103_/B _18457_/S VPWR VGND sg13g2_a221oi_1
Xplace3102 _21363_/B _21367_/B VPWR VGND sg13g2_buf_1
XFILLER_30_860 VPWR VGND sg13g2_decap_8
X_17319_ _17319_/Y _17319_/A _17324_/B VPWR VGND sg13g2_nand2_1
Xplace3113 _21337_/B _21332_/B VPWR VGND sg13g2_buf_1
XFILLER_15_1850 VPWR VGND sg13g2_decap_8
XFILLER_30_893 VPWR VGND sg13g2_fill_2
X_18299_ _18299_/Y _18485_/B _18361_/B _18299_/C VPWR VGND sg13g2_nor3_1
Xplace3124 _21029_/B _21042_/B VPWR VGND sg13g2_buf_1
Xplace3135 _20954_/B _20962_/B VPWR VGND sg13g2_buf_1
Xplace3146 _20903_/B _20919_/B VPWR VGND sg13g2_buf_1
XFILLER_107_409 VPWR VGND sg13g2_fill_2
XFILLER_102_1842 VPWR VGND sg13g2_decap_8
Xplace3157 _20778_/B _20784_/B VPWR VGND sg13g2_buf_1
Xplace3168 _20706_/S _20710_/B VPWR VGND sg13g2_buf_1
Xplace3179 _20578_/B _20516_/Y VPWR VGND sg13g2_buf_1
XFILLER_85_1826 VPWR VGND sg13g2_decap_8
X_20261_ _20261_/Y _13661_/Y _20319_/B _20260_/Y VPWR VGND sg13g2_o21ai_1
XFILLER_66_1214 VPWR VGND sg13g2_decap_8
X_22000_ _23994_/D _22268_/A1 _22001_/B _21999_/Y VPWR VGND sg13g2_o21ai_1
XFILLER_115_453 VPWR VGND sg13g2_decap_8
XFILLER_103_604 VPWR VGND sg13g2_decap_8
X_20192_ _20202_/A _19497_/X _20191_/X _20107_/Y VPWR VGND sg13g2_o21ai_1
XFILLER_88_315 VPWR VGND sg13g2_fill_1
XFILLER_102_114 VPWR VGND sg13g2_decap_4
XFILLER_83_1561 VPWR VGND sg13g2_fill_2
XFILLER_29_1080 VPWR VGND sg13g2_fill_1
XFILLER_57_702 VPWR VGND sg13g2_decap_8
XFILLER_102_169 VPWR VGND sg13g2_fill_2
X_23951_ _23951_/Q clkload30/A _23951_/D fanout2656/X VPWR VGND sg13g2_dfrbpq_1
XFILLER_84_510 VPWR VGND sg13g2_fill_1
XFILLER_5_1027 VPWR VGND sg13g2_decap_8
XFILLER_111_681 VPWR VGND sg13g2_decap_8
XFILLER_57_735 VPWR VGND sg13g2_decap_8
XFILLER_96_392 VPWR VGND sg13g2_decap_8
XFILLER_84_532 VPWR VGND sg13g2_decap_8
X_22902_ _22902_/Q clkload8/A _22902_/D fanout2799/X VPWR VGND sg13g2_dfrbpq_1
XFILLER_79_1619 VPWR VGND sg13g2_fill_1
XFILLER_2_1904 VPWR VGND sg13g2_decap_8
XFILLER_29_459 VPWR VGND sg13g2_decap_4
X_23882_ _23882_/Q _24131_/CLK _23882_/D fanout2711/X VPWR VGND sg13g2_dfrbpq_1
XFILLER_72_716 VPWR VGND sg13g2_decap_8
XFILLER_38_971 VPWR VGND sg13g2_decap_8
XFILLER_72_727 VPWR VGND sg13g2_fill_1
X_22833_ _22833_/Q _22869_/CLK _22833_/D fanout2797/X VPWR VGND sg13g2_dfrbpq_1
XFILLER_84_598 VPWR VGND sg13g2_decap_8
XFILLER_77_1343 VPWR VGND sg13g2_fill_1
XFILLER_112_56 VPWR VGND sg13g2_decap_8
XFILLER_24_120 VPWR VGND sg13g2_decap_4
XFILLER_25_643 VPWR VGND sg13g2_decap_8
X_22764_ _22764_/Q _22893_/CLK _22764_/D fanout2818/X VPWR VGND sg13g2_dfrbpq_1
XFILLER_72_27 VPWR VGND sg13g2_fill_2
XFILLER_52_473 VPWR VGND sg13g2_decap_8
X_22695_ _22695_/Q clkload22/A _22695_/D fanout2884/X VPWR VGND sg13g2_dfrbpq_1
XFILLER_52_484 VPWR VGND sg13g2_fill_1
XFILLER_90_1521 VPWR VGND sg13g2_decap_8
XFILLER_52_495 VPWR VGND sg13g2_fill_1
XFILLER_55_1663 VPWR VGND sg13g2_fill_2
X_21646_ _21646_/Y _21646_/A _21648_/B VPWR VGND sg13g2_nand2_1
XFILLER_90_1587 VPWR VGND sg13g2_decap_8
XFILLER_51_1549 VPWR VGND sg13g2_decap_8
X_21577_ _23804_/D _21938_/A1 _21581_/B _21576_/Y VPWR VGND sg13g2_o21ai_1
Xrebuffer5360 _13776_/A1 _11740_/Y VPWR VGND sg13g2_buf_1
X_23316_ _23316_/Q _24212_/CLK _23316_/D fanout2622/X VPWR VGND sg13g2_dfrbpq_1
Xrebuffer5371 _19953_/A _12521_/Y VPWR VGND sg13g2_buf_1
Xrebuffer5382 _14053_/B _12864_/Y VPWR VGND sg13g2_buf_1
Xplace3680 _14947_/B _14794_/X VPWR VGND sg13g2_buf_1
XFILLER_106_420 VPWR VGND sg13g2_decap_8
X_11261_ _12471_/B _14342_/B _12668_/B VPWR VGND sg13g2_nor2_1
Xplace3691 _20038_/A _20354_/B VPWR VGND sg13g2_buf_1
X_23247_ _23247_/Q clkload32/A _23247_/D fanout2648/X VPWR VGND sg13g2_dfrbpq_1
X_20459_ _23291_/D _22403_/A1 _20458_/B _20458_/Y VPWR VGND sg13g2_o21ai_1
XFILLER_10_1257 VPWR VGND sg13g2_decap_8
Xhold5050 _21642_/A _23835_/Q VPWR VGND sg13g2_dlygate4sd3_1
XFILLER_88_1494 VPWR VGND sg13g2_fill_1
XFILLER_84_1325 VPWR VGND sg13g2_decap_8
X_13000_ _13000_/X _23302_/Q _23334_/Q _23366_/Q _23398_/Q _13001_/S0 _12709_/A VPWR
+ VGND sg13g2_mux4_1
Xhold5061 _22367_/A _24170_/Q VPWR VGND sg13g2_dlygate4sd3_1
XFILLER_107_987 VPWR VGND sg13g2_decap_8
XFILLER_97_35 VPWR VGND sg13g2_decap_8
Xplace2990 _18956_/B _18957_/C VPWR VGND sg13g2_buf_1
Xhold5072 _22197_/A _24088_/Q VPWR VGND sg13g2_dlygate4sd3_1
X_23178_ _23178_/Q clkload17/A _23178_/D fanout2858/X VPWR VGND sg13g2_dfrbpq_1
XFILLER_106_475 VPWR VGND sg13g2_decap_8
Xhold5083 _20535_/A _23324_/Q VPWR VGND sg13g2_dlygate4sd3_1
XFILLER_49_1478 VPWR VGND sg13g2_decap_4
Xhold5094 _20874_/A _23484_/Q VPWR VGND sg13g2_dlygate4sd3_1
X_22129_ _22129_/Y _22129_/A _22129_/B VPWR VGND sg13g2_nand2_1
XFILLER_66_1770 VPWR VGND sg13g2_fill_2
XFILLER_62_1623 VPWR VGND sg13g2_decap_8
XFILLER_62_1634 VPWR VGND sg13g2_fill_1
XFILLER_88_860 VPWR VGND sg13g2_decap_4
XFILLER_88_871 VPWR VGND sg13g2_decap_8
XFILLER_43_1033 VPWR VGND sg13g2_fill_1
XFILLER_7_1848 VPWR VGND sg13g2_decap_8
XFILLER_27_1776 VPWR VGND sg13g2_fill_2
X_13902_ _13902_/Y _13966_/B _13902_/B VPWR VGND sg13g2_nand2_1
XFILLER_87_392 VPWR VGND sg13g2_fill_1
X_17670_ _17670_/Y _17119_/A _17670_/A2 _17670_/B1 _17669_/Y VPWR VGND sg13g2_a22oi_1
XFILLER_47_245 VPWR VGND sg13g2_decap_4
X_14882_ _14882_/Y _17838_/B _14882_/B VPWR VGND sg13g2_nor2_1
XFILLER_75_565 VPWR VGND sg13g2_fill_1
X_16621_ _16621_/Y _16626_/A _16621_/B VPWR VGND sg13g2_nor2_1
XFILLER_29_982 VPWR VGND sg13g2_decap_8
X_13833_ _13833_/X _23570_/Q _24018_/Q _13955_/S VPWR VGND sg13g2_mux2_1
XFILLER_95_1421 VPWR VGND sg13g2_fill_2
XFILLER_90_535 VPWR VGND sg13g2_fill_2
XFILLER_44_930 VPWR VGND sg13g2_decap_8
X_16552_ _16553_/B _22625_/Q _16552_/B VPWR VGND sg13g2_xnor2_1
XFILLER_62_248 VPWR VGND sg13g2_decap_8
X_13764_ _13764_/X _23601_/Q _23633_/Q _23665_/Q _23697_/Q _13773_/S0 _13765_/S1 VPWR
+ VGND sg13g2_mux4_1
XFILLER_43_440 VPWR VGND sg13g2_fill_2
XFILLER_15_142 VPWR VGND sg13g2_decap_8
X_15503_ _15509_/A _15503_/A _15503_/B _15503_/C VPWR VGND sg13g2_nand3_1
XFILLER_31_602 VPWR VGND sg13g2_fill_2
X_19271_ _23194_/D _19266_/Y _19276_/B _19270_/Y VPWR VGND sg13g2_o21ai_1
XFILLER_16_687 VPWR VGND sg13g2_decap_4
X_12715_ _12715_/X _23427_/Q _23459_/Q _23491_/Q _23523_/Q _13004_/S0 _13004_/S1 VPWR
+ VGND sg13g2_mux4_1
XFILLER_15_164 VPWR VGND sg13g2_decap_8
XFILLER_44_996 VPWR VGND sg13g2_decap_4
X_16483_ _22604_/D _17480_/A1 _16495_/S _16482_/Y VPWR VGND sg13g2_o21ai_1
XFILLER_73_1730 VPWR VGND sg13g2_fill_2
XFILLER_71_793 VPWR VGND sg13g2_decap_8
XFILLER_70_281 VPWR VGND sg13g2_fill_1
X_18222_ _18223_/B _18476_/A _18297_/A _18210_/B VPWR VGND sg13g2_o21ai_1
X_15434_ _15435_/D _15434_/A _15434_/B _15434_/C VPWR VGND sg13g2_nor3_1
XFILLER_19_1271 VPWR VGND sg13g2_decap_8
X_12646_ _12646_/X _23586_/Q _23618_/Q _23650_/Q _23682_/Q _13006_/S0 _13006_/S1 VPWR
+ VGND sg13g2_mux4_1
XFILLER_87_7 VPWR VGND sg13g2_decap_8
X_18153_ _18153_/Y _18301_/B _18379_/B _18427_/A _18539_/A _18443_/A VPWR VGND sg13g2_a221oi_1
XFILLER_54_1184 VPWR VGND sg13g2_fill_1
XFILLER_106_1263 VPWR VGND sg13g2_decap_8
X_15365_ _15372_/A _15365_/A _15365_/B _15365_/C _15365_/D VPWR VGND sg13g2_nand4_1
XFILLER_7_22 VPWR VGND sg13g2_fill_1
X_12577_ _12577_/Y _22987_/Q _12577_/B _12577_/C VPWR VGND sg13g2_nand3b_1
X_17104_ _17110_/C _22725_/Q _22724_/Q VPWR VGND sg13g2_nand2_1
XFILLER_8_864 VPWR VGND sg13g2_fill_1
X_14316_ _14316_/Y _15287_/A _15283_/C _14316_/C VPWR VGND sg13g2_nor3_1
XFILLER_7_55 VPWR VGND sg13g2_decap_8
X_18084_ _18084_/Y _14470_/A _14470_/B _22997_/Q VPWR VGND sg13g2_o21ai_1
X_11528_ _11528_/Y _13280_/B _11528_/B VPWR VGND sg13g2_nor2_1
X_15296_ _15296_/Y _15353_/A _15296_/B VPWR VGND sg13g2_nor2_1
XFILLER_7_396 VPWR VGND sg13g2_decap_8
X_14247_ _14247_/Y _15133_/A _24221_/Q _24224_/Q VPWR VGND sg13g2_nor3_1
X_11459_ _11459_/Y _11457_/Y _11458_/Y _13343_/B VPWR VGND sg13g2_a21oi_1
X_14178_ _14756_/A _24236_/Q _24235_/Q VPWR VGND sg13g2_nor2_1
XFILLER_113_957 VPWR VGND sg13g2_fill_1
XFILLER_97_134 VPWR VGND sg13g2_decap_8
XFILLER_84_1870 VPWR VGND sg13g2_decap_8
X_13129_ _13136_/A _23912_/Q _13798_/A2 _13128_/X _13133_/A _12683_/X VPWR VGND sg13g2_a221oi_1
X_18986_ _18986_/Y _19008_/A _18986_/B _18986_/C VPWR VGND sg13g2_nand3_1
XFILLER_112_467 VPWR VGND sg13g2_decap_8
XFILLER_6_1303 VPWR VGND sg13g2_decap_8
XFILLER_39_702 VPWR VGND sg13g2_decap_8
XFILLER_79_882 VPWR VGND sg13g2_decap_4
XFILLER_61_1133 VPWR VGND sg13g2_decap_4
X_17937_ _17938_/C _22943_/Q _17937_/B VPWR VGND sg13g2_nand2b_1
XFILLER_78_370 VPWR VGND sg13g2_fill_1
XFILLER_39_746 VPWR VGND sg13g2_decap_8
XFILLER_39_757 VPWR VGND sg13g2_fill_1
XFILLER_6_1369 VPWR VGND sg13g2_decap_4
X_17868_ _22920_/D _17868_/A VPWR VGND sg13g2_inv_1
XFILLER_27_919 VPWR VGND sg13g2_fill_2
XFILLER_113_1267 VPWR VGND sg13g2_fill_1
XFILLER_81_502 VPWR VGND sg13g2_decap_8
XFILLER_38_267 VPWR VGND sg13g2_decap_8
X_19607_ _19612_/C _19607_/A1 _19601_/Y _19606_/Y VPWR VGND sg13g2_o21ai_1
XFILLER_26_418 VPWR VGND sg13g2_fill_1
X_16819_ _22675_/D _16169_/A _16818_/A _16818_/Y VPWR VGND sg13g2_a21oi_1
X_17799_ _17806_/B _22575_/Q _22574_/Q _17799_/C VPWR VGND sg13g2_nand3_1
XFILLER_19_492 VPWR VGND sg13g2_decap_8
XFILLER_39_1603 VPWR VGND sg13g2_fill_1
X_19538_ _19538_/Y _19538_/A VPWR VGND sg13g2_inv_1
XFILLER_35_963 VPWR VGND sg13g2_fill_2
XFILLER_78_1696 VPWR VGND sg13g2_decap_8
X_19469_ _19469_/Y _19436_/Y _19468_/Y _20060_/A VPWR VGND sg13g2_a21oi_1
X_21500_ _21500_/Y _23767_/Q _21502_/B VPWR VGND sg13g2_nand2_1
XFILLER_50_955 VPWR VGND sg13g2_decap_8
XFILLER_52_1803 VPWR VGND sg13g2_decap_8
XFILLER_17_1934 VPWR VGND sg13g2_decap_8
X_22480_ _22480_/Q clkload8/A _22480_/D fanout2807/X VPWR VGND sg13g2_dfrbpq_1
XFILLER_50_988 VPWR VGND sg13g2_fill_1
X_21431_ _23734_/D _21926_/A1 _21430_/B _21430_/Y VPWR VGND sg13g2_o21ai_1
XFILLER_104_1915 VPWR VGND sg13g2_decap_8
XFILLER_108_718 VPWR VGND sg13g2_fill_2
X_24150_ _24150_/Q clkload44/A _24150_/D fanout2752/X VPWR VGND sg13g2_dfrbpq_1
X_21362_ _23701_/D _21924_/A1 _21363_/B _21361_/Y VPWR VGND sg13g2_o21ai_1
XFILLER_107_217 VPWR VGND sg13g2_decap_8
X_23101_ _23101_/Q _23114_/CLK _23101_/D fanout2903/X VPWR VGND sg13g2_dfrbpq_1
X_24081_ _24081_/Q clkload50/A _24081_/D fanout2666/X VPWR VGND sg13g2_dfrbpq_1
X_23032_ _23032_/Q clkload13/A _23032_/D fanout2847/X VPWR VGND sg13g2_dfrbpq_1
X_20244_ _20247_/B _13523_/B _19835_/Y _19837_/Y _20243_/Y VPWR VGND sg13g2_a22oi_1
XFILLER_104_924 VPWR VGND sg13g2_fill_2
XFILLER_85_1678 VPWR VGND sg13g2_decap_4
XFILLER_81_1509 VPWR VGND sg13g2_fill_2
XFILLER_115_294 VPWR VGND sg13g2_decap_8
XFILLER_107_56 VPWR VGND sg13g2_decap_8
XFILLER_103_434 VPWR VGND sg13g2_decap_8
XFILLER_67_16 VPWR VGND sg13g2_decap_8
XFILLER_104_979 VPWR VGND sg13g2_decap_4
XFILLER_77_819 VPWR VGND sg13g2_decap_8
XFILLER_67_49 VPWR VGND sg13g2_fill_1
XFILLER_44_1386 VPWR VGND sg13g2_fill_1
X_23934_ _23934_/Q _23966_/CLK _23934_/D fanout2785/X VPWR VGND sg13g2_dfrbpq_1
XFILLER_18_919 VPWR VGND sg13g2_decap_4
XFILLER_2_1701 VPWR VGND sg13g2_decap_8
XFILLER_85_885 VPWR VGND sg13g2_fill_1
XFILLER_83_15 VPWR VGND sg13g2_fill_1
XFILLER_57_587 VPWR VGND sg13g2_decap_8
X_23865_ _23865_/Q _23966_/CLK _23865_/D fanout2783/X VPWR VGND sg13g2_dfrbpq_1
XFILLER_45_738 VPWR VGND sg13g2_decap_8
XFILLER_72_546 VPWR VGND sg13g2_fill_1
XFILLER_2_1778 VPWR VGND sg13g2_decap_8
XFILLER_44_248 VPWR VGND sg13g2_decap_8
X_22816_ _22816_/Q clkload18/A _22816_/D fanout2830/X VPWR VGND sg13g2_dfrbpq_1
XFILLER_72_557 VPWR VGND sg13g2_fill_2
X_23796_ _23796_/Q clkload29/A _23796_/D fanout2669/X VPWR VGND sg13g2_dfrbpq_1
XFILLER_57_1747 VPWR VGND sg13g2_fill_2
X_22747_ _22747_/Q clkload21/A _22747_/D fanout2877/X VPWR VGND sg13g2_dfrbpq_1
XFILLER_109_1848 VPWR VGND sg13g2_decap_8
X_12500_ _12501_/B _23232_/Q _23360_/Q _12502_/S VPWR VGND sg13g2_mux2_1
XFILLER_40_443 VPWR VGND sg13g2_fill_1
X_13480_ _13480_/X _13611_/A _13480_/B VPWR VGND sg13g2_or2_1
XFILLER_12_145 VPWR VGND sg13g2_decap_8
XFILLER_40_454 VPWR VGND sg13g2_fill_1
X_22678_ _22678_/Q clkload20/A _22678_/D fanout2867/X VPWR VGND sg13g2_dfrbpq_1
XFILLER_90_1362 VPWR VGND sg13g2_fill_1
XFILLER_8_105 VPWR VGND sg13g2_fill_1
X_12431_ _12431_/Y _12436_/A _12438_/B VPWR VGND sg13g2_nor2_1
X_21629_ _21629_/Y _21629_/A _21635_/B VPWR VGND sg13g2_nand2_1
XFILLER_12_189 VPWR VGND sg13g2_decap_4
XFILLER_12_1308 VPWR VGND sg13g2_decap_4
XFILLER_21_690 VPWR VGND sg13g2_fill_2
X_15150_ _15309_/A _15238_/B VPWR VGND sg13g2_inv_1
X_12362_ _12363_/B _23711_/Q _23839_/Q _12485_/S VPWR VGND sg13g2_mux2_1
XFILLER_113_0 VPWR VGND sg13g2_decap_8
XFILLER_5_834 VPWR VGND sg13g2_decap_4
XFILLER_4_311 VPWR VGND sg13g2_decap_8
X_14101_ _14102_/D _19721_/A _14099_/Y _14100_/Y VPWR VGND sg13g2_o21ai_1
XFILLER_10_1021 VPWR VGND sg13g2_decap_4
X_15081_ _16324_/A _22539_/Q _15117_/A _18732_/A VPWR VGND sg13g2_a21oi_1
X_12293_ _12293_/Y _12293_/A _23550_/Q VPWR VGND sg13g2_nand2_1
XFILLER_4_355 VPWR VGND sg13g2_decap_8
XFILLER_68_1854 VPWR VGND sg13g2_fill_2
X_11244_ _11245_/B _13186_/B _12551_/B VPWR VGND sg13g2_nor2_1
X_14032_ _14036_/B _14032_/A _14032_/B _14032_/C VPWR VGND sg13g2_nand3_1
XFILLER_107_784 VPWR VGND sg13g2_fill_2
XFILLER_106_261 VPWR VGND sg13g2_decap_8
XFILLER_79_101 VPWR VGND sg13g2_fill_2
XFILLER_64_1729 VPWR VGND sg13g2_decap_8
XFILLER_49_1286 VPWR VGND sg13g2_fill_1
X_18840_ _18840_/Y _18866_/A _18840_/B VPWR VGND sg13g2_nand2_1
XFILLER_79_145 VPWR VGND sg13g2_decap_4
XFILLER_79_167 VPWR VGND sg13g2_fill_1
X_18771_ _18771_/Y _18573_/A _18771_/B VPWR VGND sg13g2_nand2b_1
XFILLER_110_949 VPWR VGND sg13g2_decap_4
X_15983_ _15984_/B _22746_/Q _16013_/A2 _16013_/B1 _22682_/Q VPWR VGND sg13g2_a22oi_1
XFILLER_88_690 VPWR VGND sg13g2_fill_2
X_17722_ _22895_/D _17721_/B _17720_/Y _17721_/Y VPWR VGND sg13g2_a21oi_1
X_14934_ _14934_/Y _22525_/Q VPWR VGND sg13g2_inv_1
XFILLER_97_1516 VPWR VGND sg13g2_decap_4
XFILLER_23_1459 VPWR VGND sg13g2_fill_1
XFILLER_110_1418 VPWR VGND sg13g2_fill_1
X_17653_ _22888_/D _17652_/B _17651_/Y _17652_/Y VPWR VGND sg13g2_a21oi_1
XFILLER_76_896 VPWR VGND sg13g2_decap_8
XFILLER_91_833 VPWR VGND sg13g2_decap_8
X_14865_ _14866_/B _22488_/Q _14848_/B _14794_/X _22457_/Q VPWR VGND sg13g2_a22oi_1
X_16604_ _16605_/B _22635_/Q _22634_/Q _16604_/C VPWR VGND sg13g2_nand3_1
XFILLER_1_1244 VPWR VGND sg13g2_fill_1
XFILLER_35_248 VPWR VGND sg13g2_decap_8
X_13816_ _13816_/Y _14129_/D _13814_/Y _13815_/Y VPWR VGND sg13g2_o21ai_1
XFILLER_63_557 VPWR VGND sg13g2_decap_8
X_17584_ _17584_/X _11311_/B _22952_/Q _17622_/A VPWR VGND sg13g2_mux2_1
XFILLER_75_1814 VPWR VGND sg13g2_fill_1
X_14796_ _14797_/B _22484_/Q _14848_/B _14794_/X _22453_/Q VPWR VGND sg13g2_a22oi_1
XFILLER_95_1262 VPWR VGND sg13g2_fill_1
XFILLER_17_974 VPWR VGND sg13g2_decap_8
XFILLER_91_1104 VPWR VGND sg13g2_fill_1
XFILLER_91_899 VPWR VGND sg13g2_decap_8
X_16535_ _22621_/D _16043_/A _16547_/A _16534_/Y VPWR VGND sg13g2_a21oi_1
XFILLER_91_1115 VPWR VGND sg13g2_fill_2
XFILLER_90_398 VPWR VGND sg13g2_decap_8
X_13747_ _13748_/D _14004_/B _13747_/B VPWR VGND sg13g2_nor2_1
XFILLER_91_1148 VPWR VGND sg13g2_decap_8
X_19254_ _19255_/B _19265_/A _19268_/B VPWR VGND sg13g2_nand2b_1
X_16466_ _22596_/D _16080_/Y _16472_/B _16465_/Y VPWR VGND sg13g2_o21ai_1
XFILLER_31_454 VPWR VGND sg13g2_fill_1
X_13678_ _13678_/Y _13678_/A1 _13677_/Y _13419_/A VPWR VGND sg13g2_a21oi_1
X_15417_ _15417_/Y _15497_/S _16060_/A VPWR VGND sg13g2_nor2_1
X_19185_ _23155_/D _23155_/Q _15120_/X _19185_/S VPWR VGND sg13g2_mux2_1
X_16397_ _16397_/Y _22566_/Q _16413_/S VPWR VGND sg13g2_nand2_1
XFILLER_106_1060 VPWR VGND sg13g2_decap_4
XFILLER_89_1000 VPWR VGND sg13g2_decap_8
XFILLER_89_1011 VPWR VGND sg13g2_decap_8
XFILLER_30_1419 VPWR VGND sg13g2_decap_8
X_18136_ _22961_/D _18524_/B _18553_/A1 _18135_/Y VPWR VGND sg13g2_o21ai_1
XFILLER_12_1820 VPWR VGND sg13g2_decap_8
X_15348_ _15463_/B _16776_/C _15348_/B VPWR VGND sg13g2_nand2_1
X_15279_ _15279_/Y _23000_/Q VPWR VGND sg13g2_inv_1
XFILLER_86_1954 VPWR VGND sg13g2_fill_1
XFILLER_12_1897 VPWR VGND sg13g2_decap_8
XFILLER_67_1331 VPWR VGND sg13g2_decap_4
X_17018_ _17023_/B _22712_/Q _17018_/B VPWR VGND sg13g2_and2_1
XFILLER_47_1916 VPWR VGND sg13g2_decap_8
XFILLER_99_944 VPWR VGND sg13g2_fill_1
XFILLER_99_955 VPWR VGND sg13g2_decap_8
XFILLER_113_743 VPWR VGND sg13g2_decap_8
XFILLER_112_231 VPWR VGND sg13g2_decap_8
XFILLER_98_454 VPWR VGND sg13g2_decap_4
XFILLER_28_1348 VPWR VGND sg13g2_fill_2
XFILLER_115_1318 VPWR VGND sg13g2_decap_8
XFILLER_98_487 VPWR VGND sg13g2_fill_1
XFILLER_112_275 VPWR VGND sg13g2_decap_8
XFILLER_112_286 VPWR VGND sg13g2_fill_1
X_18969_ _18969_/Y _18999_/A _18969_/B _18969_/C VPWR VGND sg13g2_nand3b_1
XFILLER_79_690 VPWR VGND sg13g2_fill_1
XFILLER_39_521 VPWR VGND sg13g2_decap_8
XFILLER_41_1526 VPWR VGND sg13g2_decap_8
XFILLER_113_1042 VPWR VGND sg13g2_fill_1
X_21980_ _23986_/D _21980_/A1 _21982_/B _21979_/Y VPWR VGND sg13g2_o21ai_1
XFILLER_94_660 VPWR VGND sg13g2_decap_8
XFILLER_94_671 VPWR VGND sg13g2_fill_1
XFILLER_54_502 VPWR VGND sg13g2_decap_4
X_20931_ _23511_/D _20931_/A1 _20930_/B _20930_/Y VPWR VGND sg13g2_o21ai_1
XFILLER_96_1048 VPWR VGND sg13g2_decap_8
XFILLER_96_1059 VPWR VGND sg13g2_fill_2
XFILLER_26_248 VPWR VGND sg13g2_fill_2
X_20862_ _20862_/Y _20862_/A _20874_/B VPWR VGND sg13g2_nand2_1
XFILLER_81_343 VPWR VGND sg13g2_decap_8
X_23650_ _23650_/Q clkload42/A _23650_/D fanout2728/X VPWR VGND sg13g2_dfrbpq_1
X_22601_ _22601_/Q clkload10/A _22601_/D fanout2813/X VPWR VGND sg13g2_dfrbpq_1
XFILLER_41_218 VPWR VGND sg13g2_decap_8
X_23581_ _23581_/Q clkload53/A _23581_/D fanout2779/X VPWR VGND sg13g2_dfrbpq_1
X_20793_ _23446_/D _20929_/A1 _20794_/B _20792_/Y VPWR VGND sg13g2_o21ai_1
XFILLER_39_1477 VPWR VGND sg13g2_decap_8
XFILLER_74_1357 VPWR VGND sg13g2_decap_4
XFILLER_35_1319 VPWR VGND sg13g2_fill_2
X_22532_ _22532_/Q _22941_/CLK _22532_/D fanout2803/X VPWR VGND sg13g2_dfrbpq_1
XFILLER_91_1660 VPWR VGND sg13g2_decap_8
XFILLER_52_1611 VPWR VGND sg13g2_fill_1
XFILLER_56_1780 VPWR VGND sg13g2_decap_4
XFILLER_33_1010 VPWR VGND sg13g2_fill_2
X_22463_ _22463_/Q clkload18/A _22463_/D fanout2827/X VPWR VGND sg13g2_dfrbpq_1
XFILLER_13_1617 VPWR VGND sg13g2_decap_8
X_24202_ _24202_/Q clkload34/A _24202_/D fanout2697/X VPWR VGND sg13g2_dfrbpq_1
X_21414_ _23726_/D _21974_/A1 _21416_/B _21413_/Y VPWR VGND sg13g2_o21ai_1
X_22394_ _24183_/D _19688_/Y _22393_/B _22393_/Y VPWR VGND sg13g2_o21ai_1
XFILLER_5_108 VPWR VGND sg13g2_fill_2
XFILLER_33_1098 VPWR VGND sg13g2_decap_4
X_24133_ _24133_/Q clkload45/A _24133_/D fanout2714/X VPWR VGND sg13g2_dfrbpq_1
X_21345_ _23694_/D _21345_/A1 _21347_/B _21344_/Y VPWR VGND sg13g2_o21ai_1
XFILLER_108_559 VPWR VGND sg13g2_decap_8
XFILLER_11_1385 VPWR VGND sg13g2_decap_8
X_21276_ _23660_/D _21342_/A1 _21281_/B _21275_/Y VPWR VGND sg13g2_o21ai_1
X_24064_ _24064_/Q clkload43/A _24064_/D fanout2769/X VPWR VGND sg13g2_dfrbpq_1
Xfanout2807 fanout2807/X fanout2809/X VPWR VGND sg13g2_buf_1
XFILLER_1_325 VPWR VGND sg13g2_fill_1
Xfanout2818 fanout2818/X fanout2819/X VPWR VGND sg13g2_buf_1
X_23015_ _23015_/Q _23029_/CLK _23015_/D fanout2808/X VPWR VGND sg13g2_dfrbpq_1
X_20227_ _20236_/A _24268_/A _20318_/B VPWR VGND sg13g2_nand2_1
Xfanout2829 fanout2829/X fanout2830/X VPWR VGND sg13g2_buf_1
XFILLER_104_776 VPWR VGND sg13g2_decap_8
XFILLER_49_307 VPWR VGND sg13g2_fill_2
XFILLER_49_318 VPWR VGND sg13g2_fill_1
XFILLER_44_1172 VPWR VGND sg13g2_fill_2
XFILLER_92_608 VPWR VGND sg13g2_decap_8
X_12980_ _12989_/D _12977_/X _13552_/A _12979_/X VPWR VGND sg13g2_o21ai_1
XFILLER_57_340 VPWR VGND sg13g2_decap_4
X_20089_ _20089_/Y _20084_/Y _20085_/B _19861_/B _20088_/Y _15669_/C VPWR VGND sg13g2_a221oi_1
XFILLER_115_1896 VPWR VGND sg13g2_decap_8
XFILLER_98_1836 VPWR VGND sg13g2_fill_1
XFILLER_85_671 VPWR VGND sg13g2_decap_8
X_23917_ _23917_/Q _24205_/CLK _23917_/D fanout2649/X VPWR VGND sg13g2_dfrbpq_1
XFILLER_57_395 VPWR VGND sg13g2_fill_2
X_14650_ _14650_/Y _14692_/A1 _14714_/A2 _14649_/Y VPWR VGND sg13g2_o21ai_1
X_23848_ _23848_/Q clkload31/A _23848_/D fanout2653/X VPWR VGND sg13g2_dfrbpq_1
X_11862_ _11862_/Y _11860_/Y _12414_/A _11861_/Y VPWR VGND sg13g2_o21ai_1
XFILLER_2_1575 VPWR VGND sg13g2_fill_1
XFILLER_2_1597 VPWR VGND sg13g2_decap_8
XFILLER_72_387 VPWR VGND sg13g2_fill_1
XFILLER_14_933 VPWR VGND sg13g2_decap_8
X_14581_ _14581_/Y _14596_/A _17042_/C _14609_/C VPWR VGND sg13g2_nand3_1
X_23779_ _23779_/Q clkload39/A _23779_/D fanout2737/X VPWR VGND sg13g2_dfrbpq_1
X_11793_ _11794_/D _12486_/A _11792_/X _11951_/A VPWR VGND sg13g2_o21ai_1
X_16320_ _16321_/B _16320_/A _16320_/B VPWR VGND sg13g2_nand2_1
XFILLER_109_1656 VPWR VGND sg13g2_decap_4
X_13532_ _13657_/A _13532_/A _13950_/B _13950_/C _13950_/A VPWR VGND sg13g2_nor4_2
XFILLER_70_1700 VPWR VGND sg13g2_decap_8
XFILLER_16_1230 VPWR VGND sg13g2_decap_4
X_16251_ _16263_/B _16251_/A _16253_/C _16253_/D VPWR VGND sg13g2_nor3_2
XFILLER_70_1733 VPWR VGND sg13g2_decap_4
X_13463_ _13463_/X _24077_/Q _24141_/Q _13466_/A VPWR VGND sg13g2_mux2_1
XFILLER_16_1241 VPWR VGND sg13g2_fill_2
XFILLER_90_1192 VPWR VGND sg13g2_fill_2
XFILLER_16_1263 VPWR VGND sg13g2_decap_8
X_15202_ _16852_/B _15424_/A _15424_/B _15625_/B VPWR VGND sg13g2_nand3_1
XFILLER_31_1728 VPWR VGND sg13g2_decap_8
X_12414_ _12414_/Y _12414_/A _23166_/Q VPWR VGND sg13g2_nor2b_1
X_16182_ _22507_/D _16193_/B _16180_/Y _16181_/Y VPWR VGND sg13g2_o21ai_1
X_13394_ _13394_/X _23436_/Q _23500_/Q _23596_/Q _23660_/Q _13251_/B _13559_/S1 VPWR
+ VGND sg13g2_mux4_1
X_15133_ _15442_/S _15133_/A _15133_/B VPWR VGND sg13g2_nor2_1
XFILLER_103_1277 VPWR VGND sg13g2_decap_8
X_12345_ _12345_/X _12353_/A _12345_/B VPWR VGND sg13g2_xor2_1
XFILLER_4_130 VPWR VGND sg13g2_decap_8
XFILLER_114_529 VPWR VGND sg13g2_decap_8
X_19941_ _19941_/Y _19941_/A _19941_/B _19941_/C _19941_/D VPWR VGND sg13g2_nand4_1
X_15064_ _15064_/X _23149_/Q _16323_/B _15120_/S VPWR VGND sg13g2_mux2_1
XFILLER_68_1651 VPWR VGND sg13g2_decap_8
X_12276_ _12277_/D _12428_/C _12531_/A _12968_/B _15491_/A VPWR VGND sg13g2_or4_1
XFILLER_29_1635 VPWR VGND sg13g2_decap_8
X_14015_ _14015_/Y _14013_/A _14014_/X _14103_/A VPWR VGND sg13g2_a21oi_1
X_11227_ _11227_/Y _11222_/B _11222_/A _11219_/Y _23193_/Q VPWR VGND sg13g2_a22oi_1
X_19872_ _19872_/Y _19872_/A _19872_/B VPWR VGND sg13g2_nor2_1
XFILLER_64_1559 VPWR VGND sg13g2_fill_1
XFILLER_96_936 VPWR VGND sg13g2_fill_1
XFILLER_81_1840 VPWR VGND sg13g2_fill_1
X_18823_ _18823_/Y _17965_/A _23038_/Q _18823_/B1 _19124_/A1 VPWR VGND sg13g2_a22oi_1
XFILLER_42_1802 VPWR VGND sg13g2_fill_1
XFILLER_96_958 VPWR VGND sg13g2_decap_8
XFILLER_7_1453 VPWR VGND sg13g2_fill_1
X_15966_ _15967_/B _22779_/Q _15940_/B _15966_/B1 _22869_/Q VPWR VGND sg13g2_a22oi_1
X_18754_ _18754_/Y _18757_/A _18753_/Y _23028_/Q VPWR VGND sg13g2_a21oi_1
XFILLER_64_800 VPWR VGND sg13g2_fill_2
X_14917_ _14919_/A _24256_/A _14879_/A _14916_/Y VPWR VGND sg13g2_a21oi_1
X_17705_ _17705_/X _22564_/Q _17705_/B VPWR VGND sg13g2_xor2_1
X_15897_ _15904_/A _22936_/Q _15897_/A2 _15896_/Y VPWR VGND sg13g2_a21oi_1
X_18685_ _18685_/Y _18685_/A _18685_/B VPWR VGND sg13g2_nand2_1
XFILLER_91_630 VPWR VGND sg13g2_fill_2
XFILLER_63_321 VPWR VGND sg13g2_decap_8
XFILLER_110_1259 VPWR VGND sg13g2_decap_8
XFILLER_36_557 VPWR VGND sg13g2_decap_8
XFILLER_40_1581 VPWR VGND sg13g2_decap_8
XFILLER_63_343 VPWR VGND sg13g2_decap_8
XFILLER_40_1592 VPWR VGND sg13g2_fill_1
X_14848_ _14857_/B _22487_/Q _14848_/B VPWR VGND sg13g2_nand2_1
X_17636_ _22050_/A _21918_/D VPWR VGND sg13g2_inv_1
XFILLER_90_151 VPWR VGND sg13g2_decap_4
XFILLER_91_696 VPWR VGND sg13g2_fill_1
XFILLER_56_1010 VPWR VGND sg13g2_decap_8
X_17567_ _17567_/X _17567_/A _17567_/B VPWR VGND sg13g2_and2_1
XFILLER_56_1021 VPWR VGND sg13g2_fill_2
XFILLER_63_398 VPWR VGND sg13g2_decap_8
X_14779_ _14790_/B _14885_/B VPWR VGND sg13g2_inv_1
XFILLER_56_1043 VPWR VGND sg13g2_fill_1
XFILLER_75_1666 VPWR VGND sg13g2_fill_2
X_16518_ _16519_/B _16856_/A _16779_/A _16518_/C _17399_/A VPWR VGND sg13g2_nand4_1
X_19306_ _20367_/A _23189_/Q _19306_/B _19306_/C VPWR VGND sg13g2_nand3b_1
XFILLER_17_1027 VPWR VGND sg13g2_fill_1
X_17498_ _17498_/Y _17498_/A _17498_/B VPWR VGND sg13g2_nand2_1
XFILLER_32_774 VPWR VGND sg13g2_decap_8
X_19237_ _23189_/D _14614_/Y _23189_/Q _19237_/S VPWR VGND sg13g2_mux2_1
XFILLER_31_273 VPWR VGND sg13g2_decap_8
X_16449_ _16449_/Y _22589_/Q _16517_/S VPWR VGND sg13g2_nand2_1
XFILLER_108_1199 VPWR VGND sg13g2_fill_2
XFILLER_31_295 VPWR VGND sg13g2_decap_4
XFILLER_76_0 VPWR VGND sg13g2_decap_8
X_19168_ _23140_/D _23140_/Q _19168_/A1 _19169_/S VPWR VGND sg13g2_mux2_1
XFILLER_9_981 VPWR VGND sg13g2_decap_8
XFILLER_34_1396 VPWR VGND sg13g2_decap_4
XFILLER_101_1929 VPWR VGND sg13g2_decap_8
X_18119_ _22953_/D _18331_/A _22953_/Q _18119_/S VPWR VGND sg13g2_mux2_1
XFILLER_69_1426 VPWR VGND sg13g2_fill_2
X_19099_ _23085_/D _23085_/Q _19098_/X _19099_/S VPWR VGND sg13g2_mux2_1
XFILLER_69_1437 VPWR VGND sg13g2_fill_2
Xhold4904 _20656_/A _23382_/Q VPWR VGND sg13g2_dlygate4sd3_1
X_21130_ _21130_/Y _21130_/A _21130_/B VPWR VGND sg13g2_nand2_1
Xhold4915 _21439_/A _23738_/Q VPWR VGND sg13g2_dlygate4sd3_1
Xhold4926 _20823_/A _23460_/Q VPWR VGND sg13g2_dlygate4sd3_1
Xhold4937 _20898_/A _23495_/Q VPWR VGND sg13g2_dlygate4sd3_1
XFILLER_86_1784 VPWR VGND sg13g2_decap_8
Xhold4948 _20964_/A _23527_/Q VPWR VGND sg13g2_dlygate4sd3_1
XFILLER_99_752 VPWR VGND sg13g2_decap_8
Xhold4959 _22241_/A _24110_/Q VPWR VGND sg13g2_dlygate4sd3_1
X_21061_ _21061_/Y _23562_/Q _21071_/B VPWR VGND sg13g2_nand2_1
XFILLER_113_540 VPWR VGND sg13g2_decap_8
XFILLER_98_240 VPWR VGND sg13g2_fill_1
XFILLER_63_1025 VPWR VGND sg13g2_decap_8
XFILLER_87_925 VPWR VGND sg13g2_fill_1
XFILLER_82_1659 VPWR VGND sg13g2_decap_8
X_20012_ _20015_/B _20038_/A _20012_/B VPWR VGND sg13g2_nor2_1
XFILLER_87_936 VPWR VGND sg13g2_decap_8
XFILLER_100_201 VPWR VGND sg13g2_decap_8
XFILLER_24_1009 VPWR VGND sg13g2_fill_1
XFILLER_60_1902 VPWR VGND sg13g2_decap_8
XFILLER_101_735 VPWR VGND sg13g2_fill_1
XFILLER_100_223 VPWR VGND sg13g2_fill_1
XFILLER_115_1159 VPWR VGND sg13g2_decap_8
XFILLER_80_1372 VPWR VGND sg13g2_fill_1
XFILLER_101_779 VPWR VGND sg13g2_decap_4
XFILLER_39_340 VPWR VGND sg13g2_fill_2
XFILLER_74_619 VPWR VGND sg13g2_decap_8
XFILLER_104_35 VPWR VGND sg13g2_decap_8
X_23702_ _23702_/Q clkload58/A _23702_/D fanout2758/X VPWR VGND sg13g2_dfrbpq_1
XFILLER_3_1862 VPWR VGND sg13g2_decap_8
X_20914_ _23504_/D _22445_/A1 _20913_/B _20913_/Y VPWR VGND sg13g2_o21ai_1
X_21894_ _23942_/D _21960_/A1 _21893_/B _21893_/Y VPWR VGND sg13g2_o21ai_1
XFILLER_42_505 VPWR VGND sg13g2_decap_4
XFILLER_58_1831 VPWR VGND sg13g2_decap_8
XFILLER_82_696 VPWR VGND sg13g2_fill_2
X_23633_ _23633_/Q _24113_/CLK _23633_/D fanout2683/X VPWR VGND sg13g2_dfrbpq_1
XFILLER_74_1110 VPWR VGND sg13g2_fill_1
X_20845_ _23470_/D _21345_/A1 _20847_/B _20844_/Y VPWR VGND sg13g2_o21ai_1
XFILLER_54_398 VPWR VGND sg13g2_fill_2
XFILLER_23_730 VPWR VGND sg13g2_fill_2
XFILLER_54_1706 VPWR VGND sg13g2_fill_2
XFILLER_11_903 VPWR VGND sg13g2_decap_4
XFILLER_22_240 VPWR VGND sg13g2_decap_4
XFILLER_39_1285 VPWR VGND sg13g2_fill_1
X_23564_ _23564_/Q _24210_/CLK _23564_/D fanout2642/X VPWR VGND sg13g2_dfrbpq_1
XFILLER_74_1165 VPWR VGND sg13g2_fill_2
XFILLER_106_1818 VPWR VGND sg13g2_decap_8
X_20776_ _23438_/D _20266_/Y _20778_/B _20775_/Y VPWR VGND sg13g2_o21ai_1
XFILLER_50_560 VPWR VGND sg13g2_decap_8
XFILLER_11_936 VPWR VGND sg13g2_fill_2
XFILLER_22_262 VPWR VGND sg13g2_fill_1
XFILLER_74_1198 VPWR VGND sg13g2_decap_8
X_22515_ _22515_/Q clkload11/A _22515_/D fanout2841/X VPWR VGND sg13g2_dfrbpq_1
XFILLER_11_947 VPWR VGND sg13g2_decap_8
XFILLER_10_435 VPWR VGND sg13g2_decap_4
X_23495_ _23495_/Q _24170_/CLK _23495_/D fanout2698/X VPWR VGND sg13g2_dfrbpq_1
XFILLER_17_1572 VPWR VGND sg13g2_fill_1
XFILLER_13_1403 VPWR VGND sg13g2_decap_8
XFILLER_52_1463 VPWR VGND sg13g2_decap_8
XFILLER_104_1542 VPWR VGND sg13g2_fill_1
X_22446_ _24209_/D _24209_/Q _22446_/A1 _22449_/S VPWR VGND sg13g2_mux2_1
XFILLER_10_468 VPWR VGND sg13g2_fill_2
XFILLER_13_87 VPWR VGND sg13g2_fill_1
XFILLER_104_1575 VPWR VGND sg13g2_decap_8
XFILLER_89_14 VPWR VGND sg13g2_decap_8
XFILLER_109_879 VPWR VGND sg13g2_fill_1
X_22377_ _22377_/Y _24176_/Q _22377_/B VPWR VGND sg13g2_nand2_1
XFILLER_89_47 VPWR VGND sg13g2_fill_2
XFILLER_89_58 VPWR VGND sg13g2_fill_1
X_12130_ _12130_/Y _23484_/Q _12134_/S VPWR VGND sg13g2_nand2b_1
X_24116_ _24116_/Q _24212_/CLK _24116_/D fanout2622/X VPWR VGND sg13g2_dfrbpq_1
XFILLER_108_389 VPWR VGND sg13g2_decap_8
X_21328_ _21328_/Y _21328_/A _21330_/B VPWR VGND sg13g2_nand2_1
XFILLER_11_1182 VPWR VGND sg13g2_decap_8
XFILLER_65_1824 VPWR VGND sg13g2_decap_8
XFILLER_104_540 VPWR VGND sg13g2_decap_8
X_12061_ _12061_/X _24027_/Q _24059_/Q _12062_/A VPWR VGND sg13g2_mux2_1
X_24047_ _24047_/Q clkload50/A _24047_/D fanout2654/X VPWR VGND sg13g2_dfrbpq_1
X_21259_ _23651_/D _21325_/A1 _21266_/B _21258_/Y VPWR VGND sg13g2_o21ai_1
XFILLER_89_240 VPWR VGND sg13g2_fill_2
Xfanout2626 fanout2626/X fanout2628/X VPWR VGND sg13g2_buf_1
Xfanout2637 fanout2637/X fanout2644/X VPWR VGND sg13g2_buf_1
Xfanout2648 fanout2648/X fanout2652/X VPWR VGND sg13g2_buf_1
Xfanout2659 fanout2659/X fanout2660/X VPWR VGND sg13g2_buf_1
XFILLER_78_936 VPWR VGND sg13g2_decap_4
XFILLER_8_1762 VPWR VGND sg13g2_decap_8
X_15820_ _15820_/Y _22473_/Q _16020_/B VPWR VGND sg13g2_nand2b_1
XFILLER_92_405 VPWR VGND sg13g2_decap_8
XFILLER_18_502 VPWR VGND sg13g2_decap_8
XFILLER_111_1524 VPWR VGND sg13g2_fill_2
XFILLER_115_1693 VPWR VGND sg13g2_decap_8
X_15751_ _15751_/Y _15947_/A1 _15750_/Y _15947_/B1 VPWR VGND sg13g2_o21ai_1
X_12963_ _12964_/C _12963_/A _12965_/B _12963_/C VPWR VGND sg13g2_nand3_1
XFILLER_57_170 VPWR VGND sg13g2_decap_4
XFILLER_58_693 VPWR VGND sg13g2_decap_4
XFILLER_73_630 VPWR VGND sg13g2_decap_8
XFILLER_57_181 VPWR VGND sg13g2_fill_2
X_14702_ _14702_/Y _14660_/A _14686_/B _14701_/X VPWR VGND sg13g2_a21oi_1
XFILLER_57_192 VPWR VGND sg13g2_decap_8
X_18470_ _18470_/Y _18120_/Y _18461_/Y _18469_/Y VPWR VGND sg13g2_o21ai_1
XFILLER_111_1579 VPWR VGND sg13g2_decap_8
X_15682_ _15683_/A _22700_/Q _15708_/A2 _15731_/B1 _22636_/Q VPWR VGND sg13g2_a22oi_1
XFILLER_18_568 VPWR VGND sg13g2_fill_2
XFILLER_59_1639 VPWR VGND sg13g2_decap_8
X_12894_ _12895_/C _14189_/A _12893_/X _12686_/B VPWR VGND sg13g2_a21oi_1
XFILLER_61_825 VPWR VGND sg13g2_fill_2
XFILLER_73_685 VPWR VGND sg13g2_fill_1
X_17421_ _17421_/Y _17421_/A _17425_/B VPWR VGND sg13g2_nand2_1
XFILLER_60_302 VPWR VGND sg13g2_decap_4
XFILLER_45_387 VPWR VGND sg13g2_decap_4
XFILLER_73_696 VPWR VGND sg13g2_decap_8
X_11845_ _11845_/Y _11384_/Y _11840_/Y _11842_/Y _11393_/Y _11844_/Y VPWR VGND sg13g2_a221oi_1
XFILLER_72_184 VPWR VGND sg13g2_fill_1
XFILLER_76_1953 VPWR VGND sg13g2_fill_2
XFILLER_92_1221 VPWR VGND sg13g2_decap_4
XFILLER_33_549 VPWR VGND sg13g2_fill_2
XFILLER_14_730 VPWR VGND sg13g2_decap_8
XFILLER_57_1352 VPWR VGND sg13g2_fill_2
XFILLER_57_1363 VPWR VGND sg13g2_decap_8
XFILLER_53_1205 VPWR VGND sg13g2_decap_8
XFILLER_57_1374 VPWR VGND sg13g2_fill_2
XFILLER_60_357 VPWR VGND sg13g2_decap_8
X_17352_ _22802_/D _16150_/A _17351_/B _17351_/Y VPWR VGND sg13g2_o21ai_1
X_11776_ _11776_/Y _22551_/Q _11736_/Y _11776_/B1 _11993_/A _11775_/Y VPWR VGND sg13g2_a221oi_1
XFILLER_41_560 VPWR VGND sg13g2_fill_2
X_16303_ _16303_/Y _22535_/Q _16301_/Y _16302_/Y VPWR VGND sg13g2_o21ai_1
XFILLER_14_796 VPWR VGND sg13g2_decap_8
XFILLER_13_273 VPWR VGND sg13g2_decap_8
X_13515_ _13522_/B _13748_/A _13748_/B _13748_/C _13515_/D VPWR VGND sg13g2_and4_1
X_17283_ _22770_/D _16150_/A _17302_/S _17282_/Y VPWR VGND sg13g2_o21ai_1
XFILLER_9_233 VPWR VGND sg13g2_fill_2
X_14495_ _14496_/D _22605_/Q _23016_/Q VPWR VGND sg13g2_xor2_1
Xplace3509 _24264_/A _15000_/B2 VPWR VGND sg13g2_buf_1
X_19022_ _19024_/B _19019_/Y _19045_/C VPWR VGND sg13g2_nand2b_1
XFILLER_35_1672 VPWR VGND sg13g2_fill_2
XFILLER_70_1552 VPWR VGND sg13g2_fill_2
X_16234_ _22516_/D _16233_/B _16229_/Y _16232_/X _16233_/Y VPWR VGND sg13g2_a22oi_1
XFILLER_35_1683 VPWR VGND sg13g2_decap_8
XFILLER_9_277 VPWR VGND sg13g2_decap_8
XFILLER_35_1694 VPWR VGND sg13g2_fill_2
X_13446_ _13446_/Y _13748_/B _13748_/A _13748_/C _13949_/C VPWR VGND sg13g2_nand4_1
XFILLER_70_1574 VPWR VGND sg13g2_decap_8
XFILLER_70_1585 VPWR VGND sg13g2_fill_2
XFILLER_9_288 VPWR VGND sg13g2_fill_1
Xclkload14 clkload14/X clkload14/A VPWR VGND sg13g2_buf_8
XFILLER_103_1052 VPWR VGND sg13g2_decap_8
Xclkload25 clkload25/Y clkload25/A VPWR VGND sg13g2_inv_16
X_16165_ _16165_/Y _16165_/A _16193_/B VPWR VGND sg13g2_nand2_1
Xclkload36 clkload36/X clkload36/A VPWR VGND sg13g2_buf_16
Xclkload47 clkload47/Y clkload47/A VPWR VGND sg13g2_inv_4
X_13377_ _13377_/Y _13374_/Y _13375_/Y _13376_/X VPWR VGND sg13g2_o21ai_1
Xclkload58 clkload58/Y clkload58/A VPWR VGND sg13g2_inv_1
XFILLER_86_1036 VPWR VGND sg13g2_decap_8
X_15116_ _15117_/B _17929_/A1 _15029_/B _18635_/A2 _15116_/B2 _15115_/Y VPWR VGND
+ sg13g2_a221oi_1
XFILLER_115_838 VPWR VGND sg13g2_decap_8
XFILLER_86_1058 VPWR VGND sg13g2_decap_8
XFILLER_47_1009 VPWR VGND sg13g2_decap_8
XFILLER_86_1069 VPWR VGND sg13g2_fill_1
XFILLER_5_494 VPWR VGND sg13g2_decap_8
XFILLER_79_80 VPWR VGND sg13g2_decap_4
X_15047_ _15047_/Y _15047_/A _15047_/B VPWR VGND sg13g2_nand2_1
X_12259_ _12259_/Y _11441_/S _12257_/X _12258_/Y VPWR VGND sg13g2_a21oi_1
XFILLER_96_733 VPWR VGND sg13g2_fill_1
XFILLER_25_1318 VPWR VGND sg13g2_fill_1
Xclkbuf_0_clk_i clkbuf_0_clk_i/X clk_i VPWR VGND sg13g2_buf_8
XFILLER_64_1389 VPWR VGND sg13g2_decap_8
XFILLER_110_543 VPWR VGND sg13g2_decap_8
XFILLER_96_766 VPWR VGND sg13g2_decap_8
X_18806_ _18807_/C _23067_/Q _18825_/B VPWR VGND sg13g2_nand2_1
XFILLER_95_254 VPWR VGND sg13g2_decap_4
XFILLER_68_468 VPWR VGND sg13g2_fill_2
X_19786_ _19786_/Y _20310_/A2 _19514_/Y _19782_/Y _20343_/S0 VPWR VGND sg13g2_a22oi_1
XFILLER_83_416 VPWR VGND sg13g2_decap_8
X_16998_ _17004_/C _22708_/Q _17008_/D VPWR VGND sg13g2_nand2_1
XFILLER_95_287 VPWR VGND sg13g2_decap_8
X_18737_ _18737_/Y _18713_/A _18736_/Y _23025_/Q VPWR VGND sg13g2_a21oi_1
X_15949_ _15950_/C _15949_/A _15949_/B _15949_/C _15949_/D VPWR VGND sg13g2_and4_1
XFILLER_64_630 VPWR VGND sg13g2_decap_4
XFILLER_3_1158 VPWR VGND sg13g2_decap_8
XFILLER_110_1045 VPWR VGND sg13g2_fill_2
XFILLER_23_1097 VPWR VGND sg13g2_fill_1
XFILLER_92_972 VPWR VGND sg13g2_decap_8
X_18668_ _18668_/Y _23012_/Q _18668_/B VPWR VGND sg13g2_xnor2_1
XFILLER_63_151 VPWR VGND sg13g2_decap_4
XFILLER_97_1198 VPWR VGND sg13g2_decap_8
X_17619_ _17619_/Y _22885_/Q _17661_/B VPWR VGND sg13g2_nor2_1
XFILLER_75_1430 VPWR VGND sg13g2_fill_2
X_18599_ _18599_/Y _18599_/A1 _14880_/B _18598_/X VPWR VGND sg13g2_o21ai_1
XFILLER_90_1906 VPWR VGND sg13g2_fill_1
X_20630_ _23369_/D _22233_/A0 _23369_/Q _20640_/S VPWR VGND sg13g2_mux2_1
XFILLER_75_1474 VPWR VGND sg13g2_decap_4
XFILLER_71_1327 VPWR VGND sg13g2_fill_1
XFILLER_20_711 VPWR VGND sg13g2_decap_8
XFILLER_32_571 VPWR VGND sg13g2_decap_8
XFILLER_36_1447 VPWR VGND sg13g2_decap_8
XFILLER_36_1458 VPWR VGND sg13g2_fill_1
X_20561_ _20580_/S _20649_/B _22119_/A VPWR VGND sg13g2_and2_1
XFILLER_71_1349 VPWR VGND sg13g2_decap_4
Xclkload8 clkload8/X clkload8/A VPWR VGND sg13g2_buf_8
X_22300_ _22300_/Y _22300_/A _22300_/B VPWR VGND sg13g2_nand2_1
XFILLER_20_777 VPWR VGND sg13g2_fill_2
X_20492_ _20492_/Y _20492_/A _20500_/B VPWR VGND sg13g2_nand2_1
X_23280_ _23280_/Q _24214_/CLK _23280_/D fanout2626/X VPWR VGND sg13g2_dfrbpq_1
XFILLER_34_1193 VPWR VGND sg13g2_decap_4
XFILLER_105_1884 VPWR VGND sg13g2_decap_8
XFILLER_30_1035 VPWR VGND sg13g2_fill_2
XFILLER_106_827 VPWR VGND sg13g2_decap_8
XFILLER_12_1480 VPWR VGND sg13g2_fill_2
X_22162_ _22162_/Y _22162_/A _22175_/B VPWR VGND sg13g2_nand2_1
Xhold4701 _17353_/A _22803_/Q VPWR VGND sg13g2_dlygate4sd3_1
XFILLER_69_1256 VPWR VGND sg13g2_decap_8
Xhold4712 _20482_/A _23302_/Q VPWR VGND sg13g2_dlygate4sd3_1
Xhold4723 _22145_/A _24063_/Q VPWR VGND sg13g2_dlygate4sd3_1
XFILLER_69_1289 VPWR VGND sg13g2_decap_8
X_21113_ _23582_/D _21314_/A1 _21112_/B _21112_/Y VPWR VGND sg13g2_o21ai_1
Xhold4734 _22350_/A _24162_/Q VPWR VGND sg13g2_dlygate4sd3_1
XFILLER_47_1521 VPWR VGND sg13g2_decap_4
Xhold4745 _19857_/A _23227_/Q VPWR VGND sg13g2_dlygate4sd3_1
Xhold4756 _17408_/A _22823_/Q VPWR VGND sg13g2_dlygate4sd3_1
X_22093_ _22093_/Y _22093_/A _22108_/B VPWR VGND sg13g2_nand2_1
XFILLER_82_1434 VPWR VGND sg13g2_decap_8
XFILLER_47_1554 VPWR VGND sg13g2_decap_8
Xhold4767 _17437_/A _22839_/Q VPWR VGND sg13g2_dlygate4sd3_1
XFILLER_47_1565 VPWR VGND sg13g2_fill_2
Xhold4778 _17260_/A _22760_/Q VPWR VGND sg13g2_dlygate4sd3_1
Xhold4789 _17460_/A _22848_/Q VPWR VGND sg13g2_dlygate4sd3_1
XFILLER_114_893 VPWR VGND sg13g2_decap_4
XFILLER_87_733 VPWR VGND sg13g2_fill_1
XFILLER_99_593 VPWR VGND sg13g2_decap_8
XFILLER_87_744 VPWR VGND sg13g2_fill_2
XFILLER_86_232 VPWR VGND sg13g2_decap_8
XFILLER_60_1710 VPWR VGND sg13g2_decap_8
XFILLER_115_56 VPWR VGND sg13g2_decap_8
XFILLER_86_243 VPWR VGND sg13g2_fill_2
XFILLER_101_565 VPWR VGND sg13g2_decap_8
XFILLER_5_1924 VPWR VGND sg13g2_decap_8
XFILLER_75_928 VPWR VGND sg13g2_fill_1
XFILLER_25_1863 VPWR VGND sg13g2_decap_4
XFILLER_75_38 VPWR VGND sg13g2_fill_1
XFILLER_112_1833 VPWR VGND sg13g2_decap_8
XFILLER_60_1765 VPWR VGND sg13g2_fill_1
XFILLER_21_1727 VPWR VGND sg13g2_fill_2
XFILLER_41_1164 VPWR VGND sg13g2_decap_8
X_22995_ _22995_/Q clkload16/A _22995_/D fanout2921/X VPWR VGND sg13g2_dfrbpq_1
X_21946_ _23967_/D _21946_/A1 _21951_/B _21945_/Y VPWR VGND sg13g2_o21ai_1
XFILLER_55_674 VPWR VGND sg13g2_fill_1
XFILLER_15_516 VPWR VGND sg13g2_decap_8
XFILLER_110_1590 VPWR VGND sg13g2_fill_1
XFILLER_27_398 VPWR VGND sg13g2_decap_8
XFILLER_54_184 VPWR VGND sg13g2_fill_1
X_21877_ _23934_/D _21943_/A1 _21876_/B _21876_/Y VPWR VGND sg13g2_o21ai_1
XFILLER_42_335 VPWR VGND sg13g2_decap_8
XFILLER_58_1672 VPWR VGND sg13g2_fill_1
XFILLER_39_1060 VPWR VGND sg13g2_decap_8
X_23616_ _23616_/Q clkload39/A _23616_/D fanout2739/X VPWR VGND sg13g2_dfrbpq_1
XFILLER_54_1514 VPWR VGND sg13g2_decap_8
X_20828_ _23462_/D _21331_/A1 _20827_/B _20827_/Y VPWR VGND sg13g2_o21ai_1
XFILLER_54_1547 VPWR VGND sg13g2_decap_8
XFILLER_19_1678 VPWR VGND sg13g2_fill_1
XFILLER_23_582 VPWR VGND sg13g2_decap_4
X_23547_ _23547_/Q clkload48/A _23547_/D fanout2755/X VPWR VGND sg13g2_dfrbpq_1
X_11561_ _11561_/Y _11571_/B _11574_/B1 _11583_/S VPWR VGND sg13g2_o21ai_1
X_20759_ _23429_/D _21329_/A1 _20772_/B _20758_/Y VPWR VGND sg13g2_o21ai_1
XFILLER_11_766 VPWR VGND sg13g2_decap_8
X_13300_ _13300_/X _13356_/B _13356_/D VPWR VGND sg13g2_and2_1
XFILLER_13_1211 VPWR VGND sg13g2_decap_8
XFILLER_7_726 VPWR VGND sg13g2_fill_2
X_23478_ _23478_/Q clkload54/A _23478_/D fanout2781/X VPWR VGND sg13g2_dfrbpq_1
XFILLER_10_265 VPWR VGND sg13g2_fill_1
X_11492_ _11492_/Y _12583_/C _11492_/B VPWR VGND sg13g2_nand2_1
XFILLER_32_1856 VPWR VGND sg13g2_decap_8
XFILLER_104_1361 VPWR VGND sg13g2_decap_4
XFILLER_109_643 VPWR VGND sg13g2_decap_8
X_13231_ _13231_/Y _13232_/S _24106_/Q _13230_/Y VPWR VGND sg13g2_o21ai_1
X_22429_ _24199_/D _22429_/A1 _22444_/B _22428_/Y VPWR VGND sg13g2_o21ai_1
XFILLER_108_175 VPWR VGND sg13g2_decap_8
X_13162_ _13162_/Y _13166_/B _23593_/Q _13161_/Y VPWR VGND sg13g2_o21ai_1
XFILLER_87_1356 VPWR VGND sg13g2_decap_8
XFILLER_3_932 VPWR VGND sg13g2_decap_8
XFILLER_3_943 VPWR VGND sg13g2_fill_2
Xclkbuf_3_2_0_clk_i clkbuf_3_2_0_clk_i/X clkbuf_0_clk_i/X VPWR VGND sg13g2_buf_16
X_12113_ _12113_/Y _12112_/A _12111_/Y _12112_/Y _14039_/A VPWR VGND sg13g2_a22oi_1
XFILLER_6_0 VPWR VGND sg13g2_decap_8
X_13093_ _13093_/Y _14104_/A _13093_/B VPWR VGND sg13g2_nand2_1
XFILLER_2_453 VPWR VGND sg13g2_fill_1
X_12044_ _12045_/B _23707_/Q _23739_/Q _23771_/Q _23803_/Q _11406_/S _12171_/S1 VPWR
+ VGND sg13g2_mux4_1
X_16921_ _22694_/D _16920_/X _17107_/A _16921_/S VPWR VGND sg13g2_mux2_1
XFILLER_49_61 VPWR VGND sg13g2_decap_8
XFILLER_61_1518 VPWR VGND sg13g2_decap_8
X_19640_ _19822_/B _19714_/S _19376_/Y _19639_/Y VPWR VGND sg13g2_a21oi_1
XFILLER_43_1941 VPWR VGND sg13g2_decap_8
XFILLER_77_243 VPWR VGND sg13g2_decap_4
X_16852_ _17044_/D _16852_/A _16852_/B _17034_/D VPWR VGND sg13g2_nor3_1
XFILLER_93_714 VPWR VGND sg13g2_fill_2
XFILLER_65_405 VPWR VGND sg13g2_fill_2
XFILLER_65_416 VPWR VGND sg13g2_decap_8
XFILLER_66_939 VPWR VGND sg13g2_fill_1
XFILLER_1_35 VPWR VGND sg13g2_decap_8
XFILLER_92_213 VPWR VGND sg13g2_decap_8
X_15803_ _15807_/A _22900_/Q _15937_/B VPWR VGND sg13g2_nand2_1
XFILLER_115_1490 VPWR VGND sg13g2_decap_8
X_19571_ _19571_/X _19422_/Y _19431_/Y _19589_/A VPWR VGND sg13g2_mux2_1
X_16783_ _16784_/B _15238_/B _16781_/Y _16782_/Y VPWR VGND sg13g2_a21oi_1
XFILLER_20_1215 VPWR VGND sg13g2_fill_2
X_13995_ _13996_/A _14104_/A _13995_/B VPWR VGND sg13g2_xnor2_1
XFILLER_4_1467 VPWR VGND sg13g2_fill_2
XFILLER_0_1309 VPWR VGND sg13g2_decap_4
X_18522_ _18522_/Y _18562_/A _18522_/B VPWR VGND sg13g2_nand2_1
X_15734_ _15735_/C _15734_/A _15734_/B _15734_/C _15734_/D VPWR VGND sg13g2_and4_1
X_12946_ _12947_/B _14053_/A _12946_/B VPWR VGND sg13g2_nor2_1
XFILLER_65_93 VPWR VGND sg13g2_decap_8
X_18453_ _18453_/X _18301_/A _18178_/Y _18452_/Y VPWR VGND sg13g2_a21o_1
XFILLER_34_847 VPWR VGND sg13g2_fill_1
X_15665_ _15668_/C _15665_/A _15665_/B VPWR VGND sg13g2_nor2_1
XFILLER_2_1191 VPWR VGND sg13g2_fill_2
X_12877_ _12877_/Y _23941_/Q _12877_/B VPWR VGND sg13g2_nand2b_1
XFILLER_60_121 VPWR VGND sg13g2_decap_4
XFILLER_61_655 VPWR VGND sg13g2_fill_1
XFILLER_76_1761 VPWR VGND sg13g2_fill_2
X_14616_ _14616_/Y _14637_/B _23190_/Q VPWR VGND sg13g2_nor2b_1
X_17404_ _22821_/D _17884_/A _17412_/B _17403_/Y VPWR VGND sg13g2_o21ai_1
X_11828_ _11828_/Y _11917_/A _11827_/X _13776_/A1 VPWR VGND sg13g2_o21ai_1
X_18384_ _18384_/Y _18385_/B _18334_/A _18359_/Y VPWR VGND sg13g2_a21oi_1
X_15596_ _15596_/Y _22762_/Q _15991_/A2 _15309_/Y _22494_/Q _15595_/X VPWR VGND sg13g2_a221oi_1
XFILLER_42_880 VPWR VGND sg13g2_decap_8
XFILLER_33_1609 VPWR VGND sg13g2_fill_2
XFILLER_53_1035 VPWR VGND sg13g2_fill_1
X_17335_ _17335_/Y _17335_/A _17341_/B VPWR VGND sg13g2_nand2_1
Xplace4007 _12712_/A _11418_/A VPWR VGND sg13g2_buf_1
XFILLER_18_1155 VPWR VGND sg13g2_decap_8
XFILLER_14_593 VPWR VGND sg13g2_fill_2
XFILLER_37_1778 VPWR VGND sg13g2_decap_8
Xplace4018 _12406_/A _11393_/A VPWR VGND sg13g2_buf_4
Xplace4029 _12126_/A _12557_/S VPWR VGND sg13g2_buf_2
X_11759_ _11760_/B _24152_/Q _24184_/Q _12293_/A VPWR VGND sg13g2_mux2_1
XFILLER_18_1166 VPWR VGND sg13g2_fill_2
XFILLER_14_1008 VPWR VGND sg13g2_fill_2
Xplace3306 _22264_/A1 _19750_/Y VPWR VGND sg13g2_buf_1
Xplace3317 _21617_/A0 _22246_/A0 VPWR VGND sg13g2_buf_1
X_17266_ _17266_/Y _17266_/A _17266_/B VPWR VGND sg13g2_nand2_1
Xplace3328 _22440_/A1 _21343_/A0 VPWR VGND sg13g2_buf_1
X_14478_ _14481_/B _22589_/Q _23000_/Q VPWR VGND sg13g2_xor2_1
Xplace3339 _21960_/A1 _20141_/Y VPWR VGND sg13g2_buf_1
X_16217_ _16217_/Y _16244_/B _19150_/B _16216_/Y _18613_/A VPWR VGND sg13g2_a22oi_1
X_19005_ _23057_/D _18999_/Y _19002_/Y _19003_/Y _19004_/Y VPWR VGND sg13g2_a22oi_1
X_13429_ _13429_/X _13778_/A1 _13923_/A2 _22571_/Q VPWR VGND sg13g2_a21o_1
X_17197_ _17197_/Y _17197_/A _17197_/B VPWR VGND sg13g2_nor2_1
X_16148_ _16150_/A _16148_/A _15775_/B VPWR VGND sg13g2_nor2b_1
XFILLER_115_635 VPWR VGND sg13g2_decap_8
XFILLER_114_112 VPWR VGND sg13g2_decap_8
XFILLER_83_1732 VPWR VGND sg13g2_fill_2
X_16079_ _22490_/D _17386_/B _16076_/Y _16078_/Y VPWR VGND sg13g2_o21ai_1
XFILLER_114_189 VPWR VGND sg13g2_decap_8
XFILLER_83_1765 VPWR VGND sg13g2_decap_4
X_19907_ _19907_/Y _20305_/A _15510_/Y _20201_/B VPWR VGND sg13g2_o21ai_1
XFILLER_9_1356 VPWR VGND sg13g2_fill_1
XFILLER_29_1295 VPWR VGND sg13g2_decap_8
XFILLER_57_906 VPWR VGND sg13g2_decap_8
XFILLER_111_863 VPWR VGND sg13g2_decap_8
XFILLER_84_703 VPWR VGND sg13g2_decap_8
XFILLER_29_608 VPWR VGND sg13g2_decap_8
XFILLER_56_405 VPWR VGND sg13g2_decap_8
XFILLER_96_585 VPWR VGND sg13g2_decap_8
XFILLER_110_395 VPWR VGND sg13g2_decap_8
X_19769_ _19769_/Y _19769_/A _19769_/B VPWR VGND sg13g2_nand2_1
XFILLER_72_909 VPWR VGND sg13g2_fill_1
X_21800_ _21800_/Y _21800_/A _21802_/B VPWR VGND sg13g2_nand2_1
X_22780_ _22780_/Q clkload10/A _22780_/D fanout2814/X VPWR VGND sg13g2_dfrbpq_1
XFILLER_0_1821 VPWR VGND sg13g2_decap_4
XFILLER_37_685 VPWR VGND sg13g2_decap_8
XFILLER_64_471 VPWR VGND sg13g2_fill_2
XFILLER_77_1558 VPWR VGND sg13g2_decap_8
XFILLER_52_633 VPWR VGND sg13g2_decap_8
XFILLER_101_14 VPWR VGND sg13g2_decap_8
XFILLER_77_1569 VPWR VGND sg13g2_fill_2
XFILLER_52_655 VPWR VGND sg13g2_decap_8
XFILLER_52_666 VPWR VGND sg13g2_fill_1
XFILLER_107_1902 VPWR VGND sg13g2_decap_8
X_21662_ _21662_/Y _21662_/A _21666_/B VPWR VGND sg13g2_nand2_1
XFILLER_40_828 VPWR VGND sg13g2_decap_8
XFILLER_94_1894 VPWR VGND sg13g2_decap_8
XFILLER_16_1807 VPWR VGND sg13g2_decap_8
XFILLER_90_1747 VPWR VGND sg13g2_fill_1
X_23401_ _23401_/Q _24205_/CLK _23401_/D fanout2672/X VPWR VGND sg13g2_dfrbpq_1
XFILLER_61_29 VPWR VGND sg13g2_fill_1
X_20613_ _23360_/D _22414_/A1 _20616_/B _20612_/Y VPWR VGND sg13g2_o21ai_1
X_21593_ _23811_/D _21954_/A1 _21600_/B _21592_/Y VPWR VGND sg13g2_o21ai_1
XFILLER_32_1119 VPWR VGND sg13g2_decap_8
Xrebuffer5520 rebuffer5520/X rebuffer5521/X VPWR VGND sg13g2_buf_1
X_23332_ _23332_/Q _24196_/CLK _23332_/D fanout2700/X VPWR VGND sg13g2_dfrbpq_1
X_20544_ _20544_/Y _23328_/Q _20548_/B VPWR VGND sg13g2_nand2_1
Xrebuffer5531 rebuffer5531/X rebuffer5532/X VPWR VGND sg13g2_buf_1
Xrebuffer5542 rebuffer5542/X rebuffer5543/X VPWR VGND sg13g2_buf_1
Xrebuffer5553 rebuffer5553/X rebuffer5554/X VPWR VGND sg13g2_buf_1
Xplace3840 _14686_/A place3840/A VPWR VGND sg13g2_buf_2
Xrebuffer5564 _14944_/A1 _14941_/Y VPWR VGND sg13g2_buf_2
Xplace3851 _18259_/B _18178_/Y VPWR VGND sg13g2_buf_1
XFILLER_14_1575 VPWR VGND sg13g2_decap_4
X_23263_ _23263_/Q _23682_/CLK _23263_/D fanout2725/X VPWR VGND sg13g2_dfrbpq_1
XFILLER_14_1586 VPWR VGND sg13g2_decap_8
Xplace3862 _12413_/B _11736_/A VPWR VGND sg13g2_buf_2
XFILLER_10_1428 VPWR VGND sg13g2_decap_4
XFILLER_4_718 VPWR VGND sg13g2_fill_1
Xhold5210 _20300_/A _23248_/Q VPWR VGND sg13g2_dlygate4sd3_1
Xplace3873 _15718_/S _16029_/B VPWR VGND sg13g2_buf_1
XFILLER_101_1545 VPWR VGND sg13g2_decap_8
Xplace3884 _18856_/B _18823_/B1 VPWR VGND sg13g2_buf_1
Xplace3895 _18385_/A _18264_/A VPWR VGND sg13g2_buf_1
X_22214_ _24095_/D _22280_/A1 _22219_/B _22213_/Y VPWR VGND sg13g2_o21ai_1
XFILLER_105_112 VPWR VGND sg13g2_decap_8
X_23194_ _23194_/Q clkload12/A _23194_/D fanout2913/X VPWR VGND sg13g2_dfrbpq_1
X_22145_ _22145_/Y _22145_/A _22151_/B VPWR VGND sg13g2_nand2_1
XFILLER_79_519 VPWR VGND sg13g2_decap_8
XFILLER_27_1903 VPWR VGND sg13g2_decap_4
XFILLER_27_1925 VPWR VGND sg13g2_decap_8
XFILLER_114_690 VPWR VGND sg13g2_decap_8
X_22076_ _24030_/D _19947_/Y _22075_/B _22075_/Y VPWR VGND sg13g2_o21ai_1
XFILLER_102_841 VPWR VGND sg13g2_fill_2
XFILLER_87_530 VPWR VGND sg13g2_fill_2
XFILLER_86_37 VPWR VGND sg13g2_fill_2
XFILLER_0_957 VPWR VGND sg13g2_fill_2
XFILLER_43_1237 VPWR VGND sg13g2_decap_4
XFILLER_82_1297 VPWR VGND sg13g2_fill_2
XFILLER_19_42 VPWR VGND sg13g2_decap_4
XFILLER_5_1721 VPWR VGND sg13g2_decap_8
XFILLER_48_939 VPWR VGND sg13g2_decap_4
XFILLER_19_53 VPWR VGND sg13g2_fill_1
XFILLER_101_384 VPWR VGND sg13g2_decap_4
XFILLER_19_129 VPWR VGND sg13g2_decap_8
XFILLER_112_1630 VPWR VGND sg13g2_decap_4
XFILLER_25_1682 VPWR VGND sg13g2_decap_8
XFILLER_25_1693 VPWR VGND sg13g2_fill_1
XFILLER_112_1663 VPWR VGND sg13g2_decap_8
XFILLER_95_1603 VPWR VGND sg13g2_fill_2
X_12800_ _12800_/Y _23268_/Q _12802_/B VPWR VGND sg13g2_nand2b_1
X_13780_ _13864_/A _13777_/Y _11993_/A _13779_/Y VPWR VGND sg13g2_a21o_2
XFILLER_5_1798 VPWR VGND sg13g2_decap_8
XFILLER_99_1794 VPWR VGND sg13g2_fill_1
XFILLER_27_151 VPWR VGND sg13g2_decap_8
X_22978_ _22978_/Q clkload16/A _22978_/D fanout2920/X VPWR VGND sg13g2_dfrbpq_1
XFILLER_55_460 VPWR VGND sg13g2_decap_8
XFILLER_74_279 VPWR VGND sg13g2_decap_4
XFILLER_112_1696 VPWR VGND sg13g2_decap_8
XFILLER_21_1579 VPWR VGND sg13g2_fill_2
XFILLER_71_920 VPWR VGND sg13g2_decap_8
X_12731_ _12732_/B _24035_/Q _24067_/Q _24099_/Q _24131_/Q _13275_/S0 _12789_/S VPWR
+ VGND sg13g2_mux4_1
X_21929_ _21929_/Y _23960_/Q _21965_/S VPWR VGND sg13g2_nand2_1
XFILLER_16_858 VPWR VGND sg13g2_decap_4
XFILLER_70_430 VPWR VGND sg13g2_decap_8
XFILLER_15_346 VPWR VGND sg13g2_fill_2
Xinput4430 _18951_/B instr_rdata_i[23] VPWR VGND sg13g2_buf_1
X_15450_ _15451_/C _15446_/Y _16785_/C VPWR VGND sg13g2_nand2b_1
Xinput4441 _19120_/A1 instr_rdata_i[4] VPWR VGND sg13g2_buf_1
XFILLER_73_1923 VPWR VGND sg13g2_decap_8
XFILLER_42_154 VPWR VGND sg13g2_decap_8
X_12662_ _12663_/D _12661_/Y _14129_/A VPWR VGND sg13g2_nand2b_1
Xinput4452 _15969_/A irqs_i[13] VPWR VGND sg13g2_buf_1
XFILLER_30_305 VPWR VGND sg13g2_decap_8
Xinput4463 _14205_/A irqs_i[9] VPWR VGND sg13g2_buf_1
Xclkbuf_leaf_63_clk_i _24212_/CLK clkload0/A VPWR VGND sg13g2_buf_16
XFILLER_30_327 VPWR VGND sg13g2_decap_8
X_14401_ _24238_/D _14273_/Y _14399_/Y _14571_/A VPWR VGND sg13g2_a21oi_1
XFILLER_106_1412 VPWR VGND sg13g2_decap_8
X_11613_ _11614_/B _14629_/A _19235_/B VPWR VGND sg13g2_nor2_1
X_12593_ _12593_/X _12593_/A _12593_/B VPWR VGND sg13g2_or2_1
XFILLER_30_349 VPWR VGND sg13g2_decap_8
X_17120_ _22728_/D _17226_/A _17118_/Y _17119_/Y VPWR VGND sg13g2_a21oi_1
X_14332_ _15245_/D _17034_/A _14359_/C VPWR VGND sg13g2_nand2_1
XFILLER_51_40 VPWR VGND sg13g2_fill_2
X_11544_ _11548_/B _13158_/S _11544_/B VPWR VGND sg13g2_nor2_1
XFILLER_71_1680 VPWR VGND sg13g2_fill_2
X_17051_ _17061_/A _22717_/Q VPWR VGND sg13g2_inv_1
X_14263_ _14263_/Y _14263_/A _24239_/Q VPWR VGND sg13g2_nand2_1
X_11475_ _11475_/Y _11707_/A _11475_/B VPWR VGND sg13g2_nor2_1
XFILLER_104_1180 VPWR VGND sg13g2_decap_8
X_16002_ _16003_/A _22941_/Q _15924_/B _15969_/B _14211_/A VPWR VGND sg13g2_a22oi_1
XFILLER_13_1074 VPWR VGND sg13g2_decap_8
X_13214_ _13215_/D _13889_/B _13213_/X _11951_/A VPWR VGND sg13g2_o21ai_1
XFILLER_100_1044 VPWR VGND sg13g2_decap_8
XFILLER_87_1153 VPWR VGND sg13g2_decap_8
X_14194_ _24218_/D _14194_/A _14194_/B VPWR VGND sg13g2_nor2_1
XFILLER_83_1006 VPWR VGND sg13g2_fill_1
X_13145_ _13146_/D _13145_/A _13145_/B VPWR VGND sg13g2_nor2_1
XFILLER_100_1099 VPWR VGND sg13g2_fill_1
XFILLER_3_784 VPWR VGND sg13g2_decap_4
XFILLER_65_1451 VPWR VGND sg13g2_fill_2
XFILLER_112_649 VPWR VGND sg13g2_decap_8
XFILLER_111_126 VPWR VGND sg13g2_decap_8
XFILLER_80_1916 VPWR VGND sg13g2_fill_2
X_17953_ _17953_/Y _18463_/S _17953_/B VPWR VGND sg13g2_nand2_1
XFILLER_32_7 VPWR VGND sg13g2_decap_8
X_13076_ _13078_/A _13723_/A _13077_/B _13077_/C _13077_/D VPWR VGND sg13g2_and4_1
XFILLER_78_530 VPWR VGND sg13g2_decap_8
XFILLER_65_1484 VPWR VGND sg13g2_fill_2
XFILLER_26_1446 VPWR VGND sg13g2_fill_2
X_12027_ _12028_/B _23739_/Q _23803_/Q _23867_/Q _23963_/Q _11960_/S _12146_/S VPWR
+ VGND sg13g2_mux4_1
X_16904_ _16904_/Y _22691_/Q _16904_/B VPWR VGND sg13g2_xnor2_1
XFILLER_6_1529 VPWR VGND sg13g2_fill_1
X_17884_ _17884_/Y _17884_/A _17917_/B VPWR VGND sg13g2_nor2_1
XFILLER_113_1427 VPWR VGND sg13g2_fill_1
XFILLER_65_202 VPWR VGND sg13g2_decap_4
XFILLER_38_427 VPWR VGND sg13g2_fill_2
XFILLER_93_522 VPWR VGND sg13g2_fill_1
X_19623_ _19623_/Y _19850_/A _19623_/B VPWR VGND sg13g2_nor2_1
X_16835_ _16835_/Y _16846_/A _16835_/B VPWR VGND sg13g2_nand2_1
Xclkbuf_leaf_16_clk_i _22733_/CLK clkbuf_4_5__f_clk_i/X VPWR VGND sg13g2_buf_16
XFILLER_20_1001 VPWR VGND sg13g2_fill_1
XFILLER_38_449 VPWR VGND sg13g2_fill_2
XFILLER_66_758 VPWR VGND sg13g2_decap_8
XFILLER_43_1793 VPWR VGND sg13g2_decap_4
XFILLER_54_909 VPWR VGND sg13g2_decap_8
XFILLER_47_950 VPWR VGND sg13g2_fill_1
X_19554_ _20028_/B _19552_/X _19553_/X _19712_/B VPWR VGND sg13g2_mux2_1
XFILLER_81_717 VPWR VGND sg13g2_decap_4
XFILLER_20_1034 VPWR VGND sg13g2_fill_1
X_16766_ _16767_/B _22668_/Q _22667_/Q _16770_/D VPWR VGND sg13g2_nand3_1
XFILLER_81_728 VPWR VGND sg13g2_fill_1
X_13978_ _13978_/X _24180_/Q _24212_/Q _23316_/Q _23348_/Q _13978_/S0 _13978_/S1 VPWR
+ VGND sg13g2_mux4_1
XFILLER_94_1113 VPWR VGND sg13g2_fill_2
X_18505_ _18505_/Y _18514_/A _18497_/Y _18500_/Y _18504_/A _18504_/Y VPWR VGND sg13g2_a221oi_1
XFILLER_111_1195 VPWR VGND sg13g2_decap_8
XFILLER_20_1078 VPWR VGND sg13g2_decap_8
X_15717_ _15717_/X _17147_/A _22468_/Q _16000_/S VPWR VGND sg13g2_mux2_1
X_16697_ _22654_/D _16048_/X _16707_/A _16696_/Y VPWR VGND sg13g2_a21oi_1
X_19485_ _19767_/A _19719_/A _19735_/B VPWR VGND sg13g2_nor2_1
XFILLER_62_953 VPWR VGND sg13g2_fill_2
XFILLER_22_806 VPWR VGND sg13g2_fill_2
X_18436_ _18436_/Y _18530_/A _18406_/B _18435_/X _18332_/B VPWR VGND sg13g2_a22oi_1
X_15648_ _15649_/D _15647_/Y _15667_/B VPWR VGND sg13g2_nand2b_1
XFILLER_15_880 VPWR VGND sg13g2_decap_8
X_18367_ _18367_/Y _18253_/B _18360_/Y _18366_/Y VPWR VGND sg13g2_o21ai_1
X_15579_ _15584_/A _22837_/Q _17399_/B _17517_/B _15572_/Y _15578_/Y VPWR VGND sg13g2_a221oi_1
XFILLER_14_390 VPWR VGND sg13g2_decap_8
XFILLER_72_1466 VPWR VGND sg13g2_decap_8
XFILLER_37_1597 VPWR VGND sg13g2_decap_8
X_17318_ _22787_/D _16063_/A _17321_/B _17317_/Y VPWR VGND sg13g2_o21ai_1
XFILLER_33_1439 VPWR VGND sg13g2_fill_2
Xplace3103 _21367_/B _21416_/B VPWR VGND sg13g2_buf_1
Xplace3114 _21330_/B _21332_/B VPWR VGND sg13g2_buf_1
X_18298_ _18299_/C _18465_/B _18297_/Y _18539_/A VPWR VGND sg13g2_a21oi_1
Xplace3125 _21042_/B _21019_/B VPWR VGND sg13g2_buf_1
Xplace3136 _20962_/B _20971_/B VPWR VGND sg13g2_buf_1
Xplace3147 _20809_/B _20801_/B VPWR VGND sg13g2_buf_1
X_17249_ _22755_/D _16063_/A _17252_/B _17248_/Y VPWR VGND sg13g2_o21ai_1
XFILLER_89_1941 VPWR VGND sg13g2_decap_8
Xplace3158 _20742_/B _20738_/B VPWR VGND sg13g2_buf_1
Xplace3169 _20616_/B _20624_/B VPWR VGND sg13g2_buf_1
X_20260_ _20260_/Y _20260_/A _20260_/B VPWR VGND sg13g2_nand2_1
XFILLER_115_432 VPWR VGND sg13g2_decap_8
XFILLER_102_1898 VPWR VGND sg13g2_decap_8
X_20191_ _20191_/X _20316_/A3 _23218_/Q _20316_/A2 _20316_/A1 _20224_/A _20316_/S0
+ VPWR VGND sg13g2_mux4_1
XFILLER_66_1259 VPWR VGND sg13g2_decap_8
XFILLER_9_1131 VPWR VGND sg13g2_decap_4
XFILLER_48_1682 VPWR VGND sg13g2_decap_8
XFILLER_102_137 VPWR VGND sg13g2_decap_8
XFILLER_48_1693 VPWR VGND sg13g2_fill_1
X_23950_ _23950_/Q clkload36/A _23950_/D fanout2643/X VPWR VGND sg13g2_dfrbpq_1
XFILLER_69_563 VPWR VGND sg13g2_decap_4
XFILLER_111_660 VPWR VGND sg13g2_decap_8
XFILLER_5_1006 VPWR VGND sg13g2_decap_8
XFILLER_69_574 VPWR VGND sg13g2_decap_8
XFILLER_22_1800 VPWR VGND sg13g2_decap_8
XFILLER_99_1024 VPWR VGND sg13g2_decap_4
X_22901_ _22901_/Q clkload8/A _22901_/D fanout2799/X VPWR VGND sg13g2_dfrbpq_1
XFILLER_22_1822 VPWR VGND sg13g2_fill_1
XFILLER_61_1871 VPWR VGND sg13g2_fill_2
X_23881_ _23881_/Q _24113_/CLK _23881_/D fanout2682/X VPWR VGND sg13g2_dfrbpq_1
XFILLER_57_758 VPWR VGND sg13g2_decap_8
XFILLER_56_246 VPWR VGND sg13g2_fill_1
XFILLER_72_706 VPWR VGND sg13g2_fill_2
X_22832_ _22832_/Q _22869_/CLK _22832_/D fanout2796/X VPWR VGND sg13g2_dfrbpq_1
XFILLER_112_35 VPWR VGND sg13g2_decap_8
XFILLER_38_994 VPWR VGND sg13g2_fill_1
XFILLER_53_931 VPWR VGND sg13g2_decap_8
XFILLER_65_791 VPWR VGND sg13g2_decap_8
XFILLER_71_227 VPWR VGND sg13g2_fill_2
XFILLER_37_493 VPWR VGND sg13g2_fill_2
X_22763_ _22763_/Q _22893_/CLK _22763_/D fanout2819/X VPWR VGND sg13g2_dfrbpq_1
XFILLER_25_666 VPWR VGND sg13g2_decap_4
X_21714_ _23866_/D _21934_/A1 _21713_/B _21713_/Y VPWR VGND sg13g2_o21ai_1
XFILLER_13_817 VPWR VGND sg13g2_fill_2
X_22694_ _22694_/Q clkload22/A _22694_/D fanout2884/X VPWR VGND sg13g2_dfrbpq_1
XFILLER_13_839 VPWR VGND sg13g2_fill_1
XFILLER_94_1691 VPWR VGND sg13g2_decap_4
XFILLER_36_1030 VPWR VGND sg13g2_fill_2
XFILLER_40_647 VPWR VGND sg13g2_fill_1
X_21645_ _23836_/D _21938_/A1 _21648_/B _21644_/Y VPWR VGND sg13g2_o21ai_1
XFILLER_36_1052 VPWR VGND sg13g2_decap_8
XFILLER_8_309 VPWR VGND sg13g2_decap_8
X_21576_ _21576_/Y _21576_/A _21581_/B VPWR VGND sg13g2_nand2_1
XFILLER_20_371 VPWR VGND sg13g2_decap_8
XFILLER_33_1951 VPWR VGND sg13g2_decap_4
X_23315_ _23315_/Q clkload50/A _23315_/D fanout2661/X VPWR VGND sg13g2_dfrbpq_1
Xrebuffer5350 place3057/A _21918_/Y VPWR VGND sg13g2_buf_2
X_20527_ _23320_/D _19750_/Y _20533_/B _20526_/Y VPWR VGND sg13g2_o21ai_1
Xrebuffer5361 _12294_/B1 _11740_/Y VPWR VGND sg13g2_buf_1
Xrebuffer5372 _12697_/B _12836_/B VPWR VGND sg13g2_buf_1
XFILLER_101_1320 VPWR VGND sg13g2_fill_1
XFILLER_107_922 VPWR VGND sg13g2_decap_4
Xrebuffer5383 _12936_/C _12864_/Y VPWR VGND sg13g2_buf_1
Xplace3670 _15901_/A2 _15946_/A2 VPWR VGND sg13g2_buf_1
XFILLER_88_1451 VPWR VGND sg13g2_decap_8
XFILLER_101_1353 VPWR VGND sg13g2_decap_4
Xplace3681 _15300_/A _19777_/A VPWR VGND sg13g2_buf_1
X_23246_ _23246_/Q clkload38/A _23246_/D fanout2630/X VPWR VGND sg13g2_dfrbpq_1
Xplace3692 _20356_/B _19861_/B VPWR VGND sg13g2_buf_1
XFILLER_4_537 VPWR VGND sg13g2_decap_4
X_20458_ _20458_/Y _20458_/A _20458_/B VPWR VGND sg13g2_nand2_1
Xhold5040 _22355_/A _24164_/Q VPWR VGND sg13g2_dlygate4sd3_1
XFILLER_97_14 VPWR VGND sg13g2_decap_8
XFILLER_84_1315 VPWR VGND sg13g2_decap_4
Xplace2980 _18535_/B _18096_/C VPWR VGND sg13g2_buf_1
Xhold5051 _20990_/A _23540_/Q VPWR VGND sg13g2_dlygate4sd3_1
Xhold5062 _21814_/A _23904_/Q VPWR VGND sg13g2_dlygate4sd3_1
Xhold5073 _20484_/A _23303_/Q VPWR VGND sg13g2_dlygate4sd3_1
Xplace2991 _19045_/C _18957_/C VPWR VGND sg13g2_buf_1
X_23177_ _23177_/Q clkload17/A _23177_/D fanout2858/X VPWR VGND sg13g2_dfrbpq_1
X_11191_ _14240_/A _11316_/B _11315_/D _14121_/B VPWR VGND sg13g2_and3_2
X_20389_ _23259_/D _22403_/A1 _20388_/B _20388_/Y VPWR VGND sg13g2_o21ai_1
Xhold5084 _20839_/A _23467_/Q VPWR VGND sg13g2_dlygate4sd3_1
XFILLER_49_1468 VPWR VGND sg13g2_decap_4
Xhold5095 _19223_/A _23178_/Q VPWR VGND sg13g2_dlygate4sd3_1
X_22128_ _24055_/D _22262_/A1 _22129_/B _22127_/Y VPWR VGND sg13g2_o21ai_1
XFILLER_27_1733 VPWR VGND sg13g2_fill_2
XFILLER_95_809 VPWR VGND sg13g2_decap_8
XFILLER_7_1827 VPWR VGND sg13g2_decap_8
X_14950_ _16278_/B _17879_/A1 _14966_/B _18635_/A2 _14950_/B2 _14949_/Y VPWR VGND
+ sg13g2_a221oi_1
XFILLER_47_1192 VPWR VGND sg13g2_decap_8
X_22059_ _24022_/D _22260_/A1 _22065_/B _22058_/Y VPWR VGND sg13g2_o21ai_1
X_13901_ _13902_/B _13897_/X _13898_/X _13899_/X _13900_/X _13794_/S _13141_/B VPWR
+ VGND sg13g2_mux4_1
XFILLER_40_1911 VPWR VGND sg13g2_decap_8
XFILLER_5_1540 VPWR VGND sg13g2_decap_8
X_14881_ _18636_/A _17859_/A1 _14801_/B _14949_/A VPWR VGND sg13g2_o21ai_1
XFILLER_36_909 VPWR VGND sg13g2_decap_8
XFILLER_78_1108 VPWR VGND sg13g2_decap_4
XFILLER_29_961 VPWR VGND sg13g2_decap_8
X_13832_ _13832_/X _24050_/Q _24082_/Q _24114_/Q _24146_/Q _13840_/S0 _13955_/S VPWR
+ VGND sg13g2_mux4_1
X_16620_ _16621_/B _22639_/Q _16620_/B VPWR VGND sg13g2_xnor2_1
XFILLER_95_1411 VPWR VGND sg13g2_fill_1
XFILLER_16_600 VPWR VGND sg13g2_decap_4
XFILLER_56_780 VPWR VGND sg13g2_fill_2
XFILLER_62_216 VPWR VGND sg13g2_decap_8
X_16551_ _16552_/B _16559_/C _16564_/D VPWR VGND sg13g2_nand2_1
XFILLER_46_84 VPWR VGND sg13g2_decap_4
X_13763_ _13763_/X _23729_/Q _23761_/Q _23793_/Q _23825_/Q _13773_/S0 _13765_/S1 VPWR
+ VGND sg13g2_mux4_1
XFILLER_16_633 VPWR VGND sg13g2_decap_8
XFILLER_56_1406 VPWR VGND sg13g2_fill_2
X_15502_ _15503_/C _22459_/Q _15575_/B _17234_/A _22758_/Q VPWR VGND sg13g2_a22oi_1
X_12714_ _12714_/X _23587_/Q _23619_/Q _23651_/Q _23683_/Q _13004_/S0 _13004_/S1 VPWR
+ VGND sg13g2_mux4_1
XFILLER_108_1507 VPWR VGND sg13g2_decap_8
X_19270_ _19270_/Y _19265_/A _19269_/Y _23194_/Q VPWR VGND sg13g2_o21ai_1
X_16482_ _16482_/Y _22604_/Q _16495_/S VPWR VGND sg13g2_nand2_1
XFILLER_31_625 VPWR VGND sg13g2_decap_8
XFILLER_31_636 VPWR VGND sg13g2_fill_1
X_15433_ _15434_/C _15187_/C _15432_/Y _17034_/C VPWR VGND sg13g2_a21oi_1
XFILLER_19_1250 VPWR VGND sg13g2_decap_8
XFILLER_30_113 VPWR VGND sg13g2_decap_4
XFILLER_34_1704 VPWR VGND sg13g2_decap_8
X_18221_ _22968_/D _18220_/Y _11311_/B _18221_/S VPWR VGND sg13g2_mux2_1
X_12645_ _12663_/B _13611_/A _12645_/B VPWR VGND sg13g2_or2_1
XFILLER_31_658 VPWR VGND sg13g2_decap_4
XFILLER_106_1242 VPWR VGND sg13g2_decap_8
X_15364_ _15365_/D _22843_/Q _16005_/B _15309_/Y _22485_/Q VPWR VGND sg13g2_a22oi_1
XFILLER_30_179 VPWR VGND sg13g2_decap_8
XFILLER_54_1196 VPWR VGND sg13g2_decap_4
XFILLER_15_1158 VPWR VGND sg13g2_decap_8
XFILLER_8_843 VPWR VGND sg13g2_decap_8
XFILLER_50_1038 VPWR VGND sg13g2_decap_8
X_14315_ _14316_/C _15289_/A _19728_/A _14336_/C VPWR VGND sg13g2_nand3_1
X_17103_ _22725_/D _17092_/B _17101_/Y _17102_/Y VPWR VGND sg13g2_a21oi_1
X_18083_ _22944_/D _18082_/Y _22944_/Q _18140_/B VPWR VGND sg13g2_mux2_1
XFILLER_7_353 VPWR VGND sg13g2_decap_8
XFILLER_32_1472 VPWR VGND sg13g2_fill_1
X_17034_ _17222_/C _17034_/A _17034_/B _17034_/C _17034_/D VPWR VGND sg13g2_or4_1
XFILLER_7_375 VPWR VGND sg13g2_decap_8
X_14246_ _14246_/Y _14246_/A VPWR VGND sg13g2_inv_1
X_11458_ _11458_/Y _12123_/A _23542_/Q VPWR VGND sg13g2_nand2_1
XFILLER_67_1524 VPWR VGND sg13g2_decap_4
XFILLER_28_1508 VPWR VGND sg13g2_decap_8
X_14177_ _14187_/A _14193_/B VPWR VGND sg13g2_inv_1
XFILLER_113_925 VPWR VGND sg13g2_fill_1
X_11389_ _11390_/B _11919_/S _23542_/Q _13774_/A VPWR VGND sg13g2_a21oi_1
XFILLER_10_1781 VPWR VGND sg13g2_decap_8
XFILLER_97_113 VPWR VGND sg13g2_decap_8
X_13128_ _13128_/X _23560_/Q _24008_/Q _13466_/A VPWR VGND sg13g2_mux2_1
X_18985_ _18986_/C _19047_/A _23088_/Q VPWR VGND sg13g2_nand2_1
XFILLER_98_669 VPWR VGND sg13g2_fill_2
XFILLER_79_850 VPWR VGND sg13g2_fill_1
XFILLER_61_1112 VPWR VGND sg13g2_decap_8
X_17936_ _17937_/B _19235_/C _14241_/D _16858_/A VPWR VGND sg13g2_a21oi_1
X_13059_ _13059_/Y _13070_/B VPWR VGND sg13g2_inv_1
XFILLER_94_820 VPWR VGND sg13g2_decap_8
XFILLER_79_894 VPWR VGND sg13g2_fill_2
XFILLER_113_1224 VPWR VGND sg13g2_decap_8
XFILLER_66_522 VPWR VGND sg13g2_decap_8
XFILLER_94_842 VPWR VGND sg13g2_fill_1
X_17867_ _17868_/A _17867_/A1 _17926_/A2 _17927_/B _22920_/Q _17866_/Y VPWR VGND sg13g2_a221oi_1
XFILLER_39_769 VPWR VGND sg13g2_decap_4
X_19606_ _19606_/Y _19607_/A1 _20229_/A _19605_/Y VPWR VGND sg13g2_o21ai_1
X_16818_ _16818_/Y _16818_/A _16818_/B VPWR VGND sg13g2_nor2_1
X_17798_ _17806_/A _22576_/Q VPWR VGND sg13g2_inv_1
XFILLER_66_599 VPWR VGND sg13g2_decap_8
XFILLER_19_471 VPWR VGND sg13g2_decap_8
X_16749_ _16750_/B _22664_/Q _16753_/C VPWR VGND sg13g2_nand2_1
XFILLER_34_441 VPWR VGND sg13g2_fill_2
XFILLER_50_901 VPWR VGND sg13g2_decap_8
X_19468_ _19468_/Y _20080_/A _19468_/B _19468_/C VPWR VGND sg13g2_nand3_1
XFILLER_59_1096 VPWR VGND sg13g2_decap_4
XFILLER_62_794 VPWR VGND sg13g2_fill_2
XFILLER_17_1913 VPWR VGND sg13g2_decap_8
XFILLER_21_124 VPWR VGND sg13g2_decap_8
X_18419_ _18419_/Y _18415_/Y _18418_/Y _18172_/Y VPWR VGND sg13g2_a21oi_1
XFILLER_22_658 VPWR VGND sg13g2_fill_1
XFILLER_107_1039 VPWR VGND sg13g2_decap_8
X_19399_ _19399_/Y _19399_/A _19986_/A VPWR VGND sg13g2_nand2_1
XFILLER_22_669 VPWR VGND sg13g2_decap_8
XFILLER_91_1875 VPWR VGND sg13g2_fill_1
XFILLER_91_1886 VPWR VGND sg13g2_decap_4
XFILLER_33_1214 VPWR VGND sg13g2_decap_4
X_21430_ _21430_/Y _23734_/Q _21430_/B VPWR VGND sg13g2_nand2_1
XFILLER_21_179 VPWR VGND sg13g2_decap_4
X_21361_ _21361_/Y _21361_/A _21363_/B VPWR VGND sg13g2_nand2_1
XFILLER_11_1501 VPWR VGND sg13g2_decap_4
X_23100_ _23100_/Q _23114_/CLK _23100_/D fanout2903/X VPWR VGND sg13g2_dfrbpq_1
X_20312_ _20312_/Y _20302_/X _20309_/Y _20311_/Y VPWR VGND sg13g2_o21ai_1
X_24080_ _24080_/Q _24210_/CLK _24080_/D fanout2634/X VPWR VGND sg13g2_dfrbpq_1
XFILLER_102_1684 VPWR VGND sg13g2_decap_8
XFILLER_11_1578 VPWR VGND sg13g2_decap_8
X_23031_ _23031_/Q clkload17/A _23031_/D fanout2847/X VPWR VGND sg13g2_dfrbpq_1
X_20243_ _20243_/Y _20243_/A _20243_/B VPWR VGND sg13g2_nand2_1
XFILLER_66_1023 VPWR VGND sg13g2_decap_4
XFILLER_85_1668 VPWR VGND sg13g2_fill_1
XFILLER_66_1045 VPWR VGND sg13g2_decap_8
XFILLER_115_273 VPWR VGND sg13g2_decap_8
XFILLER_107_35 VPWR VGND sg13g2_decap_8
XFILLER_103_413 VPWR VGND sg13g2_decap_8
XFILLER_66_1056 VPWR VGND sg13g2_fill_1
XFILLER_89_669 VPWR VGND sg13g2_decap_4
XFILLER_88_146 VPWR VGND sg13g2_decap_4
XFILLER_83_1381 VPWR VGND sg13g2_fill_1
XFILLER_76_308 VPWR VGND sg13g2_decap_4
XFILLER_57_500 VPWR VGND sg13g2_decap_8
XFILLER_40_1207 VPWR VGND sg13g2_decap_4
XFILLER_57_522 VPWR VGND sg13g2_fill_2
X_23933_ _23933_/Q _23966_/CLK _23933_/D fanout2786/X VPWR VGND sg13g2_dfrbpq_1
XFILLER_29_235 VPWR VGND sg13g2_decap_8
XFILLER_6_1882 VPWR VGND sg13g2_decap_8
XFILLER_72_503 VPWR VGND sg13g2_fill_1
X_23864_ _23864_/Q _24113_/CLK _23864_/D fanout2690/X VPWR VGND sg13g2_dfrbpq_1
XFILLER_17_419 VPWR VGND sg13g2_fill_2
XFILLER_29_279 VPWR VGND sg13g2_fill_2
XFILLER_113_1780 VPWR VGND sg13g2_decap_8
XFILLER_44_216 VPWR VGND sg13g2_fill_1
XFILLER_84_396 VPWR VGND sg13g2_decap_8
XFILLER_2_1757 VPWR VGND sg13g2_decap_8
XFILLER_77_1130 VPWR VGND sg13g2_decap_8
X_22815_ _22815_/Q _22917_/CLK _22815_/D fanout2892/X VPWR VGND sg13g2_dfrbpq_1
X_23795_ _23795_/Q clkload51/A _23795_/D fanout2666/X VPWR VGND sg13g2_dfrbpq_1
XFILLER_92_1606 VPWR VGND sg13g2_fill_1
XFILLER_38_1103 VPWR VGND sg13g2_decap_4
XFILLER_57_1726 VPWR VGND sg13g2_decap_8
XFILLER_26_986 VPWR VGND sg13g2_decap_8
XFILLER_53_772 VPWR VGND sg13g2_decap_8
X_22746_ _22746_/Q clkload21/A _22746_/D fanout2874/X VPWR VGND sg13g2_dfrbpq_1
XFILLER_109_1827 VPWR VGND sg13g2_decap_8
XFILLER_40_400 VPWR VGND sg13g2_fill_2
XFILLER_52_260 VPWR VGND sg13g2_fill_2
XFILLER_80_580 VPWR VGND sg13g2_fill_1
XFILLER_12_102 VPWR VGND sg13g2_decap_8
XFILLER_38_1147 VPWR VGND sg13g2_decap_8
XFILLER_12_124 VPWR VGND sg13g2_decap_8
X_22677_ _22677_/Q clkload20/A _22677_/D fanout2867/X VPWR VGND sg13g2_dfrbpq_1
XFILLER_107_1540 VPWR VGND sg13g2_fill_1
X_12430_ _12438_/B _12181_/A _15491_/A _12428_/Y _12429_/Y VPWR VGND sg13g2_a22oi_1
XFILLER_8_117 VPWR VGND sg13g2_decap_8
XFILLER_107_1562 VPWR VGND sg13g2_decap_4
XFILLER_32_64 VPWR VGND sg13g2_fill_1
XFILLER_16_1489 VPWR VGND sg13g2_decap_8
X_12361_ _12385_/A _12730_/S _12358_/Y _12360_/Y VPWR VGND sg13g2_a21oi_1
Xplace4190 _12193_/S _12191_/S VPWR VGND sg13g2_buf_4
X_14100_ _14100_/Y _19494_/B VPWR VGND sg13g2_inv_1
X_11312_ _11314_/B _14461_/A _14461_/B _11312_/C VPWR VGND sg13g2_nor3_1
XFILLER_68_1800 VPWR VGND sg13g2_decap_8
X_15080_ _18732_/A _15080_/A _15080_/B VPWR VGND sg13g2_nor2_1
X_12292_ _12292_/X _23902_/Q _23998_/Q _12293_/A VPWR VGND sg13g2_mux2_1
XFILLER_107_741 VPWR VGND sg13g2_decap_8
XFILLER_4_334 VPWR VGND sg13g2_decap_8
XFILLER_107_752 VPWR VGND sg13g2_fill_1
XFILLER_106_0 VPWR VGND sg13g2_decap_8
X_14031_ _14031_/Y _14032_/A _14032_/B _14032_/C VPWR VGND sg13g2_nor3_1
X_11243_ _12551_/B _11243_/A _11243_/B _14240_/A _11243_/D VPWR VGND sg13g2_nor4_2
X_23229_ _23229_/Q _24190_/CLK _23229_/D fanout2773/X VPWR VGND sg13g2_dfrbpq_1
XFILLER_84_1145 VPWR VGND sg13g2_fill_2
XFILLER_29_1839 VPWR VGND sg13g2_decap_8
XFILLER_49_1265 VPWR VGND sg13g2_decap_8
XFILLER_64_1719 VPWR VGND sg13g2_decap_4
X_11174_ _14459_/A _19268_/A _23192_/Q _19261_/B VPWR VGND sg13g2_or3_1
XFILLER_7_1613 VPWR VGND sg13g2_decap_4
XFILLER_79_179 VPWR VGND sg13g2_decap_8
X_18770_ _18776_/B _18765_/Y _18769_/Y _18824_/S VPWR VGND sg13g2_mux2_1
XFILLER_67_319 VPWR VGND sg13g2_decap_8
XFILLER_94_105 VPWR VGND sg13g2_fill_2
X_15982_ _16205_/A _23028_/Q _22578_/Q _15982_/S VPWR VGND sg13g2_mux2_1
X_17721_ _17721_/Y _22895_/Q _17721_/B VPWR VGND sg13g2_nor2_1
X_14933_ _14933_/X _23136_/Q _16320_/A _14933_/S VPWR VGND sg13g2_mux2_1
XFILLER_62_1487 VPWR VGND sg13g2_decap_8
XFILLER_87_190 VPWR VGND sg13g2_decap_8
XFILLER_75_330 VPWR VGND sg13g2_decap_8
XFILLER_114_1577 VPWR VGND sg13g2_fill_1
XFILLER_76_875 VPWR VGND sg13g2_decap_8
XFILLER_48_588 VPWR VGND sg13g2_fill_2
X_17652_ _17652_/Y _22888_/Q _17652_/B VPWR VGND sg13g2_nor2_1
X_14864_ _14866_/A _14862_/Y _14863_/Y _14774_/X VPWR VGND sg13g2_o21ai_1
XFILLER_75_374 VPWR VGND sg13g2_fill_1
XFILLER_63_525 VPWR VGND sg13g2_decap_4
XFILLER_91_845 VPWR VGND sg13g2_decap_8
X_16603_ _22635_/D _17476_/A1 _16610_/A _16602_/Y VPWR VGND sg13g2_a21oi_1
X_13815_ _13815_/Y _14129_/D _23570_/Q _13974_/S VPWR VGND sg13g2_nand3_1
XFILLER_90_344 VPWR VGND sg13g2_fill_1
X_17583_ _17583_/Y _17583_/A VPWR VGND sg13g2_inv_1
XFILLER_44_750 VPWR VGND sg13g2_decap_4
XFILLER_51_709 VPWR VGND sg13g2_fill_2
XFILLER_32_901 VPWR VGND sg13g2_decap_8
XFILLER_56_1203 VPWR VGND sg13g2_decap_8
X_19322_ _19762_/A _19322_/A _19437_/B VPWR VGND sg13g2_xnor2_1
XFILLER_44_761 VPWR VGND sg13g2_fill_2
XFILLER_56_1214 VPWR VGND sg13g2_fill_1
XFILLER_73_60 VPWR VGND sg13g2_fill_2
X_16534_ _16534_/Y _16547_/A _16534_/B VPWR VGND sg13g2_nor2_1
XFILLER_44_772 VPWR VGND sg13g2_fill_1
X_13746_ _13747_/B _13753_/A _13753_/B VPWR VGND sg13g2_or2_1
XFILLER_43_260 VPWR VGND sg13g2_fill_2
XFILLER_16_485 VPWR VGND sg13g2_decap_8
XFILLER_16_496 VPWR VGND sg13g2_fill_2
XFILLER_108_1337 VPWR VGND sg13g2_fill_2
X_19253_ _19268_/B _19253_/A _19252_/Y VPWR VGND sg13g2_nor2b_1
XFILLER_108_1348 VPWR VGND sg13g2_fill_1
X_13677_ _13677_/Y _13676_/B _23504_/Q _13676_/Y VPWR VGND sg13g2_o21ai_1
XFILLER_38_1670 VPWR VGND sg13g2_decap_8
X_16465_ _16465_/Y _22596_/Q _16472_/B VPWR VGND sg13g2_nand2_1
XFILLER_38_1681 VPWR VGND sg13g2_fill_1
X_18204_ _18377_/A _18498_/A _18498_/B VPWR VGND sg13g2_nand2_1
XFILLER_38_1692 VPWR VGND sg13g2_decap_8
XFILLER_31_477 VPWR VGND sg13g2_fill_1
X_15416_ _16060_/A _23002_/Q _22552_/Q _15591_/S VPWR VGND sg13g2_mux2_1
X_12628_ _19983_/A _12628_/A1 _12628_/A2 _12463_/Y VPWR VGND sg13g2_a21o_1
X_19184_ _23154_/D _23154_/Q _15111_/X _19185_/S VPWR VGND sg13g2_mux2_1
X_16396_ _22565_/D _23015_/Q _22565_/Q _16421_/S VPWR VGND sg13g2_mux2_1
XFILLER_12_691 VPWR VGND sg13g2_decap_8
X_18135_ _18135_/Y _18135_/A _18524_/B VPWR VGND sg13g2_nand2_1
X_15347_ _15347_/Y _15482_/A _15359_/A VPWR VGND sg13g2_nor2_1
X_15278_ _22452_/D _16046_/A _15273_/X _15497_/S VPWR VGND sg13g2_mux2_1
XFILLER_12_1876 VPWR VGND sg13g2_decap_8
X_14229_ _14229_/Y _14229_/A _14851_/B VPWR VGND sg13g2_nor2_2
X_17017_ _22712_/D _16946_/S _17015_/Y _17016_/Y VPWR VGND sg13g2_o21ai_1
XFILLER_28_1305 VPWR VGND sg13g2_decap_4
XFILLER_113_722 VPWR VGND sg13g2_decap_8
XFILLER_112_210 VPWR VGND sg13g2_decap_8
XFILLER_63_1207 VPWR VGND sg13g2_decap_8
XFILLER_63_1218 VPWR VGND sg13g2_fill_2
XFILLER_63_1229 VPWR VGND sg13g2_fill_1
XFILLER_86_628 VPWR VGND sg13g2_fill_2
XFILLER_113_799 VPWR VGND sg13g2_decap_8
X_18968_ _18969_/C _23054_/Q _19003_/A _19001_/C VPWR VGND sg13g2_or3_1
XFILLER_39_500 VPWR VGND sg13g2_decap_8
XFILLER_21_0 VPWR VGND sg13g2_decap_8
XFILLER_100_427 VPWR VGND sg13g2_decap_8
XFILLER_113_1010 VPWR VGND sg13g2_decap_4
XFILLER_112_298 VPWR VGND sg13g2_decap_8
XFILLER_100_438 VPWR VGND sg13g2_fill_1
XFILLER_100_449 VPWR VGND sg13g2_decap_8
X_17919_ _22937_/D _17919_/A VPWR VGND sg13g2_inv_1
XFILLER_67_842 VPWR VGND sg13g2_decap_8
X_18899_ _18899_/Y _18899_/A _18899_/B VPWR VGND sg13g2_nand2_1
XFILLER_39_555 VPWR VGND sg13g2_decap_8
XFILLER_27_706 VPWR VGND sg13g2_fill_1
X_20930_ _20930_/Y _23511_/Q _20930_/B VPWR VGND sg13g2_nand2_1
XFILLER_94_683 VPWR VGND sg13g2_decap_8
XFILLER_39_588 VPWR VGND sg13g2_fill_2
XFILLER_81_322 VPWR VGND sg13g2_decap_8
X_20861_ _23477_/D _20927_/A1 _20902_/S _20860_/Y VPWR VGND sg13g2_o21ai_1
XFILLER_39_1401 VPWR VGND sg13g2_decap_4
XFILLER_54_569 VPWR VGND sg13g2_decap_4
XFILLER_81_366 VPWR VGND sg13g2_decap_8
X_22600_ _22600_/Q clkload18/A _22600_/D fanout2820/X VPWR VGND sg13g2_dfrbpq_1
X_23580_ _23580_/Q clkload53/A _23580_/D fanout2782/X VPWR VGND sg13g2_dfrbpq_1
XFILLER_93_1948 VPWR VGND sg13g2_decap_8
XFILLER_78_1494 VPWR VGND sg13g2_decap_8
XFILLER_39_1445 VPWR VGND sg13g2_decap_8
X_20792_ _20792_/Y _20792_/A _20794_/B VPWR VGND sg13g2_nand2_1
XFILLER_81_399 VPWR VGND sg13g2_fill_2
XFILLER_1_1790 VPWR VGND sg13g2_decap_8
XFILLER_34_260 VPWR VGND sg13g2_decap_4
XFILLER_39_1456 VPWR VGND sg13g2_fill_2
XFILLER_74_1336 VPWR VGND sg13g2_fill_1
XFILLER_39_1467 VPWR VGND sg13g2_fill_2
XFILLER_62_591 VPWR VGND sg13g2_decap_8
X_22531_ _22531_/Q _22941_/CLK _22531_/D fanout2803/X VPWR VGND sg13g2_dfrbpq_1
XFILLER_17_1710 VPWR VGND sg13g2_fill_1
XFILLER_50_764 VPWR VGND sg13g2_fill_1
XFILLER_52_1623 VPWR VGND sg13g2_decap_4
XFILLER_50_786 VPWR VGND sg13g2_fill_2
X_22462_ _22462_/Q clkload26/A _22462_/D fanout2829/X VPWR VGND sg13g2_dfrbpq_1
XFILLER_72_1082 VPWR VGND sg13g2_fill_2
X_24201_ _24201_/Q _24205_/CLK _24201_/D fanout2672/X VPWR VGND sg13g2_dfrbpq_1
X_21413_ _21413_/Y _21413_/A _21416_/B VPWR VGND sg13g2_nand2_1
X_22393_ _22393_/Y _24183_/Q _22393_/B VPWR VGND sg13g2_nand2_1
XFILLER_108_538 VPWR VGND sg13g2_decap_8
X_24132_ _24132_/Q clkload45/A _24132_/D fanout2716/X VPWR VGND sg13g2_dfrbpq_1
XFILLER_68_1107 VPWR VGND sg13g2_fill_1
XFILLER_50_1380 VPWR VGND sg13g2_fill_1
X_21344_ _21344_/Y _23694_/Q _21347_/B VPWR VGND sg13g2_nand2_1
XFILLER_11_1375 VPWR VGND sg13g2_fill_1
XFILLER_2_816 VPWR VGND sg13g2_fill_1
X_24063_ _24063_/Q _24131_/CLK _24063_/D fanout2750/X VPWR VGND sg13g2_dfrbpq_1
X_21275_ _21275_/Y _23660_/Q _21281_/B VPWR VGND sg13g2_nand2_1
XFILLER_104_722 VPWR VGND sg13g2_decap_8
Xfanout2808 fanout2808/X fanout2809/X VPWR VGND sg13g2_buf_1
X_23014_ _23014_/Q _23029_/CLK _23014_/D fanout2808/X VPWR VGND sg13g2_dfrbpq_1
Xfanout2819 fanout2819/X fanout2822/X VPWR VGND sg13g2_buf_1
X_20226_ _20226_/Y _20352_/A _20226_/B VPWR VGND sg13g2_nand2_1
XFILLER_85_1498 VPWR VGND sg13g2_fill_1
XFILLER_89_477 VPWR VGND sg13g2_decap_8
XFILLER_24_1703 VPWR VGND sg13g2_decap_4
XFILLER_8_1944 VPWR VGND sg13g2_decap_8
XFILLER_44_1151 VPWR VGND sg13g2_decap_8
XFILLER_115_1875 VPWR VGND sg13g2_decap_8
XFILLER_44_1184 VPWR VGND sg13g2_fill_1
X_20088_ _20088_/Y _20087_/A _20086_/Y _20087_/Y VPWR VGND sg13g2_o21ai_1
XFILLER_94_48 VPWR VGND sg13g2_decap_4
XFILLER_100_972 VPWR VGND sg13g2_decap_4
XFILLER_45_514 VPWR VGND sg13g2_decap_8
X_23916_ _23916_/Q _24210_/CLK _23916_/D fanout2636/X VPWR VGND sg13g2_dfrbpq_1
XFILLER_2_1532 VPWR VGND sg13g2_decap_8
XFILLER_73_845 VPWR VGND sg13g2_fill_2
XFILLER_17_249 VPWR VGND sg13g2_decap_8
X_23847_ _23847_/Q clkload37/A _23847_/D fanout2707/X VPWR VGND sg13g2_dfrbpq_1
X_11861_ _11861_/Y _11861_/A _11861_/B _12414_/A _14196_/B VPWR VGND sg13g2_nand4_1
XFILLER_45_569 VPWR VGND sg13g2_decap_8
XFILLER_57_1501 VPWR VGND sg13g2_fill_1
XFILLER_72_344 VPWR VGND sg13g2_fill_1
XFILLER_96_1572 VPWR VGND sg13g2_decap_8
XFILLER_92_1403 VPWR VGND sg13g2_fill_1
X_13600_ _13733_/B _13989_/A1 _13597_/X _13599_/Y VPWR VGND sg13g2_a21o_1
XFILLER_72_366 VPWR VGND sg13g2_decap_4
XFILLER_73_889 VPWR VGND sg13g2_decap_8
X_23778_ _23778_/Q clkload39/A _23778_/D fanout2740/X VPWR VGND sg13g2_dfrbpq_1
X_11792_ _11792_/X _23257_/Q _23385_/Q _11792_/S VPWR VGND sg13g2_mux2_1
XFILLER_57_1567 VPWR VGND sg13g2_decap_8
XFILLER_14_956 VPWR VGND sg13g2_fill_1
XFILLER_41_742 VPWR VGND sg13g2_decap_8
X_13531_ _13532_/A _13530_/Y _13949_/C VPWR VGND sg13g2_nand2b_1
X_22729_ _22729_/Q _22733_/CLK _22729_/D fanout2884/X VPWR VGND sg13g2_dfrbpq_1
XFILLER_40_241 VPWR VGND sg13g2_decap_4
XFILLER_35_1832 VPWR VGND sg13g2_decap_8
X_16250_ _16253_/D _16250_/A _16250_/B VPWR VGND sg13g2_nand2_1
X_13462_ _13469_/C _13641_/A _13462_/B VPWR VGND sg13g2_nor2_1
X_15201_ _15201_/Y _22685_/Q _15487_/A2 _15487_/B1 _22621_/Q VPWR VGND sg13g2_a22oi_1
X_12413_ _12413_/X _22558_/Q _12413_/B VPWR VGND sg13g2_or2_1
XFILLER_70_1767 VPWR VGND sg13g2_decap_8
X_16181_ _16181_/Y _16181_/A _16193_/B VPWR VGND sg13g2_nand2_1
XFILLER_51_1155 VPWR VGND sg13g2_decap_8
XFILLER_70_1778 VPWR VGND sg13g2_fill_1
X_13393_ _13393_/X _23468_/Q _23532_/Q _23628_/Q _23692_/Q _13251_/B _13559_/S1 VPWR
+ VGND sg13g2_mux4_1
XFILLER_51_1166 VPWR VGND sg13g2_decap_8
XFILLER_12_1139 VPWR VGND sg13g2_decap_4
X_12344_ _12345_/B _12344_/A _12343_/Y VPWR VGND sg13g2_nor2b_1
XFILLER_86_1229 VPWR VGND sg13g2_fill_2
XFILLER_114_508 VPWR VGND sg13g2_decap_8
X_19940_ _19941_/D _24254_/A _19977_/B VPWR VGND sg13g2_nand2_1
XFILLER_99_219 VPWR VGND sg13g2_decap_8
XFILLER_5_676 VPWR VGND sg13g2_decap_8
XFILLER_29_1603 VPWR VGND sg13g2_fill_2
X_14014_ _14014_/X _13660_/B _13657_/C _14014_/S VPWR VGND sg13g2_mux2_1
XFILLER_9_1708 VPWR VGND sg13g2_fill_1
XFILLER_4_186 VPWR VGND sg13g2_decap_8
X_19871_ _19871_/X _20080_/B _19870_/Y _20080_/A VPWR VGND sg13g2_mux2_1
XFILLER_49_1073 VPWR VGND sg13g2_decap_8
XFILLER_64_1527 VPWR VGND sg13g2_decap_8
X_18822_ _18822_/Y _18822_/A _18822_/B VPWR VGND sg13g2_nand2_1
XFILLER_68_82 VPWR VGND sg13g2_decap_8
XFILLER_49_831 VPWR VGND sg13g2_fill_1
XFILLER_68_93 VPWR VGND sg13g2_fill_2
XFILLER_0_381 VPWR VGND sg13g2_decap_4
X_18753_ _18753_/Y _18753_/A _18753_/B VPWR VGND sg13g2_nand2_1
XFILLER_81_1896 VPWR VGND sg13g2_fill_1
X_15965_ _15967_/A _22907_/Q _15825_/B _15767_/B _22511_/Q VPWR VGND sg13g2_a22oi_1
XFILLER_49_853 VPWR VGND sg13g2_decap_8
XFILLER_3_1307 VPWR VGND sg13g2_fill_2
XFILLER_23_1235 VPWR VGND sg13g2_fill_2
XFILLER_23_1246 VPWR VGND sg13g2_fill_2
X_17704_ _17705_/B _22563_/Q _17715_/C VPWR VGND sg13g2_nand2_1
XFILLER_82_119 VPWR VGND sg13g2_decap_8
X_14916_ _14916_/Y _14949_/A _14916_/B _14916_/C _14916_/D VPWR VGND sg13g2_nand4_1
X_18684_ _18685_/B _23014_/Q _18684_/B VPWR VGND sg13g2_nand2_1
XFILLER_36_514 VPWR VGND sg13g2_decap_8
XFILLER_63_300 VPWR VGND sg13g2_decap_8
X_15896_ _15896_/Y _15896_/A _15896_/B _15896_/C _15896_/D VPWR VGND sg13g2_nand4_1
XFILLER_48_385 VPWR VGND sg13g2_fill_2
XFILLER_76_694 VPWR VGND sg13g2_decap_8
XFILLER_110_1238 VPWR VGND sg13g2_decap_8
XFILLER_97_1347 VPWR VGND sg13g2_fill_1
X_17635_ _17635_/X _22557_/Q _17635_/B VPWR VGND sg13g2_xor2_1
XFILLER_90_130 VPWR VGND sg13g2_fill_1
XFILLER_79_1770 VPWR VGND sg13g2_fill_2
XFILLER_36_569 VPWR VGND sg13g2_fill_2
XFILLER_79_1781 VPWR VGND sg13g2_fill_2
XFILLER_95_1060 VPWR VGND sg13g2_fill_2
XFILLER_23_219 VPWR VGND sg13g2_fill_1
X_17566_ _17567_/B _22549_/Q _22946_/Q _22550_/Q VPWR VGND sg13g2_a21o_1
X_14778_ _14778_/Y _17372_/A _14763_/Y _14777_/Y VPWR VGND sg13g2_o21ai_1
XFILLER_16_271 VPWR VGND sg13g2_fill_1
XFILLER_90_196 VPWR VGND sg13g2_decap_8
XFILLER_32_731 VPWR VGND sg13g2_decap_4
XFILLER_44_591 VPWR VGND sg13g2_decap_8
XFILLER_17_1006 VPWR VGND sg13g2_decap_8
X_16517_ _22618_/D _17228_/B _22618_/Q _16517_/S VPWR VGND sg13g2_mux2_1
XFILLER_32_753 VPWR VGND sg13g2_decap_8
X_13729_ _13729_/Y _13722_/Y _13723_/X _13724_/Y _14103_/A VPWR VGND sg13g2_a22oi_1
X_17497_ _22865_/D _16500_/Y _17498_/B _17496_/Y VPWR VGND sg13g2_o21ai_1
XFILLER_31_252 VPWR VGND sg13g2_decap_8
X_19236_ _23188_/D _23188_/Q _19274_/B _19235_/Y VPWR VGND sg13g2_a21o_1
XFILLER_53_1943 VPWR VGND sg13g2_decap_8
XFILLER_53_1954 VPWR VGND sg13g2_fill_1
X_16448_ _22588_/D _16043_/A _16456_/B _16447_/Y VPWR VGND sg13g2_o21ai_1
XFILLER_34_1342 VPWR VGND sg13g2_decap_8
XFILLER_14_1949 VPWR VGND sg13g2_decap_4
X_19167_ _23139_/D _23139_/Q _14964_/Y _19169_/S VPWR VGND sg13g2_mux2_1
XFILLER_101_1908 VPWR VGND sg13g2_decap_8
X_16379_ _22551_/D _23001_/Q _22551_/Q _18657_/B VPWR VGND sg13g2_mux2_1
XFILLER_69_0 VPWR VGND sg13g2_fill_2
X_19098_ _19098_/X _18951_/B _23117_/Q _19098_/S VPWR VGND sg13g2_mux2_1
Xhold4905 _21337_/A _23690_/Q VPWR VGND sg13g2_dlygate4sd3_1
X_18049_ _18049_/Y _18473_/S _18049_/B VPWR VGND sg13g2_nand2_1
Xhold4916 _22208_/A _24093_/Q VPWR VGND sg13g2_dlygate4sd3_1
Xhold4927 _21264_/A _23654_/Q VPWR VGND sg13g2_dlygate4sd3_1
XFILLER_67_1140 VPWR VGND sg13g2_fill_2
Xhold4938 _22032_/A _24010_/Q VPWR VGND sg13g2_dlygate4sd3_1
Xhold4949 _21635_/A _23832_/Q VPWR VGND sg13g2_dlygate4sd3_1
XFILLER_82_1616 VPWR VGND sg13g2_fill_2
XFILLER_47_1736 VPWR VGND sg13g2_decap_4
XFILLER_63_1004 VPWR VGND sg13g2_decap_8
XFILLER_67_1184 VPWR VGND sg13g2_decap_4
XFILLER_28_1157 VPWR VGND sg13g2_fill_2
X_20011_ _20012_/B _12632_/D _20117_/C _20010_/Y _20013_/A VPWR VGND sg13g2_a22oi_1
XFILLER_115_1138 VPWR VGND sg13g2_decap_8
XFILLER_113_596 VPWR VGND sg13g2_decap_8
XFILLER_86_436 VPWR VGND sg13g2_fill_1
XFILLER_58_127 VPWR VGND sg13g2_decap_8
XFILLER_60_1925 VPWR VGND sg13g2_fill_2
XFILLER_101_758 VPWR VGND sg13g2_fill_2
XFILLER_104_14 VPWR VGND sg13g2_decap_8
XFILLER_86_469 VPWR VGND sg13g2_fill_2
XFILLER_39_352 VPWR VGND sg13g2_fill_1
XFILLER_39_363 VPWR VGND sg13g2_decap_4
X_21962_ _23975_/D _21962_/A1 _21961_/B _21961_/Y VPWR VGND sg13g2_o21ai_1
XFILLER_27_525 VPWR VGND sg13g2_decap_8
XFILLER_3_1841 VPWR VGND sg13g2_decap_8
XFILLER_27_536 VPWR VGND sg13g2_fill_1
XFILLER_66_171 VPWR VGND sg13g2_fill_1
X_23701_ _23701_/Q clkload52/A _23701_/D fanout2756/X VPWR VGND sg13g2_dfrbpq_1
XFILLER_39_396 VPWR VGND sg13g2_fill_2
X_20913_ _20913_/Y _23504_/Q _20913_/B VPWR VGND sg13g2_nand2_1
XFILLER_82_664 VPWR VGND sg13g2_fill_1
X_21893_ _21893_/Y _23942_/Q _21893_/B VPWR VGND sg13g2_nand2_1
XFILLER_70_815 VPWR VGND sg13g2_decap_4
XFILLER_82_675 VPWR VGND sg13g2_decap_8
XFILLER_110_1783 VPWR VGND sg13g2_decap_8
X_23632_ _23632_/Q clkload56/A _23632_/D fanout2676/X VPWR VGND sg13g2_dfrbpq_1
XFILLER_93_1734 VPWR VGND sg13g2_fill_2
X_20844_ _20844_/Y _23470_/Q _20847_/B VPWR VGND sg13g2_nand2_1
XFILLER_39_1231 VPWR VGND sg13g2_fill_2
XFILLER_70_837 VPWR VGND sg13g2_fill_1
XFILLER_19_1827 VPWR VGND sg13g2_decap_8
XFILLER_19_1838 VPWR VGND sg13g2_fill_1
XFILLER_23_742 VPWR VGND sg13g2_decap_8
XFILLER_39_1264 VPWR VGND sg13g2_decap_8
XFILLER_54_1718 VPWR VGND sg13g2_decap_8
X_23563_ _23563_/Q clkload38/A _23563_/D fanout2633/X VPWR VGND sg13g2_dfrbpq_1
XFILLER_80_17 VPWR VGND sg13g2_fill_1
X_20775_ _20775_/Y _23438_/Q _20778_/B VPWR VGND sg13g2_nand2_1
XFILLER_35_1117 VPWR VGND sg13g2_decap_8
XFILLER_74_1177 VPWR VGND sg13g2_decap_8
XFILLER_39_1297 VPWR VGND sg13g2_decap_8
X_22514_ _22514_/Q clkload11/A _22514_/D fanout2834/X VPWR VGND sg13g2_dfrbpq_1
X_23494_ _23494_/Q clkload42/A _23494_/D fanout2721/X VPWR VGND sg13g2_dfrbpq_1
XFILLER_22_285 VPWR VGND sg13g2_decap_8
XFILLER_109_803 VPWR VGND sg13g2_decap_8
X_22445_ _24208_/D _22445_/A1 _22450_/B _22444_/Y VPWR VGND sg13g2_o21ai_1
XFILLER_17_1595 VPWR VGND sg13g2_decap_8
XFILLER_108_302 VPWR VGND sg13g2_decap_8
XFILLER_109_836 VPWR VGND sg13g2_decap_8
XFILLER_52_1497 VPWR VGND sg13g2_decap_8
X_22376_ _24175_/D _24175_/Q _20280_/Y _22382_/S VPWR VGND sg13g2_mux2_1
X_24115_ _24115_/Q clkload51/A _24115_/D fanout2665/X VPWR VGND sg13g2_dfrbpq_1
XFILLER_108_379 VPWR VGND sg13g2_fill_1
XFILLER_11_1161 VPWR VGND sg13g2_fill_1
X_21327_ _23684_/D _21327_/A1 _21332_/B _21326_/Y VPWR VGND sg13g2_o21ai_1
XFILLER_85_1240 VPWR VGND sg13g2_decap_8
XFILLER_46_1202 VPWR VGND sg13g2_decap_4
X_12060_ _12060_/X _23899_/Q _23995_/Q _12062_/A VPWR VGND sg13g2_mux2_1
X_24046_ _24046_/Q _24170_/CLK _24046_/D fanout2639/X VPWR VGND sg13g2_dfrbpq_1
XFILLER_89_230 VPWR VGND sg13g2_fill_1
X_21258_ _21258_/Y _23651_/Q _21266_/B VPWR VGND sg13g2_nand2_1
XFILLER_78_904 VPWR VGND sg13g2_fill_1
Xfanout2627 fanout2627/X fanout2628/X VPWR VGND sg13g2_buf_1
XFILLER_78_915 VPWR VGND sg13g2_fill_2
Xfanout2638 fanout2638/X fanout2640/X VPWR VGND sg13g2_buf_1
Xfanout2649 fanout2649/X fanout2651/X VPWR VGND sg13g2_buf_1
X_20209_ _20209_/Y _20355_/A _20354_/B _20208_/Y VPWR VGND sg13g2_o21ai_1
X_21189_ _23618_/D _21323_/A1 _21188_/B _21188_/Y VPWR VGND sg13g2_o21ai_1
XFILLER_104_596 VPWR VGND sg13g2_decap_8
XFILLER_8_1741 VPWR VGND sg13g2_decap_8
XFILLER_63_1571 VPWR VGND sg13g2_fill_2
XFILLER_77_458 VPWR VGND sg13g2_fill_2
XFILLER_4_1605 VPWR VGND sg13g2_decap_4
XFILLER_63_1593 VPWR VGND sg13g2_fill_1
XFILLER_115_1672 VPWR VGND sg13g2_decap_8
XFILLER_111_1503 VPWR VGND sg13g2_fill_2
XFILLER_86_981 VPWR VGND sg13g2_decap_8
XFILLER_46_812 VPWR VGND sg13g2_decap_8
X_12962_ _12964_/B _19803_/A _19446_/A _12963_/C VPWR VGND sg13g2_o21ai_1
XFILLER_64_119 VPWR VGND sg13g2_decap_4
X_15750_ _15750_/Y _22735_/Q _15898_/A2 _15901_/B1 _22671_/Q VPWR VGND sg13g2_a22oi_1
XFILLER_100_780 VPWR VGND sg13g2_decap_8
XFILLER_24_1588 VPWR VGND sg13g2_fill_2
XFILLER_45_300 VPWR VGND sg13g2_fill_1
XFILLER_98_1645 VPWR VGND sg13g2_decap_8
XFILLER_45_311 VPWR VGND sg13g2_decap_8
X_14701_ _14701_/X _14701_/A _14701_/B VPWR VGND sg13g2_and2_1
XFILLER_41_1880 VPWR VGND sg13g2_decap_8
X_11913_ _11913_/X _24154_/Q _24186_/Q _23290_/Q _23322_/Q _12401_/B _11423_/B VPWR
+ VGND sg13g2_mux4_1
XFILLER_46_878 VPWR VGND sg13g2_decap_4
X_12893_ _12893_/X _24069_/Q _24133_/Q _13264_/B VPWR VGND sg13g2_mux2_1
X_15681_ _15689_/B _15681_/A _15681_/B VPWR VGND sg13g2_nand2_1
XFILLER_45_355 VPWR VGND sg13g2_fill_1
XFILLER_72_152 VPWR VGND sg13g2_fill_1
X_17420_ _22829_/D _16175_/A _17419_/B _17419_/Y VPWR VGND sg13g2_o21ai_1
XFILLER_33_517 VPWR VGND sg13g2_decap_8
XFILLER_92_1200 VPWR VGND sg13g2_decap_8
X_11844_ _11844_/Y _12243_/A _11844_/B VPWR VGND sg13g2_nor2_1
XFILLER_79_1099 VPWR VGND sg13g2_decap_8
X_14632_ _14632_/Y _14631_/B _14627_/X _14631_/Y VPWR VGND sg13g2_o21ai_1
XFILLER_54_73 VPWR VGND sg13g2_decap_4
X_17351_ _17351_/Y _17351_/A _17351_/B VPWR VGND sg13g2_nand2_1
X_11775_ _11775_/Y _11773_/Y _12414_/A _11774_/Y VPWR VGND sg13g2_o21ai_1
X_16302_ _16302_/Y _16302_/A1 _16314_/C _15070_/B VPWR VGND sg13g2_o21ai_1
XFILLER_9_212 VPWR VGND sg13g2_decap_8
X_13514_ _13515_/D _14004_/B _13514_/B VPWR VGND sg13g2_nor2_1
XFILLER_109_1487 VPWR VGND sg13g2_decap_8
XFILLER_92_1299 VPWR VGND sg13g2_fill_1
X_17282_ _17282_/Y _17282_/A _17302_/S VPWR VGND sg13g2_nand2_1
X_14494_ _14496_/C _22608_/Q _23019_/Q VPWR VGND sg13g2_xor2_1
X_19021_ _19021_/Y _19043_/A _19021_/B VPWR VGND sg13g2_nand2_1
X_16233_ _16233_/Y _22516_/Q _16233_/B VPWR VGND sg13g2_nand2_1
X_13445_ _13949_/C _13510_/A _13510_/B VPWR VGND sg13g2_nor2_1
XFILLER_16_1094 VPWR VGND sg13g2_fill_2
Xclkload15 clkload15/Y clkload15/A VPWR VGND sg13g2_inv_8
XFILLER_10_981 VPWR VGND sg13g2_fill_1
XFILLER_31_1559 VPWR VGND sg13g2_decap_8
Xclkload26 clkload26/Y clkload26/A VPWR VGND sg13g2_inv_4
X_16164_ _16164_/Y _17902_/B2 _16161_/X _16163_/X VPWR VGND sg13g2_a21oi_1
XFILLER_10_992 VPWR VGND sg13g2_decap_4
Xclkload37 clkload37/X clkload37/A VPWR VGND sg13g2_buf_16
X_13376_ _13376_/X _14030_/A _20197_/B VPWR VGND sg13g2_and2_1
Xclkload48 clkload48/X clkload48/A VPWR VGND sg13g2_buf_16
XFILLER_115_817 VPWR VGND sg13g2_decap_8
Xclkload59 clkload59/X clkload59/A VPWR VGND sg13g2_buf_16
X_12327_ _12514_/A _12327_/A _12327_/B VPWR VGND sg13g2_nand2_1
X_15115_ _15115_/Y _15115_/A _15115_/B VPWR VGND sg13g2_nand2_1
XFILLER_6_985 VPWR VGND sg13g2_fill_2
X_16095_ _22492_/D _16205_/B _16093_/Y _16094_/Y VPWR VGND sg13g2_o21ai_1
XFILLER_29_1400 VPWR VGND sg13g2_decap_8
X_15046_ _15047_/B _22475_/Q _15006_/B _14966_/B VPWR VGND sg13g2_a21oi_1
X_12258_ _12258_/Y _12414_/A _23164_/Q VPWR VGND sg13g2_nor2b_1
XFILLER_9_1516 VPWR VGND sg13g2_fill_2
XFILLER_44_1909 VPWR VGND sg13g2_decap_8
XFILLER_96_712 VPWR VGND sg13g2_fill_1
XFILLER_69_926 VPWR VGND sg13g2_decap_8
XFILLER_69_937 VPWR VGND sg13g2_fill_2
X_19854_ _19854_/Y _19854_/A _19854_/B VPWR VGND sg13g2_nor2_1
X_12189_ _12190_/B _23837_/Q _23933_/Q _12191_/S VPWR VGND sg13g2_mux2_1
XFILLER_110_522 VPWR VGND sg13g2_decap_8
X_18805_ _18807_/B _18803_/Y _18804_/Y _18824_/S VPWR VGND sg13g2_mux2_1
XFILLER_42_1611 VPWR VGND sg13g2_decap_8
X_19785_ _19785_/Y _19782_/Y _19784_/Y _19884_/A VPWR VGND sg13g2_o21ai_1
XFILLER_27_1190 VPWR VGND sg13g2_fill_2
XFILLER_49_650 VPWR VGND sg13g2_decap_4
X_16997_ _22708_/D _17007_/A1 _16995_/Y _16996_/Y VPWR VGND sg13g2_o21ai_1
XFILLER_83_406 VPWR VGND sg13g2_decap_4
XFILLER_7_1262 VPWR VGND sg13g2_decap_8
XFILLER_62_1081 VPWR VGND sg13g2_fill_2
X_18736_ _18736_/Y _15911_/Y _18729_/B _18732_/Y VPWR VGND sg13g2_o21ai_1
XFILLER_110_1002 VPWR VGND sg13g2_decap_8
XFILLER_110_599 VPWR VGND sg13g2_decap_8
XFILLER_23_1054 VPWR VGND sg13g2_fill_1
X_15948_ _15949_/D _22615_/Q _15317_/Y _15947_/Y VPWR VGND sg13g2_a21oi_1
XFILLER_64_620 VPWR VGND sg13g2_fill_2
XFILLER_76_480 VPWR VGND sg13g2_decap_8
XFILLER_110_1024 VPWR VGND sg13g2_decap_8
XFILLER_97_1155 VPWR VGND sg13g2_decap_4
X_18667_ _18668_/B _18667_/A _18670_/C VPWR VGND sg13g2_nor2b_1
XFILLER_63_141 VPWR VGND sg13g2_fill_2
X_15879_ _15879_/Y _22741_/Q _15901_/A2 _15901_/B1 _22677_/Q VPWR VGND sg13g2_a22oi_1
XFILLER_40_1390 VPWR VGND sg13g2_fill_2
XFILLER_52_826 VPWR VGND sg13g2_decap_8
XFILLER_64_686 VPWR VGND sg13g2_decap_8
XFILLER_91_472 VPWR VGND sg13g2_decap_8
X_17618_ _17618_/Y _17092_/A _17388_/B _17670_/B1 _17617_/Y VPWR VGND sg13g2_a22oi_1
XFILLER_51_325 VPWR VGND sg13g2_fill_2
XFILLER_52_848 VPWR VGND sg13g2_decap_8
X_18598_ _18598_/X _18598_/A _18598_/B VPWR VGND sg13g2_and2_1
X_20560_ _23335_/D _22429_/A1 _20572_/B _20559_/Y VPWR VGND sg13g2_o21ai_1
XFILLER_60_892 VPWR VGND sg13g2_decap_8
Xclkload9 clkload9/X clkload9/A VPWR VGND sg13g2_buf_8
XFILLER_20_756 VPWR VGND sg13g2_fill_2
X_19219_ _23174_/D _24263_/A _23174_/Q _19234_/S VPWR VGND sg13g2_mux2_1
XFILLER_14_1735 VPWR VGND sg13g2_fill_1
XFILLER_34_1161 VPWR VGND sg13g2_decap_4
X_20491_ _23305_/D _23305_/Q _22433_/A1 _20511_/S VPWR VGND sg13g2_mux2_1
XFILLER_105_1863 VPWR VGND sg13g2_decap_8
XFILLER_9_790 VPWR VGND sg13g2_decap_8
XFILLER_30_1025 VPWR VGND sg13g2_decap_4
X_22230_ _24103_/D _22296_/A1 _22229_/B _22229_/Y VPWR VGND sg13g2_o21ai_1
XFILLER_30_1058 VPWR VGND sg13g2_decap_8
XFILLER_30_1069 VPWR VGND sg13g2_fill_1
X_22161_ _24070_/D _20141_/Y _22160_/B _22160_/Y VPWR VGND sg13g2_o21ai_1
XFILLER_105_316 VPWR VGND sg13g2_decap_8
Xhold4702 _17262_/A _22761_/Q VPWR VGND sg13g2_dlygate4sd3_1
Xhold4713 _22359_/A _24166_/Q VPWR VGND sg13g2_dlygate4sd3_1
Xhold4724 _21549_/A _23792_/Q VPWR VGND sg13g2_dlygate4sd3_1
X_21112_ _21112_/Y _23582_/Q _21112_/B VPWR VGND sg13g2_nand2_1
Xhold4735 _21687_/A _23858_/Q VPWR VGND sg13g2_dlygate4sd3_1
Xhold4746 _20725_/A _23414_/Q VPWR VGND sg13g2_dlygate4sd3_1
X_22092_ _24037_/D _22292_/A1 _22108_/B _22091_/Y VPWR VGND sg13g2_o21ai_1
Xhold4757 _17331_/A _22793_/Q VPWR VGND sg13g2_dlygate4sd3_1
XFILLER_87_701 VPWR VGND sg13g2_decap_8
Xhold4768 _21182_/A _23615_/Q VPWR VGND sg13g2_dlygate4sd3_1
XFILLER_114_872 VPWR VGND sg13g2_decap_8
Xhold4779 _21993_/A _23991_/Q VPWR VGND sg13g2_dlygate4sd3_1
XFILLER_99_572 VPWR VGND sg13g2_decap_8
X_21043_ _23555_/D _22288_/A1 _21029_/B _21042_/Y VPWR VGND sg13g2_o21ai_1
XFILLER_115_35 VPWR VGND sg13g2_decap_8
XFILLER_113_393 VPWR VGND sg13g2_decap_8
XFILLER_101_544 VPWR VGND sg13g2_decap_8
XFILLER_5_1903 VPWR VGND sg13g2_decap_8
XFILLER_25_1842 VPWR VGND sg13g2_decap_8
XFILLER_25_1853 VPWR VGND sg13g2_fill_2
XFILLER_112_1812 VPWR VGND sg13g2_decap_8
XFILLER_86_266 VPWR VGND sg13g2_fill_2
XFILLER_60_1744 VPWR VGND sg13g2_fill_2
XFILLER_68_970 VPWR VGND sg13g2_decap_8
XFILLER_25_1886 VPWR VGND sg13g2_decap_4
X_22994_ _22994_/Q _23187_/CLK _22994_/D fanout2916/X VPWR VGND sg13g2_dfrbpq_1
XFILLER_27_322 VPWR VGND sg13g2_fill_1
XFILLER_28_856 VPWR VGND sg13g2_fill_1
XFILLER_60_1799 VPWR VGND sg13g2_fill_1
XFILLER_55_642 VPWR VGND sg13g2_decap_8
X_21945_ _21945_/Y _23967_/Q _21951_/B VPWR VGND sg13g2_nand2_1
XFILLER_112_1889 VPWR VGND sg13g2_decap_8
XFILLER_95_1829 VPWR VGND sg13g2_fill_2
XFILLER_83_973 VPWR VGND sg13g2_fill_1
XFILLER_83_995 VPWR VGND sg13g2_decap_8
XFILLER_27_377 VPWR VGND sg13g2_decap_8
XFILLER_82_483 VPWR VGND sg13g2_fill_2
X_21876_ _21876_/Y _23934_/Q _21876_/B VPWR VGND sg13g2_nand2_1
XFILLER_91_27 VPWR VGND sg13g2_fill_2
XFILLER_91_38 VPWR VGND sg13g2_fill_1
X_23615_ _23615_/Q clkload40/A _23615_/D fanout2737/X VPWR VGND sg13g2_dfrbpq_1
X_20827_ _20827_/Y _23462_/Q _20827_/B VPWR VGND sg13g2_nand2_1
XFILLER_19_1635 VPWR VGND sg13g2_fill_1
XFILLER_106_1605 VPWR VGND sg13g2_fill_1
XFILLER_39_1094 VPWR VGND sg13g2_fill_1
X_23546_ _23546_/Q clkload46/A _23546_/D fanout2686/X VPWR VGND sg13g2_dfrbpq_1
XFILLER_11_723 VPWR VGND sg13g2_decap_4
X_20758_ _20758_/Y _20758_/A _20772_/B VPWR VGND sg13g2_nand2_1
XFILLER_11_745 VPWR VGND sg13g2_decap_8
XFILLER_50_391 VPWR VGND sg13g2_decap_8
XFILLER_7_705 VPWR VGND sg13g2_decap_8
X_23477_ _23477_/Q clkload57/A _23477_/D fanout2761/X VPWR VGND sg13g2_dfrbpq_1
X_11491_ _11491_/Y _11464_/Y _11460_/Y _11490_/Y VPWR VGND sg13g2_o21ai_1
XFILLER_104_1340 VPWR VGND sg13g2_decap_8
X_20689_ _23397_/D _20124_/Y _20690_/B _20688_/Y VPWR VGND sg13g2_o21ai_1
XFILLER_109_622 VPWR VGND sg13g2_decap_8
XFILLER_6_215 VPWR VGND sg13g2_fill_1
XFILLER_7_749 VPWR VGND sg13g2_fill_2
X_13230_ _13230_/Y _24138_/Q _13232_/S VPWR VGND sg13g2_nand2b_1
X_22428_ _22428_/Y _22428_/A _22444_/B VPWR VGND sg13g2_nand2_1
XFILLER_13_1256 VPWR VGND sg13g2_decap_8
XFILLER_104_1384 VPWR VGND sg13g2_decap_4
XFILLER_108_154 VPWR VGND sg13g2_decap_8
X_13161_ _13161_/Y _23625_/Q _13166_/B VPWR VGND sg13g2_nand2b_1
XFILLER_109_699 VPWR VGND sg13g2_decap_8
X_22359_ _22359_/Y _22359_/A _22359_/B VPWR VGND sg13g2_nand2_1
XFILLER_30_1570 VPWR VGND sg13g2_fill_1
X_12112_ _12112_/Y _12112_/A _12111_/B VPWR VGND sg13g2_nor2b_1
X_13092_ _13092_/Y _20147_/A _20147_/B VPWR VGND sg13g2_nor2_1
XFILLER_65_1644 VPWR VGND sg13g2_decap_8
X_16920_ _16920_/X _22694_/Q _16920_/B VPWR VGND sg13g2_xor2_1
X_24029_ _24029_/Q clkload44/A _24029_/D fanout2744/X VPWR VGND sg13g2_dfrbpq_1
XFILLER_104_371 VPWR VGND sg13g2_decap_8
XFILLER_78_734 VPWR VGND sg13g2_decap_4
XFILLER_2_487 VPWR VGND sg13g2_decap_8
XFILLER_77_222 VPWR VGND sg13g2_decap_4
XFILLER_78_756 VPWR VGND sg13g2_decap_8
X_16851_ _22683_/D _17228_/B _16850_/X _16851_/S VPWR VGND sg13g2_mux2_1
XFILLER_49_95 VPWR VGND sg13g2_decap_4
XFILLER_78_789 VPWR VGND sg13g2_decap_8
XFILLER_1_14 VPWR VGND sg13g2_decap_8
XFILLER_66_929 VPWR VGND sg13g2_fill_1
XFILLER_19_801 VPWR VGND sg13g2_fill_1
XFILLER_24_1341 VPWR VGND sg13g2_decap_8
X_15802_ _22472_/D _16158_/A _15801_/X _15936_/S VPWR VGND sg13g2_mux2_1
XFILLER_37_108 VPWR VGND sg13g2_fill_2
XFILLER_59_981 VPWR VGND sg13g2_decap_8
XFILLER_93_737 VPWR VGND sg13g2_decap_4
X_16782_ _16782_/Y _19773_/A _16782_/B _16782_/C _16782_/D VPWR VGND sg13g2_nor4_1
XFILLER_18_300 VPWR VGND sg13g2_fill_2
XFILLER_65_439 VPWR VGND sg13g2_decap_8
X_13994_ _13995_/B _14104_/B _14104_/C VPWR VGND sg13g2_nor2_1
X_18521_ _18522_/B _18264_/A _18509_/X _18515_/Y VPWR VGND sg13g2_a21oi_1
XFILLER_111_1355 VPWR VGND sg13g2_fill_1
X_15733_ _15734_/D _22605_/Q _15992_/A2 _15732_/Y VPWR VGND sg13g2_a21oi_1
XFILLER_19_878 VPWR VGND sg13g2_fill_2
XFILLER_4_1479 VPWR VGND sg13g2_fill_1
X_12945_ _12946_/B _15690_/A _12948_/B VPWR VGND sg13g2_nor2_1
XFILLER_73_450 VPWR VGND sg13g2_fill_2
XFILLER_74_984 VPWR VGND sg13g2_fill_2
X_18452_ _18452_/Y _18348_/B _18451_/Y _18274_/B VPWR VGND sg13g2_a21oi_1
XFILLER_33_314 VPWR VGND sg13g2_decap_8
XFILLER_61_623 VPWR VGND sg13g2_fill_2
X_15664_ _15665_/B _15984_/A _15662_/Y _15663_/Y VPWR VGND sg13g2_o21ai_1
X_12876_ _12897_/A _12983_/A _13028_/B _12876_/C VPWR VGND sg13g2_nor3_1
XFILLER_73_494 VPWR VGND sg13g2_fill_2
XFILLER_45_196 VPWR VGND sg13g2_decap_8
X_17403_ _17403_/Y _17403_/A _17412_/B VPWR VGND sg13g2_nand2_1
XFILLER_37_1713 VPWR VGND sg13g2_decap_4
X_14615_ _14615_/Y _14629_/A _19235_/C _23190_/Q VPWR VGND sg13g2_o21ai_1
XFILLER_57_1150 VPWR VGND sg13g2_decap_8
X_11827_ _11827_/X _23897_/Q _23993_/Q _24089_/Q _24121_/Q _12062_/A _12039_/A VPWR
+ VGND sg13g2_mux4_1
X_18383_ _22982_/D _12712_/A _18432_/B _18382_/Y VPWR VGND sg13g2_a21oi_1
X_15595_ _15595_/X _22852_/Q _16005_/B VPWR VGND sg13g2_and2_1
XFILLER_60_155 VPWR VGND sg13g2_fill_1
XFILLER_61_678 VPWR VGND sg13g2_decap_4
XFILLER_14_561 VPWR VGND sg13g2_decap_8
XFILLER_53_1014 VPWR VGND sg13g2_fill_1
Xplace4008 _13911_/A2 place4008/A VPWR VGND sg13g2_buf_1
XFILLER_14_572 VPWR VGND sg13g2_fill_2
XFILLER_53_1025 VPWR VGND sg13g2_fill_1
X_17334_ _22794_/D _17872_/A _17371_/S _17333_/Y VPWR VGND sg13g2_o21ai_1
XFILLER_92_1085 VPWR VGND sg13g2_fill_1
X_11758_ _11758_/Y _11762_/B _23224_/Q _11757_/Y VPWR VGND sg13g2_o21ai_1
X_14546_ _14546_/Y _18771_/B _18857_/S _18446_/S VPWR VGND sg13g2_o21ai_1
XFILLER_60_188 VPWR VGND sg13g2_decap_4
XFILLER_72_1659 VPWR VGND sg13g2_decap_8
Xplace4019 _12730_/S _12889_/A VPWR VGND sg13g2_buf_1
XFILLER_41_391 VPWR VGND sg13g2_fill_1
Xplace3307 _21301_/A1 _22396_/A1 VPWR VGND sg13g2_buf_1
XFILLER_50_1913 VPWR VGND sg13g2_decap_8
Xplace3318 _22246_/A0 _22446_/A1 VPWR VGND sg13g2_buf_1
X_17265_ _22762_/D _17872_/A _17270_/B _17264_/Y VPWR VGND sg13g2_o21ai_1
XFILLER_105_1159 VPWR VGND sg13g2_fill_2
X_14477_ _14481_/A _22601_/Q _23012_/Q VPWR VGND sg13g2_xor2_1
Xplace3329 _21972_/A0 _21343_/A0 VPWR VGND sg13g2_buf_1
X_19004_ _19004_/Y _23057_/Q _19019_/A _19048_/B1 VPWR VGND sg13g2_o21ai_1
X_16216_ _16216_/Y _22514_/Q _18607_/A VPWR VGND sg13g2_nor2_1
X_13428_ _13428_/X _13428_/A _13428_/B _13428_/C _13428_/D VPWR VGND sg13g2_or4_1
X_17196_ _17196_/Y _22742_/Q _17196_/B VPWR VGND sg13g2_xnor2_1
XFILLER_115_614 VPWR VGND sg13g2_decap_8
X_13359_ _13359_/Y _14030_/A _20195_/A _20193_/B VPWR VGND sg13g2_o21ai_1
X_16078_ _16078_/Y _16078_/A _16209_/B VPWR VGND sg13g2_nand2_1
XFILLER_9_1302 VPWR VGND sg13g2_decap_8
XFILLER_48_1864 VPWR VGND sg13g2_decap_4
XFILLER_114_168 VPWR VGND sg13g2_decap_8
XFILLER_9_1313 VPWR VGND sg13g2_fill_2
XFILLER_69_712 VPWR VGND sg13g2_decap_8
X_19906_ _19906_/Y _24253_/A _19977_/B _19905_/Y _20177_/A VPWR VGND sg13g2_a22oi_1
XFILLER_9_1324 VPWR VGND sg13g2_fill_1
X_15029_ _16304_/C _17902_/A1 _15029_/B VPWR VGND sg13g2_nand2b_1
XFILLER_64_1154 VPWR VGND sg13g2_fill_2
XFILLER_96_531 VPWR VGND sg13g2_decap_8
XFILLER_111_842 VPWR VGND sg13g2_decap_8
XFILLER_60_1018 VPWR VGND sg13g2_fill_2
X_19837_ _19837_/Y _20355_/A _20354_/B VPWR VGND sg13g2_nor2_1
XFILLER_60_1029 VPWR VGND sg13g2_fill_1
XFILLER_96_564 VPWR VGND sg13g2_fill_2
XFILLER_28_108 VPWR VGND sg13g2_fill_1
XFILLER_110_374 VPWR VGND sg13g2_fill_2
X_19768_ _19769_/B _19663_/A _19766_/Y _19767_/Y VPWR VGND sg13g2_o21ai_1
XFILLER_56_439 VPWR VGND sg13g2_decap_4
X_18719_ _18726_/B _23022_/Q _18719_/B VPWR VGND sg13g2_nand2_1
XFILLER_71_409 VPWR VGND sg13g2_decap_8
X_19699_ _19987_/B _19702_/A _19695_/Y _19698_/X VPWR VGND sg13g2_a21oi_1
XFILLER_25_815 VPWR VGND sg13g2_decap_8
XFILLER_52_612 VPWR VGND sg13g2_decap_8
X_21730_ _23871_/D _21946_/A1 _21738_/B _21729_/Y VPWR VGND sg13g2_o21ai_1
XFILLER_20_1772 VPWR VGND sg13g2_fill_2
XFILLER_24_347 VPWR VGND sg13g2_fill_1
XFILLER_0_1877 VPWR VGND sg13g2_decap_4
XFILLER_40_807 VPWR VGND sg13g2_decap_4
X_21661_ _23843_/D _21954_/A1 _21666_/B _21660_/Y VPWR VGND sg13g2_o21ai_1
XFILLER_24_369 VPWR VGND sg13g2_decap_8
XFILLER_75_1261 VPWR VGND sg13g2_fill_1
XFILLER_51_166 VPWR VGND sg13g2_decap_8
XFILLER_71_1103 VPWR VGND sg13g2_decap_8
X_23400_ _23400_/Q clkload32/A _23400_/D fanout2647/X VPWR VGND sg13g2_dfrbpq_1
X_20612_ _20612_/Y _23360_/Q _20616_/B VPWR VGND sg13g2_nand2_1
XFILLER_75_1283 VPWR VGND sg13g2_fill_1
XFILLER_71_1125 VPWR VGND sg13g2_fill_1
XFILLER_90_1759 VPWR VGND sg13g2_fill_2
X_21592_ _21592_/Y _21592_/A _21600_/B VPWR VGND sg13g2_nand2_1
X_23331_ _23331_/Q clkload34/A _23331_/D fanout2695/X VPWR VGND sg13g2_dfrbpq_1
Xrebuffer5510 rebuffer5510/X rebuffer5511/X VPWR VGND sg13g2_buf_1
Xrebuffer5521 rebuffer5521/X rebuffer5522/X VPWR VGND sg13g2_buf_1
X_20543_ _23327_/D _22412_/A1 _20548_/B _20542_/Y VPWR VGND sg13g2_o21ai_1
Xrebuffer5532 rebuffer5532/X rebuffer5533/X VPWR VGND sg13g2_buf_1
XFILLER_88_1600 VPWR VGND sg13g2_fill_2
Xrebuffer5543 rebuffer5543/X rebuffer5544/X VPWR VGND sg13g2_buf_1
XFILLER_14_1554 VPWR VGND sg13g2_decap_8
Xrebuffer5554 rebuffer5554/X rebuffer5555/X VPWR VGND sg13g2_buf_1
Xplace3830 _19608_/A _19325_/B VPWR VGND sg13g2_buf_1
Xplace3841 _14295_/B _12151_/B VPWR VGND sg13g2_buf_2
X_23262_ _23262_/Q _24190_/CLK _23262_/D fanout2773/X VPWR VGND sg13g2_dfrbpq_1
Xrebuffer5565 _13639_/S1 _22986_/Q VPWR VGND sg13g2_buf_1
X_20474_ _23298_/D _22418_/A1 _20473_/B _20473_/Y VPWR VGND sg13g2_o21ai_1
Xplace3852 _18465_/B _18210_/B VPWR VGND sg13g2_buf_1
Xplace3863 _13778_/A1 _11442_/A VPWR VGND sg13g2_buf_1
XFILLER_69_1010 VPWR VGND sg13g2_decap_4
Xhold5200 _21609_/A _23820_/Q VPWR VGND sg13g2_dlygate4sd3_1
Xplace3874 _13271_/A _12575_/Y VPWR VGND sg13g2_buf_2
X_22213_ _22213_/Y _22213_/A _22219_/B VPWR VGND sg13g2_nand2_1
Xhold5211 _22138_/A _24060_/Q VPWR VGND sg13g2_dlygate4sd3_1
Xplace3885 _18823_/B1 _18766_/Y VPWR VGND sg13g2_buf_1
X_23193_ _23193_/Q clkload12/A _23193_/D fanout2928/X VPWR VGND sg13g2_dfrbpq_2
Xplace3896 _18318_/A _18279_/A VPWR VGND sg13g2_buf_1
XFILLER_106_636 VPWR VGND sg13g2_decap_8
XFILLER_105_168 VPWR VGND sg13g2_decap_8
X_22075_ _22075_/Y _24030_/Q _22075_/B VPWR VGND sg13g2_nand2_1
XFILLER_59_222 VPWR VGND sg13g2_decap_4
XFILLER_43_1216 VPWR VGND sg13g2_fill_2
X_21026_ _23550_/D _22211_/A1 _21029_/B _21025_/Y VPWR VGND sg13g2_o21ai_1
XFILLER_87_564 VPWR VGND sg13g2_decap_8
XFILLER_5_1700 VPWR VGND sg13g2_decap_8
XFILLER_48_918 VPWR VGND sg13g2_decap_8
XFILLER_87_575 VPWR VGND sg13g2_fill_2
XFILLER_74_214 VPWR VGND sg13g2_decap_8
XFILLER_74_225 VPWR VGND sg13g2_fill_1
XFILLER_28_631 VPWR VGND sg13g2_decap_8
XFILLER_19_98 VPWR VGND sg13g2_decap_8
XFILLER_5_1777 VPWR VGND sg13g2_decap_8
XFILLER_74_247 VPWR VGND sg13g2_fill_2
XFILLER_27_130 VPWR VGND sg13g2_decap_8
X_22977_ _22977_/Q _24212_/CLK _22977_/D fanout2919/X VPWR VGND sg13g2_dfrbpq_1
XFILLER_21_1569 VPWR VGND sg13g2_fill_1
XFILLER_95_1648 VPWR VGND sg13g2_fill_1
XFILLER_42_100 VPWR VGND sg13g2_fill_2
X_12730_ _12730_/X _12728_/X _12729_/X _12730_/S VPWR VGND sg13g2_mux2_1
X_21928_ _23959_/D _21928_/A1 _21965_/S _21927_/Y VPWR VGND sg13g2_o21ai_1
XFILLER_3_1490 VPWR VGND sg13g2_decap_8
Xinput4420 _17994_/B instr_rdata_i[14] VPWR VGND sg13g2_buf_1
XFILLER_19_1410 VPWR VGND sg13g2_fill_1
Xinput4431 _18962_/A instr_rdata_i[24] VPWR VGND sg13g2_buf_1
X_12661_ _12661_/Y _13234_/B2 _12656_/Y _12658_/Y _13587_/B2 _12660_/Y VPWR VGND sg13g2_a221oi_1
X_21859_ _21859_/Y _21859_/A _21869_/B VPWR VGND sg13g2_nand2_1
Xinput4442 _19121_/A1 instr_rdata_i[5] VPWR VGND sg13g2_buf_1
Xinput4453 _14743_/A irqs_i[14] VPWR VGND sg13g2_buf_1
XFILLER_19_1443 VPWR VGND sg13g2_fill_2
Xinput4464 wire1183/A rst_ni VPWR VGND sg13g2_buf_1
XFILLER_70_475 VPWR VGND sg13g2_fill_2
X_14400_ _14571_/A _24224_/Q _14400_/B _14400_/C _14609_/B VPWR VGND sg13g2_nor4_1
X_11612_ _11612_/X _14133_/B _11623_/D VPWR VGND sg13g2_and2_1
XFILLER_54_1334 VPWR VGND sg13g2_decap_8
X_12592_ _12593_/B _23233_/Q _23265_/Q _23361_/Q _23393_/Q _12809_/A _12906_/A VPWR
+ VGND sg13g2_mux4_1
XFILLER_106_1424 VPWR VGND sg13g2_decap_4
XFILLER_54_1367 VPWR VGND sg13g2_decap_8
XFILLER_11_542 VPWR VGND sg13g2_fill_2
XFILLER_51_30 VPWR VGND sg13g2_fill_1
X_11543_ _11544_/B _24021_/Q _24053_/Q _24085_/Q _24117_/Q _11737_/S _11920_/C1 VPWR
+ VGND sg13g2_mux4_1
XFILLER_106_1457 VPWR VGND sg13g2_fill_1
X_23529_ _23529_/Q clkload47/A _23529_/D fanout2680/X VPWR VGND sg13g2_dfrbpq_1
XFILLER_11_564 VPWR VGND sg13g2_decap_4
XFILLER_32_1621 VPWR VGND sg13g2_decap_8
XFILLER_89_1419 VPWR VGND sg13g2_fill_1
X_17050_ _22716_/D _17444_/A1 _17222_/C _17049_/X VPWR VGND sg13g2_o21ai_1
X_14262_ _14262_/Y _17532_/A _22580_/Q VPWR VGND sg13g2_nand2_1
X_11474_ _11475_/B _23446_/Q _23510_/Q _11706_/S VPWR VGND sg13g2_mux2_1
XFILLER_7_568 VPWR VGND sg13g2_decap_8
X_13213_ _13213_/X _23273_/Q _23401_/Q _13213_/S VPWR VGND sg13g2_mux2_1
X_16001_ _22481_/D _16205_/A _16000_/X _16025_/A VPWR VGND sg13g2_mux2_1
XFILLER_87_1132 VPWR VGND sg13g2_decap_8
X_14193_ _14194_/B _24219_/Q _14193_/B VPWR VGND sg13g2_nand2_1
XFILLER_13_1097 VPWR VGND sg13g2_fill_1
XFILLER_109_496 VPWR VGND sg13g2_decap_8
X_13144_ _13145_/B _23464_/Q _23528_/Q _23624_/Q _23688_/Q _13631_/S1 _14146_/B VPWR
+ VGND sg13g2_mux4_1
XFILLER_98_829 VPWR VGND sg13g2_decap_4
XFILLER_112_628 VPWR VGND sg13g2_decap_8
XFILLER_111_105 VPWR VGND sg13g2_decap_8
X_17952_ _17953_/B _18940_/A _23052_/Q _18922_/A VPWR VGND sg13g2_mux2_1
XFILLER_2_262 VPWR VGND sg13g2_fill_1
XFILLER_26_1403 VPWR VGND sg13g2_decap_8
X_13075_ _24263_/A _14065_/A _13075_/B VPWR VGND sg13g2_nand2_1
XFILLER_97_339 VPWR VGND sg13g2_decap_8
XFILLER_2_273 VPWR VGND sg13g2_decap_8
XFILLER_2_284 VPWR VGND sg13g2_fill_2
X_16903_ _16904_/B _17030_/A _16903_/B VPWR VGND sg13g2_nor2_1
X_12026_ _12032_/C _12026_/A _12026_/B _12026_/C _12026_/D VPWR VGND sg13g2_nor4_2
XFILLER_6_1508 VPWR VGND sg13g2_decap_8
XFILLER_78_564 VPWR VGND sg13g2_decap_4
XFILLER_25_7 VPWR VGND sg13g2_decap_8
X_17883_ _22925_/D _17883_/A VPWR VGND sg13g2_inv_1
X_19622_ _19623_/B _19886_/A1 _20255_/A0 _19509_/Y _23214_/Q VPWR VGND sg13g2_a22oi_1
X_16834_ _16835_/B _22679_/Q _16844_/D VPWR VGND sg13g2_xor2_1
XFILLER_43_1761 VPWR VGND sg13g2_fill_1
XFILLER_76_60 VPWR VGND sg13g2_decap_8
XFILLER_76_93 VPWR VGND sg13g2_decap_8
X_19553_ _19553_/X _19330_/Y _19339_/Y _19584_/S VPWR VGND sg13g2_mux2_1
XFILLER_81_707 VPWR VGND sg13g2_decap_8
XFILLER_4_1254 VPWR VGND sg13g2_decap_8
XFILLER_47_962 VPWR VGND sg13g2_decap_8
X_16765_ _22668_/D _15693_/A _16818_/A _16764_/Y VPWR VGND sg13g2_a21oi_1
XFILLER_111_1152 VPWR VGND sg13g2_fill_1
X_13977_ _13977_/X _23252_/Q _23284_/Q _23380_/Q _23412_/Q _13978_/S0 _13978_/S1 VPWR
+ VGND sg13g2_mux4_1
X_18504_ _18504_/Y _18504_/A _18504_/B VPWR VGND sg13g2_nor2_1
X_12928_ _12928_/Y _13925_/A1 _12925_/X _12926_/Y _12927_/Y VPWR VGND sg13g2_a22oi_1
XFILLER_46_483 VPWR VGND sg13g2_decap_8
X_16696_ _16696_/Y _16707_/A _16696_/B VPWR VGND sg13g2_nor2_1
XFILLER_78_1879 VPWR VGND sg13g2_decap_4
XFILLER_18_196 VPWR VGND sg13g2_decap_8
XFILLER_73_291 VPWR VGND sg13g2_decap_8
XFILLER_33_133 VPWR VGND sg13g2_decap_8
XFILLER_94_1169 VPWR VGND sg13g2_fill_1
X_18435_ _18435_/X _17953_/B _18809_/B _18463_/S VPWR VGND sg13g2_mux2_1
X_15647_ _15647_/Y _22698_/Q _15708_/A2 _15731_/B1 _22634_/Q VPWR VGND sg13g2_a22oi_1
XFILLER_37_1510 VPWR VGND sg13g2_decap_8
XFILLER_22_829 VPWR VGND sg13g2_fill_1
XFILLER_37_1521 VPWR VGND sg13g2_fill_1
X_12859_ _13748_/B _13086_/A _13526_/B _12859_/C _13526_/D VPWR VGND sg13g2_or4_2
XFILLER_21_317 VPWR VGND sg13g2_decap_4
XFILLER_61_486 VPWR VGND sg13g2_fill_2
XFILLER_37_1554 VPWR VGND sg13g2_fill_2
X_18366_ _18366_/Y _18366_/A _18366_/B VPWR VGND sg13g2_nand2_1
X_15578_ _15578_/Y _15578_/A _15578_/B _15578_/C _15578_/D VPWR VGND sg13g2_nand4_1
XFILLER_33_1418 VPWR VGND sg13g2_fill_2
X_17317_ _17317_/Y _17317_/A _17321_/B VPWR VGND sg13g2_nand2_1
X_14529_ _14530_/B _24219_/Q _14609_/B _14529_/C _14529_/D VPWR VGND sg13g2_nor4_1
X_18297_ _18297_/Y _18297_/A _18297_/B VPWR VGND sg13g2_nand2_1
Xplace3104 _21416_/B _21406_/B VPWR VGND sg13g2_buf_1
Xplace3115 _21286_/S _21234_/B VPWR VGND sg13g2_buf_1
Xplace3126 _21019_/B _21071_/B VPWR VGND sg13g2_buf_1
XFILLER_89_1920 VPWR VGND sg13g2_decap_8
Xplace3137 _20971_/B _20983_/B VPWR VGND sg13g2_buf_1
X_17248_ _17248_/Y _17248_/A _17252_/B VPWR VGND sg13g2_nand2_1
Xplace3148 _20801_/B _20794_/B VPWR VGND sg13g2_buf_1
XFILLER_15_1885 VPWR VGND sg13g2_decap_8
Xplace3159 _20738_/B _20727_/B VPWR VGND sg13g2_buf_1
XFILLER_11_1749 VPWR VGND sg13g2_fill_1
XFILLER_115_411 VPWR VGND sg13g2_decap_8
XFILLER_102_1877 VPWR VGND sg13g2_decap_8
XFILLER_51_0 VPWR VGND sg13g2_fill_1
X_20190_ _23241_/D _22233_/A0 _23241_/Q _20190_/S VPWR VGND sg13g2_mux2_1
XFILLER_115_488 VPWR VGND sg13g2_decap_8
XFILLER_103_639 VPWR VGND sg13g2_decap_8
XFILLER_83_1563 VPWR VGND sg13g2_fill_1
XFILLER_44_1514 VPWR VGND sg13g2_fill_2
XFILLER_29_1071 VPWR VGND sg13g2_decap_8
XFILLER_44_1525 VPWR VGND sg13g2_decap_4
XFILLER_44_1547 VPWR VGND sg13g2_fill_2
XFILLER_97_895 VPWR VGND sg13g2_decap_8
XFILLER_9_1198 VPWR VGND sg13g2_decap_8
X_22900_ _22900_/Q clkload8/A _22900_/D fanout2798/X VPWR VGND sg13g2_dfrbpq_1
X_23880_ _23880_/Q clkload31/A _23880_/D fanout2653/X VPWR VGND sg13g2_dfrbpq_1
XFILLER_110_182 VPWR VGND sg13g2_decap_8
X_22831_ _22831_/Q _22869_/CLK _22831_/D fanout2794/X VPWR VGND sg13g2_dfrbpq_1
XFILLER_38_962 VPWR VGND sg13g2_decap_4
XFILLER_112_14 VPWR VGND sg13g2_decap_8
XFILLER_2_1939 VPWR VGND sg13g2_decap_8
XFILLER_22_1878 VPWR VGND sg13g2_decap_8
XFILLER_96_1946 VPWR VGND sg13g2_decap_8
XFILLER_53_921 VPWR VGND sg13g2_fill_1
X_22762_ _22762_/Q _22893_/CLK _22762_/D fanout2818/X VPWR VGND sg13g2_dfrbpq_1
XFILLER_72_29 VPWR VGND sg13g2_fill_1
X_21713_ _21713_/Y _21713_/A _21713_/B VPWR VGND sg13g2_nand2_1
XFILLER_80_751 VPWR VGND sg13g2_decap_8
XFILLER_80_762 VPWR VGND sg13g2_decap_4
XFILLER_53_976 VPWR VGND sg13g2_decap_4
X_22693_ _22693_/Q clkload22/A _22693_/D fanout2884/X VPWR VGND sg13g2_dfrbpq_1
X_21644_ _21644_/Y _21644_/A _21648_/B VPWR VGND sg13g2_nand2_1
XFILLER_12_339 VPWR VGND sg13g2_decap_8
XFILLER_55_1687 VPWR VGND sg13g2_decap_8
XFILLER_90_1578 VPWR VGND sg13g2_decap_4
X_21575_ _23803_/D _21936_/A1 _21574_/B _21574_/Y VPWR VGND sg13g2_o21ai_1
XFILLER_33_1930 VPWR VGND sg13g2_decap_8
Xplace4350 _17573_/A _22947_/Q VPWR VGND sg13g2_buf_1
Xrebuffer5340 _13245_/B2 _11910_/B VPWR VGND sg13g2_buf_1
XFILLER_21_895 VPWR VGND sg13g2_decap_8
X_23314_ _23314_/Q _24212_/CLK _23314_/D fanout2622/X VPWR VGND sg13g2_dfrbpq_1
X_20526_ _20526_/Y _20526_/A _20578_/B VPWR VGND sg13g2_nand2_1
XFILLER_14_1340 VPWR VGND sg13g2_decap_8
Xrebuffer5351 _13999_/A _13446_/Y VPWR VGND sg13g2_buf_2
XFILLER_107_901 VPWR VGND sg13g2_fill_2
Xrebuffer5362 _19168_/A1 _14973_/Y VPWR VGND sg13g2_buf_1
Xrebuffer5373 _12836_/B _12695_/Y VPWR VGND sg13g2_buf_2
Xplace3660 _16177_/B _16145_/B VPWR VGND sg13g2_buf_1
XFILLER_10_1215 VPWR VGND sg13g2_fill_1
XFILLER_21_44 VPWR VGND sg13g2_decap_8
Xrebuffer5384 _12866_/A2 _13503_/A VPWR VGND sg13g2_buf_2
XFILLER_101_1332 VPWR VGND sg13g2_fill_1
Xplace3671 _15946_/A2 _15708_/A2 VPWR VGND sg13g2_buf_1
X_23245_ _23245_/Q clkload32/A _23245_/D fanout2645/X VPWR VGND sg13g2_dfrbpq_1
Xplace3682 _20356_/A _16017_/A VPWR VGND sg13g2_buf_1
X_20457_ _23290_/D _22401_/A1 _20458_/B _20456_/Y VPWR VGND sg13g2_o21ai_1
XFILLER_49_1414 VPWR VGND sg13g2_fill_2
Xhold5030 _21108_/A _23580_/Q VPWR VGND sg13g2_dlygate4sd3_1
Xplace3693 _19861_/B _19597_/X VPWR VGND sg13g2_buf_1
Xhold5041 _20877_/A _23485_/Q VPWR VGND sg13g2_dlygate4sd3_1
Xhold5052 _21328_/A _23685_/Q VPWR VGND sg13g2_dlygate4sd3_1
Xplace2970 _18432_/B _18355_/A VPWR VGND sg13g2_buf_1
Xplace2981 _18096_/C _16376_/B VPWR VGND sg13g2_buf_1
X_23176_ _23176_/Q clkload17/A _23176_/D fanout2857/X VPWR VGND sg13g2_dfrbpq_1
XFILLER_49_1447 VPWR VGND sg13g2_decap_8
X_20388_ _20388_/Y _20388_/A _20388_/B VPWR VGND sg13g2_nand2_1
Xplace2992 _19001_/C _19042_/S VPWR VGND sg13g2_buf_1
Xhold5063 _17712_/A _22894_/Q VPWR VGND sg13g2_dlygate4sd3_1
Xhold5074 _21463_/A _23749_/Q VPWR VGND sg13g2_dlygate4sd3_1
XFILLER_27_1701 VPWR VGND sg13g2_fill_2
Xhold5085 _22331_/A _24153_/Q VPWR VGND sg13g2_dlygate4sd3_1
X_22127_ _22127_/Y _22127_/A _22136_/B VPWR VGND sg13g2_nand2_1
Xhold5096 _17423_/A _22831_/Q VPWR VGND sg13g2_dlygate4sd3_1
XFILLER_79_339 VPWR VGND sg13g2_decap_4
XFILLER_66_1772 VPWR VGND sg13g2_fill_1
XFILLER_7_1806 VPWR VGND sg13g2_decap_8
XFILLER_0_733 VPWR VGND sg13g2_fill_2
X_22058_ _22058_/Y _22058_/A _22065_/B VPWR VGND sg13g2_nand2_1
XFILLER_48_704 VPWR VGND sg13g2_decap_8
XFILLER_23_1609 VPWR VGND sg13g2_decap_8
XFILLER_62_1669 VPWR VGND sg13g2_decap_8
X_13900_ _13900_/X _23731_/Q _23763_/Q _23795_/Q _23827_/Q _13900_/S0 _13900_/S1 VPWR
+ VGND sg13g2_mux4_1
XFILLER_43_1068 VPWR VGND sg13g2_decap_8
XFILLER_47_214 VPWR VGND sg13g2_decap_8
XFILLER_102_694 VPWR VGND sg13g2_decap_4
XFILLER_21_1300 VPWR VGND sg13g2_fill_1
X_14880_ _14880_/Y _16233_/B _14880_/B VPWR VGND sg13g2_nor2_1
XFILLER_75_534 VPWR VGND sg13g2_decap_8
XFILLER_75_545 VPWR VGND sg13g2_fill_1
XFILLER_5_1563 VPWR VGND sg13g2_fill_1
XFILLER_60_1371 VPWR VGND sg13g2_fill_1
X_13831_ _13931_/A _13831_/A VPWR VGND sg13g2_inv_1
XFILLER_90_515 VPWR VGND sg13g2_fill_1
XFILLER_56_770 VPWR VGND sg13g2_fill_2
XFILLER_112_1483 VPWR VGND sg13g2_fill_1
XFILLER_90_537 VPWR VGND sg13g2_fill_1
XFILLER_1_1449 VPWR VGND sg13g2_decap_4
XFILLER_28_483 VPWR VGND sg13g2_fill_1
XFILLER_62_228 VPWR VGND sg13g2_fill_2
X_13762_ _13762_/X _23857_/Q _23889_/Q _23953_/Q _23985_/Q _13773_/S0 _13765_/S1 VPWR
+ VGND sg13g2_mux4_1
XFILLER_28_494 VPWR VGND sg13g2_decap_8
X_15501_ _15503_/B _22918_/Q _15194_/Y _15500_/Y VPWR VGND sg13g2_a21oi_1
XFILLER_71_751 VPWR VGND sg13g2_decap_8
XFILLER_43_453 VPWR VGND sg13g2_fill_1
X_12713_ _12725_/D _11355_/A _12707_/X _12712_/Y VPWR VGND sg13g2_o21ai_1
X_16481_ _22603_/D _17884_/A _16495_/S _16480_/Y VPWR VGND sg13g2_o21ai_1
XFILLER_43_464 VPWR VGND sg13g2_decap_8
X_13693_ _20292_/A _13667_/Y _13668_/Y _13692_/X VPWR VGND sg13g2_a21o_2
XFILLER_38_1841 VPWR VGND sg13g2_fill_2
XFILLER_102_91 VPWR VGND sg13g2_fill_2
X_18220_ _18220_/Y _18208_/X _18212_/Y _18219_/Y VPWR VGND sg13g2_o21ai_1
XFILLER_38_1852 VPWR VGND sg13g2_fill_2
XFILLER_43_486 VPWR VGND sg13g2_decap_8
XFILLER_70_272 VPWR VGND sg13g2_decap_8
XFILLER_73_1732 VPWR VGND sg13g2_fill_1
X_15432_ _15432_/Y _22592_/Q _16518_/C _15210_/B _22819_/Q VPWR VGND sg13g2_a22oi_1
X_12644_ _12645_/B _23298_/Q _23330_/Q _23362_/Q _23394_/Q _12809_/A _13004_/S1 VPWR
+ VGND sg13g2_mux4_1
XFILLER_106_1210 VPWR VGND sg13g2_decap_8
XFILLER_54_1142 VPWR VGND sg13g2_decap_4
XFILLER_30_158 VPWR VGND sg13g2_decap_8
XFILLER_73_1787 VPWR VGND sg13g2_fill_2
X_12575_ _12575_/Y _12575_/A _12730_/S VPWR VGND sg13g2_nand2_2
XFILLER_15_1137 VPWR VGND sg13g2_decap_8
XFILLER_12_873 VPWR VGND sg13g2_decap_8
XFILLER_7_13 VPWR VGND sg13g2_decap_8
X_17102_ _17102_/Y _17102_/A _17113_/B VPWR VGND sg13g2_nor2_1
X_14314_ _15283_/C _15186_/A _15257_/A VPWR VGND sg13g2_nor2_1
X_11526_ _11528_/B _11526_/A _11526_/B VPWR VGND sg13g2_and2_2
XFILLER_11_383 VPWR VGND sg13g2_decap_8
X_18082_ _18082_/Y _18021_/Y _18269_/A _18081_/Y VPWR VGND sg13g2_o21ai_1
X_15294_ _15353_/A _16781_/A _15294_/B _15294_/C _16786_/C VPWR VGND sg13g2_nand4_1
XFILLER_89_1238 VPWR VGND sg13g2_fill_2
XFILLER_32_1451 VPWR VGND sg13g2_decap_8
XFILLER_8_877 VPWR VGND sg13g2_decap_4
XFILLER_32_1462 VPWR VGND sg13g2_fill_2
X_17033_ _22715_/D _16927_/S _17031_/Y _17032_/Y VPWR VGND sg13g2_o21ai_1
X_11457_ _11457_/Y _12121_/S _11457_/B VPWR VGND sg13g2_nor2_2
X_14245_ _14246_/A _24230_/Q _24227_/Q _24226_/Q VPWR VGND sg13g2_o21ai_1
X_14176_ _14193_/B _14184_/B _14175_/Y _24240_/Q VPWR VGND sg13g2_o21ai_1
X_11388_ _11388_/Y _11386_/Y _24022_/Q _11387_/X VPWR VGND sg13g2_a21oi_1
XFILLER_97_103 VPWR VGND sg13g2_fill_1
XFILLER_84_1850 VPWR VGND sg13g2_decap_4
XFILLER_45_1812 VPWR VGND sg13g2_decap_8
X_18984_ _18986_/B _18984_/A _19039_/B VPWR VGND sg13g2_nand2_1
XFILLER_45_1823 VPWR VGND sg13g2_fill_1
XFILLER_79_840 VPWR VGND sg13g2_fill_2
XFILLER_26_1222 VPWR VGND sg13g2_decap_8
XFILLER_100_609 VPWR VGND sg13g2_decap_8
X_17935_ _17938_/B _15268_/A _17934_/Y _22943_/Q VPWR VGND sg13g2_o21ai_1
X_13058_ _13071_/B _13077_/D VPWR VGND sg13g2_inv_1
XFILLER_97_169 VPWR VGND sg13g2_decap_8
XFILLER_6_1327 VPWR VGND sg13g2_decap_8
X_12009_ _12010_/B _24155_/Q _23291_/Q _12015_/S VPWR VGND sg13g2_mux2_1
XFILLER_78_383 VPWR VGND sg13g2_decap_4
XFILLER_38_214 VPWR VGND sg13g2_decap_8
XFILLER_26_1288 VPWR VGND sg13g2_decap_8
X_17866_ _17866_/Y _17866_/A _17917_/B VPWR VGND sg13g2_nor2_1
XFILLER_78_394 VPWR VGND sg13g2_decap_8
XFILLER_93_331 VPWR VGND sg13g2_fill_2
XFILLER_93_342 VPWR VGND sg13g2_decap_4
X_19605_ _19605_/Y _19605_/A _20038_/A VPWR VGND sg13g2_nor2_1
X_16817_ _16818_/B _22675_/Q _16828_/D VPWR VGND sg13g2_xor2_1
XFILLER_93_364 VPWR VGND sg13g2_fill_2
XFILLER_19_450 VPWR VGND sg13g2_decap_8
X_17797_ _22905_/D _17796_/B _17795_/Y _17796_/Y VPWR VGND sg13g2_a21oi_1
XFILLER_93_386 VPWR VGND sg13g2_fill_2
X_19536_ _19538_/A _19757_/A _19536_/B VPWR VGND sg13g2_and2_1
XFILLER_78_1643 VPWR VGND sg13g2_decap_8
XFILLER_35_932 VPWR VGND sg13g2_decap_8
X_16748_ _16753_/C _22663_/Q _22662_/Q _16748_/C VPWR VGND sg13g2_and3_1
XFILLER_59_1064 VPWR VGND sg13g2_fill_2
X_19467_ _19468_/C _19459_/X _19465_/Y _19932_/A VPWR VGND sg13g2_o21ai_1
XFILLER_22_604 VPWR VGND sg13g2_decap_8
XFILLER_34_464 VPWR VGND sg13g2_decap_4
XFILLER_61_250 VPWR VGND sg13g2_decap_8
XFILLER_62_773 VPWR VGND sg13g2_fill_1
X_18418_ _18418_/Y _18332_/B _18421_/B _18417_/Y _18425_/A VPWR VGND sg13g2_a22oi_1
XFILLER_56_1952 VPWR VGND sg13g2_fill_2
XFILLER_99_0 VPWR VGND sg13g2_decap_8
XFILLER_72_1220 VPWR VGND sg13g2_decap_8
XFILLER_107_1029 VPWR VGND sg13g2_decap_4
XFILLER_52_1827 VPWR VGND sg13g2_decap_8
X_18349_ _18349_/X _18254_/A _18370_/B _18064_/C VPWR VGND sg13g2_a21o_1
XFILLER_15_1671 VPWR VGND sg13g2_decap_8
X_20311_ _20311_/Y _20344_/A1 _20310_/X _20107_/Y VPWR VGND sg13g2_o21ai_1
XFILLER_89_1783 VPWR VGND sg13g2_decap_8
X_23030_ _23030_/Q clkload17/A _23030_/D fanout2847/X VPWR VGND sg13g2_dfrbpq_1
X_20242_ _20242_/X _14399_/B _15865_/C _20345_/A1 VPWR VGND sg13g2_a21o_1
XFILLER_89_604 VPWR VGND sg13g2_decap_8
XFILLER_107_14 VPWR VGND sg13g2_decap_8
XFILLER_115_252 VPWR VGND sg13g2_decap_8
XFILLER_104_926 VPWR VGND sg13g2_fill_1
XFILLER_104_937 VPWR VGND sg13g2_fill_2
XFILLER_89_637 VPWR VGND sg13g2_decap_8
XFILLER_48_1480 VPWR VGND sg13g2_fill_1
Xclkbuf_leaf_62_clk_i clkload38/A clkbuf_4_9__f_clk_i/X VPWR VGND sg13g2_buf_16
XFILLER_112_970 VPWR VGND sg13g2_fill_1
XFILLER_29_214 VPWR VGND sg13g2_decap_8
X_23932_ _23932_/Q _23966_/CLK _23932_/D fanout2765/X VPWR VGND sg13g2_dfrbpq_1
XFILLER_85_854 VPWR VGND sg13g2_decap_8
XFILLER_6_1861 VPWR VGND sg13g2_decap_8
XFILLER_57_556 VPWR VGND sg13g2_decap_8
XFILLER_57_567 VPWR VGND sg13g2_fill_2
XFILLER_61_1691 VPWR VGND sg13g2_decap_4
X_23863_ _23863_/Q clkload52/A _23863_/D fanout2690/X VPWR VGND sg13g2_dfrbpq_1
XFILLER_2_1736 VPWR VGND sg13g2_decap_8
XFILLER_72_526 VPWR VGND sg13g2_decap_8
XFILLER_96_1732 VPWR VGND sg13g2_decap_4
XFILLER_26_932 VPWR VGND sg13g2_decap_8
X_22814_ _22814_/Q _22917_/CLK _22814_/D fanout2892/X VPWR VGND sg13g2_dfrbpq_1
X_23794_ _23794_/Q clkload29/A _23794_/D fanout2669/X VPWR VGND sg13g2_dfrbpq_1
XFILLER_26_965 VPWR VGND sg13g2_decap_8
XFILLER_109_1806 VPWR VGND sg13g2_decap_8
X_22745_ _22745_/Q clkload21/A _22745_/D fanout2874/X VPWR VGND sg13g2_dfrbpq_1
XFILLER_73_1028 VPWR VGND sg13g2_fill_2
XFILLER_40_412 VPWR VGND sg13g2_decap_8
XFILLER_53_795 VPWR VGND sg13g2_decap_8
XFILLER_80_592 VPWR VGND sg13g2_decap_8
X_22676_ _22676_/Q clkload20/A _22676_/D fanout2867/X VPWR VGND sg13g2_dfrbpq_1
XFILLER_90_1331 VPWR VGND sg13g2_fill_1
XFILLER_107_1530 VPWR VGND sg13g2_fill_2
XFILLER_90_1353 VPWR VGND sg13g2_decap_8
XFILLER_16_1424 VPWR VGND sg13g2_decap_4
XFILLER_32_21 VPWR VGND sg13g2_decap_8
XFILLER_51_1315 VPWR VGND sg13g2_decap_8
XFILLER_32_32 VPWR VGND sg13g2_fill_1
XFILLER_40_489 VPWR VGND sg13g2_fill_2
X_12360_ _12360_/Y _12730_/S _12359_/X _13191_/B1 VPWR VGND sg13g2_o21ai_1
Xplace4180 _12789_/S _11815_/S1 VPWR VGND sg13g2_buf_1
Xplace4191 _12191_/S _12134_/S VPWR VGND sg13g2_buf_2
X_11311_ _11312_/C _11311_/A _11311_/B _11595_/A VPWR VGND sg13g2_nand3_1
Xclkbuf_leaf_15_clk_i clkload22/A clkbuf_4_5__f_clk_i/X VPWR VGND sg13g2_buf_16
XFILLER_10_1001 VPWR VGND sg13g2_decap_8
X_20509_ _23314_/D _22448_/A1 _20512_/B _20508_/Y VPWR VGND sg13g2_o21ai_1
XFILLER_10_1012 VPWR VGND sg13g2_fill_1
X_12291_ _12291_/X _24030_/Q _24062_/Q _24094_/Q _24126_/Q _11755_/B _11346_/A VPWR
+ VGND sg13g2_mux4_1
X_21489_ _21489_/Y _21489_/A _21489_/B VPWR VGND sg13g2_nand2_1
XFILLER_88_1260 VPWR VGND sg13g2_decap_4
XFILLER_10_1045 VPWR VGND sg13g2_fill_2
Xplace3490 _16000_/S _15694_/S VPWR VGND sg13g2_buf_1
X_14030_ _14032_/B _14030_/A _20164_/A VPWR VGND sg13g2_xnor2_1
X_23228_ _23228_/Q clkload55/A _23228_/D fanout2771/X VPWR VGND sg13g2_dfrbpq_1
X_11242_ _17706_/A _22947_/Q VPWR VGND sg13g2_inv_1
XFILLER_107_764 VPWR VGND sg13g2_decap_8
XFILLER_84_1113 VPWR VGND sg13g2_fill_1
XFILLER_84_1124 VPWR VGND sg13g2_decap_8
XFILLER_107_786 VPWR VGND sg13g2_fill_1
X_11173_ _19261_/B _23191_/Q _19265_/B VPWR VGND sg13g2_nand2b_1
X_23159_ _23159_/Q clkload16/A _23159_/D fanout2923/X VPWR VGND sg13g2_dfrbpq_1
XFILLER_84_1179 VPWR VGND sg13g2_fill_2
XFILLER_114_1501 VPWR VGND sg13g2_decap_8
X_15981_ _22480_/D _16199_/A _15980_/X _15981_/S VPWR VGND sg13g2_mux2_1
XFILLER_114_1512 VPWR VGND sg13g2_fill_2
XFILLER_62_1444 VPWR VGND sg13g2_fill_1
XFILLER_7_1636 VPWR VGND sg13g2_decap_8
X_17720_ _17720_/Y _17147_/A _17824_/A2 _17580_/B _17719_/Y VPWR VGND sg13g2_a22oi_1
XFILLER_76_821 VPWR VGND sg13g2_decap_4
XFILLER_7_1669 VPWR VGND sg13g2_decap_8
X_17651_ _17651_/Y _17107_/A _17670_/A2 _17670_/B1 _17650_/Y VPWR VGND sg13g2_a22oi_1
XFILLER_75_353 VPWR VGND sg13g2_fill_2
XFILLER_63_504 VPWR VGND sg13g2_decap_8
X_14863_ _14863_/Y _14872_/A _22916_/Q VPWR VGND sg13g2_nor2b_1
X_16602_ _16602_/Y _16610_/A _16602_/B VPWR VGND sg13g2_nor2_1
XFILLER_21_1163 VPWR VGND sg13g2_fill_2
X_13814_ _13814_/Y _14129_/C _24050_/Q _13813_/X VPWR VGND sg13g2_a21oi_1
X_17582_ _22881_/D _22881_/Q _17581_/Y _17642_/B VPWR VGND sg13g2_mux2_1
X_14794_ _14794_/X _17838_/B _14882_/B VPWR VGND sg13g2_and2_1
XFILLER_16_431 VPWR VGND sg13g2_decap_8
X_19321_ _19437_/B _19361_/A _19360_/B _19360_/A VPWR VGND sg13g2_a21o_1
X_16533_ _16534_/B _22621_/Q _16533_/B VPWR VGND sg13g2_xnor2_1
XFILLER_16_464 VPWR VGND sg13g2_fill_1
XFILLER_90_389 VPWR VGND sg13g2_fill_2
X_19252_ _19252_/Y _19263_/A _19265_/B VPWR VGND sg13g2_nand2_1
XFILLER_92_7 VPWR VGND sg13g2_decap_4
X_16464_ _22595_/D _17098_/A _16470_/B _16463_/Y VPWR VGND sg13g2_o21ai_1
XFILLER_32_968 VPWR VGND sg13g2_fill_2
X_13676_ _13676_/Y _23536_/Q _13676_/B VPWR VGND sg13g2_nand2b_1
X_18203_ _22967_/D _14121_/A _18471_/S _18202_/Y VPWR VGND sg13g2_a21oi_1
X_15415_ _15415_/X _16058_/A _15413_/Y _15496_/S VPWR VGND sg13g2_mux2_1
XFILLER_73_1573 VPWR VGND sg13g2_fill_1
X_19183_ _23153_/D _23153_/Q _15101_/X _19185_/S VPWR VGND sg13g2_mux2_1
X_12627_ _12627_/Y _12759_/A _14358_/B _12632_/D VPWR VGND sg13g2_nor3_1
X_16395_ _22564_/D _23014_/Q _22564_/Q _16421_/S VPWR VGND sg13g2_mux2_1
XFILLER_73_1595 VPWR VGND sg13g2_decap_8
X_18134_ _22960_/D _18535_/B _18554_/A1 _18133_/Y VPWR VGND sg13g2_o21ai_1
X_15346_ _15359_/A _15346_/A VPWR VGND sg13g2_inv_1
X_12558_ _12582_/A _12558_/A _12558_/B VPWR VGND sg13g2_nor2_1
XFILLER_51_1871 VPWR VGND sg13g2_decap_4
X_11509_ _11509_/X _11507_/X _11508_/X _13640_/S VPWR VGND sg13g2_mux2_1
XFILLER_12_1855 VPWR VGND sg13g2_decap_8
XFILLER_7_184 VPWR VGND sg13g2_decap_8
X_12489_ _12505_/B _12489_/A _12489_/B _12489_/C _12489_/D VPWR VGND sg13g2_nor4_1
XFILLER_67_1300 VPWR VGND sg13g2_decap_4
X_17016_ _17016_/Y _17209_/A _17026_/B VPWR VGND sg13g2_nand2_1
X_14228_ _14851_/B _14228_/A _14831_/A _14831_/B VPWR VGND sg13g2_nand3_1
XFILLER_113_701 VPWR VGND sg13g2_decap_8
XFILLER_99_935 VPWR VGND sg13g2_decap_8
X_14159_ _14585_/B _22943_/Q _16858_/A VPWR VGND sg13g2_nor2_1
XFILLER_67_1388 VPWR VGND sg13g2_decap_8
XFILLER_80_1511 VPWR VGND sg13g2_decap_8
XFILLER_113_778 VPWR VGND sg13g2_decap_8
XFILLER_101_929 VPWR VGND sg13g2_fill_1
XFILLER_58_309 VPWR VGND sg13g2_fill_2
XFILLER_112_266 VPWR VGND sg13g2_decap_4
XFILLER_85_106 VPWR VGND sg13g2_decap_8
X_18967_ _18969_/B _18964_/Y _19001_/C VPWR VGND sg13g2_nand2b_1
XFILLER_6_1113 VPWR VGND sg13g2_fill_2
XFILLER_85_117 VPWR VGND sg13g2_fill_2
XFILLER_67_821 VPWR VGND sg13g2_decap_8
XFILLER_26_1063 VPWR VGND sg13g2_fill_1
X_17918_ _17919_/A _17918_/A1 _17918_/A2 _17923_/B _22937_/Q _17917_/Y VPWR VGND sg13g2_a221oi_1
X_18898_ _18899_/B _18897_/Y _23048_/Q _18924_/C VPWR VGND sg13g2_mux2_1
XFILLER_113_1033 VPWR VGND sg13g2_decap_8
XFILLER_94_640 VPWR VGND sg13g2_fill_1
XFILLER_67_854 VPWR VGND sg13g2_decap_8
XFILLER_14_0 VPWR VGND sg13g2_fill_2
XFILLER_23_1940 VPWR VGND sg13g2_decap_8
XFILLER_26_1096 VPWR VGND sg13g2_decap_8
XFILLER_67_876 VPWR VGND sg13g2_decap_8
X_17849_ _17849_/Y _22915_/Q _17853_/B _17849_/C VPWR VGND sg13g2_nand3_1
XFILLER_96_1028 VPWR VGND sg13g2_fill_2
XFILLER_54_526 VPWR VGND sg13g2_decap_8
XFILLER_66_386 VPWR VGND sg13g2_decap_8
XFILLER_110_1943 VPWR VGND sg13g2_decap_8
XFILLER_110_1954 VPWR VGND sg13g2_fill_1
X_20860_ _20860_/Y _20860_/A _20902_/S VPWR VGND sg13g2_nand2_1
XFILLER_54_559 VPWR VGND sg13g2_fill_1
XFILLER_78_1462 VPWR VGND sg13g2_decap_8
XFILLER_93_1927 VPWR VGND sg13g2_decap_8
X_19519_ _19519_/Y _19519_/A _19519_/B _19519_/C VPWR VGND sg13g2_nor3_1
X_20791_ _23445_/D _20927_/A1 _20794_/B _20790_/Y VPWR VGND sg13g2_o21ai_1
XFILLER_22_401 VPWR VGND sg13g2_decap_8
X_22530_ _22530_/Q _22941_/CLK _22530_/D fanout2803/X VPWR VGND sg13g2_dfrbpq_1
XFILLER_10_607 VPWR VGND sg13g2_decap_4
XFILLER_17_1744 VPWR VGND sg13g2_decap_4
X_22461_ _22461_/Q clkload18/A _22461_/D fanout2828/X VPWR VGND sg13g2_dfrbpq_1
XFILLER_33_1012 VPWR VGND sg13g2_fill_1
XFILLER_22_489 VPWR VGND sg13g2_fill_2
XFILLER_108_1883 VPWR VGND sg13g2_decap_8
X_21412_ _23725_/D _23725_/Q _21972_/A0 _21421_/S VPWR VGND sg13g2_mux2_1
X_24200_ _24200_/Q clkload32/A _24200_/D fanout2647/X VPWR VGND sg13g2_dfrbpq_1
X_22392_ _24182_/D _19628_/Y _22393_/B _22391_/Y VPWR VGND sg13g2_o21ai_1
XFILLER_33_1056 VPWR VGND sg13g2_fill_2
XFILLER_52_1679 VPWR VGND sg13g2_fill_1
XFILLER_30_1911 VPWR VGND sg13g2_fill_1
XFILLER_108_517 VPWR VGND sg13g2_decap_8
X_24131_ _24131_/Q _24131_/CLK _24131_/D fanout2715/X VPWR VGND sg13g2_dfrbpq_1
X_21343_ _23693_/D _21343_/A0 _23693_/Q _21352_/S VPWR VGND sg13g2_mux2_1
Xclkbuf_4_5__f_clk_i clkbuf_4_5__f_clk_i/X clkbuf_3_2_0_clk_i/X VPWR VGND sg13g2_buf_8
XFILLER_68_1119 VPWR VGND sg13g2_fill_2
XFILLER_11_1343 VPWR VGND sg13g2_fill_1
XFILLER_85_1411 VPWR VGND sg13g2_fill_1
XFILLER_11_1354 VPWR VGND sg13g2_decap_8
X_24062_ _24062_/Q clkload44/A _24062_/D fanout2746/X VPWR VGND sg13g2_dfrbpq_1
X_21274_ _23659_/D _21969_/A1 _21281_/B _21273_/Y VPWR VGND sg13g2_o21ai_1
XFILLER_85_1444 VPWR VGND sg13g2_decap_8
XFILLER_85_1455 VPWR VGND sg13g2_decap_8
X_23013_ _23013_/Q _23029_/CLK _23013_/D fanout2809/X VPWR VGND sg13g2_dfrbpq_1
X_20225_ _20226_/B _19912_/S _20095_/X _20224_/Y VPWR VGND sg13g2_o21ai_1
Xfanout2809 fanout2809/X fanout2810/X VPWR VGND sg13g2_buf_1
XFILLER_89_434 VPWR VGND sg13g2_fill_1
XFILLER_103_222 VPWR VGND sg13g2_decap_8
XFILLER_1_349 VPWR VGND sg13g2_fill_2
XFILLER_63_1731 VPWR VGND sg13g2_decap_4
XFILLER_103_255 VPWR VGND sg13g2_decap_8
XFILLER_8_1923 VPWR VGND sg13g2_decap_8
X_20156_ _20156_/Y _20146_/Y _20153_/Y _20155_/Y _20266_/A1 VPWR VGND sg13g2_a22oi_1
XFILLER_49_309 VPWR VGND sg13g2_fill_1
XFILLER_63_1742 VPWR VGND sg13g2_fill_2
XFILLER_77_629 VPWR VGND sg13g2_decap_8
XFILLER_103_277 VPWR VGND sg13g2_fill_1
XFILLER_115_1854 VPWR VGND sg13g2_decap_8
XFILLER_94_27 VPWR VGND sg13g2_fill_1
XFILLER_4_1809 VPWR VGND sg13g2_decap_8
XFILLER_40_1005 VPWR VGND sg13g2_fill_1
XFILLER_44_1174 VPWR VGND sg13g2_fill_1
XFILLER_69_180 VPWR VGND sg13g2_decap_8
X_20087_ _20087_/Y _20087_/A _20087_/B _20287_/B VPWR VGND sg13g2_nand3_1
XFILLER_58_876 VPWR VGND sg13g2_decap_8
X_23915_ _23915_/Q _24212_/CLK _23915_/D fanout2633/X VPWR VGND sg13g2_dfrbpq_1
XFILLER_57_353 VPWR VGND sg13g2_fill_1
XFILLER_58_887 VPWR VGND sg13g2_fill_1
XFILLER_58_898 VPWR VGND sg13g2_decap_8
XFILLER_84_194 VPWR VGND sg13g2_fill_2
X_23846_ _23846_/Q clkload41/A _23846_/D fanout2723/X VPWR VGND sg13g2_dfrbpq_1
X_11860_ _11860_/Y _23160_/Q VPWR VGND sg13g2_inv_1
XFILLER_72_378 VPWR VGND sg13g2_fill_2
X_11791_ _11794_/C _12145_/A _11791_/B VPWR VGND sg13g2_nor2_1
X_20989_ _23539_/D _22249_/A0 _23539_/Q _20989_/S VPWR VGND sg13g2_mux2_1
XFILLER_92_1426 VPWR VGND sg13g2_fill_2
X_23777_ _23777_/Q clkload39/A _23777_/D fanout2739/X VPWR VGND sg13g2_dfrbpq_1
XFILLER_60_529 VPWR VGND sg13g2_decap_8
XFILLER_53_570 VPWR VGND sg13g2_decap_4
XFILLER_53_581 VPWR VGND sg13g2_decap_8
XFILLER_57_1557 VPWR VGND sg13g2_decap_4
X_13530_ _13530_/Y _13530_/A _13530_/B VPWR VGND sg13g2_nor2_1
X_22728_ _22728_/Q _22733_/CLK _22728_/D fanout2884/X VPWR VGND sg13g2_dfrbpq_1
XFILLER_40_220 VPWR VGND sg13g2_decap_8
XFILLER_43_64 VPWR VGND sg13g2_decap_8
XFILLER_9_416 VPWR VGND sg13g2_decap_8
XFILLER_51_1101 VPWR VGND sg13g2_decap_4
X_13461_ _13462_/B _13459_/X _13460_/X _13640_/S VPWR VGND sg13g2_mux2_1
XFILLER_90_1150 VPWR VGND sg13g2_decap_4
XFILLER_43_75 VPWR VGND sg13g2_fill_2
X_22659_ _22659_/Q clkload24/A _22659_/D fanout2888/X VPWR VGND sg13g2_dfrbpq_1
XFILLER_13_489 VPWR VGND sg13g2_decap_8
XFILLER_43_86 VPWR VGND sg13g2_fill_1
XFILLER_16_1243 VPWR VGND sg13g2_fill_1
XFILLER_31_1708 VPWR VGND sg13g2_fill_1
XFILLER_70_1757 VPWR VGND sg13g2_decap_4
XFILLER_90_1194 VPWR VGND sg13g2_fill_1
X_12412_ _12412_/Y _12412_/A _12412_/B _12412_/C _12412_/D VPWR VGND sg13g2_nor4_2
X_16180_ _16180_/Y _17192_/A _16161_/X _16179_/X VPWR VGND sg13g2_a21oi_1
X_13392_ _13403_/D _13271_/A _13389_/X _13391_/X VPWR VGND sg13g2_o21ai_1
X_15131_ _24233_/D _18567_/B _15131_/B VPWR VGND sg13g2_nor2_1
X_12343_ _12343_/Y _12340_/Y _12342_/X _19861_/A VPWR VGND sg13g2_o21ai_1
XFILLER_86_1208 VPWR VGND sg13g2_decap_8
X_12274_ _12277_/C _12531_/A _12968_/B _12273_/Y VPWR VGND sg13g2_o21ai_1
X_15062_ _16323_/B _15054_/Y _15070_/B _18726_/A VPWR VGND sg13g2_o21ai_1
XFILLER_4_14 VPWR VGND sg13g2_decap_8
XFILLER_4_165 VPWR VGND sg13g2_decap_8
XFILLER_107_583 VPWR VGND sg13g2_decap_8
XFILLER_4_25 VPWR VGND sg13g2_fill_2
X_14013_ _14016_/A _14013_/A _13742_/Y VPWR VGND sg13g2_nor2b_1
X_11225_ _11681_/A _11234_/B _11199_/Y _12583_/C _12551_/C _13186_/B VPWR VGND sg13g2_a221oi_1
X_19870_ _19870_/Y _19869_/A _19698_/B _19869_/Y VPWR VGND sg13g2_o21ai_1
XFILLER_4_58 VPWR VGND sg13g2_decap_8
XFILLER_110_704 VPWR VGND sg13g2_decap_8
XFILLER_81_1831 VPWR VGND sg13g2_decap_8
X_18821_ _18826_/A _23038_/Q _18821_/B _18821_/C VPWR VGND sg13g2_nand3_1
XFILLER_68_618 VPWR VGND sg13g2_fill_2
XFILLER_96_949 VPWR VGND sg13g2_decap_4
XFILLER_81_1864 VPWR VGND sg13g2_fill_2
XFILLER_110_748 VPWR VGND sg13g2_decap_8
XFILLER_7_1444 VPWR VGND sg13g2_decap_8
XFILLER_23_1203 VPWR VGND sg13g2_fill_1
X_18752_ _18752_/Y _16417_/B _18756_/B _18651_/B VPWR VGND sg13g2_o21ai_1
X_15964_ _15976_/A _22616_/Q _15964_/A2 _15552_/B _22939_/Q VPWR VGND sg13g2_a22oi_1
X_17703_ _22893_/D _17702_/B _17701_/Y _17702_/Y VPWR VGND sg13g2_a21oi_1
X_14915_ _14916_/D _17870_/A1 _14936_/B _14947_/B _22462_/Q VPWR VGND sg13g2_a22oi_1
XFILLER_49_876 VPWR VGND sg13g2_fill_1
XFILLER_62_1296 VPWR VGND sg13g2_decap_4
X_18683_ _18683_/Y _18697_/A _18690_/B _18692_/B VPWR VGND sg13g2_o21ai_1
XFILLER_23_1258 VPWR VGND sg13g2_decap_8
XFILLER_36_504 VPWR VGND sg13g2_decap_4
XFILLER_76_673 VPWR VGND sg13g2_decap_8
X_15895_ _15896_/D _22776_/Q _15940_/B VPWR VGND sg13g2_nand2_1
XFILLER_64_835 VPWR VGND sg13g2_fill_1
X_17634_ _17635_/B _22556_/Q _17654_/D VPWR VGND sg13g2_nand2_1
XFILLER_64_846 VPWR VGND sg13g2_decap_4
XFILLER_1_1021 VPWR VGND sg13g2_fill_2
XFILLER_64_879 VPWR VGND sg13g2_fill_2
XFILLER_63_356 VPWR VGND sg13g2_decap_8
XFILLER_51_507 VPWR VGND sg13g2_fill_2
XFILLER_91_687 VPWR VGND sg13g2_decap_8
X_17565_ _17567_/A _22550_/Q _22549_/Q _22946_/Q VPWR VGND sg13g2_nand3_1
XFILLER_51_529 VPWR VGND sg13g2_decap_8
X_14777_ _14777_/Y _14777_/A VPWR VGND sg13g2_inv_1
X_11989_ _11989_/Y _14346_/B _14346_/C _19777_/B VPWR VGND sg13g2_o21ai_1
XFILLER_1_1087 VPWR VGND sg13g2_fill_2
XFILLER_32_710 VPWR VGND sg13g2_decap_8
XFILLER_95_1083 VPWR VGND sg13g2_decap_8
X_19304_ _22430_/A _22973_/Q _20437_/B _22050_/C VPWR VGND sg13g2_or3_1
XFILLER_16_283 VPWR VGND sg13g2_decap_4
X_17496_ _17496_/Y _17496_/A _17498_/B VPWR VGND sg13g2_nand2_1
XFILLER_108_1146 VPWR VGND sg13g2_fill_1
X_19235_ _19235_/Y _22969_/Q _19235_/B _19235_/C _19237_/S VPWR VGND sg13g2_nor4_1
XFILLER_34_1310 VPWR VGND sg13g2_fill_1
XFILLER_56_1089 VPWR VGND sg13g2_fill_1
X_16447_ _16447_/Y _22588_/Q _16456_/B VPWR VGND sg13g2_nand2_1
X_13659_ _13660_/B _20258_/A _20260_/A VPWR VGND sg13g2_nor2_1
XFILLER_20_949 VPWR VGND sg13g2_fill_2
XFILLER_13_990 VPWR VGND sg13g2_fill_2
XFILLER_14_1928 VPWR VGND sg13g2_decap_8
X_19166_ _23138_/D _23138_/Q _14954_/Y _19171_/S VPWR VGND sg13g2_mux2_1
XFILLER_34_1376 VPWR VGND sg13g2_fill_2
X_18117_ _22952_/D _18524_/B _18115_/Y _18116_/Y VPWR VGND sg13g2_o21ai_1
X_15329_ _15329_/Y _15328_/Y _15972_/B VPWR VGND sg13g2_nand2b_1
XFILLER_8_482 VPWR VGND sg13g2_decap_8
X_19097_ _23084_/D _23084_/Q _19096_/X _19099_/S VPWR VGND sg13g2_mux2_1
XFILLER_105_509 VPWR VGND sg13g2_decap_8
X_18048_ _18049_/B _18973_/B _23055_/Q _18048_/S VPWR VGND sg13g2_mux2_1
Xhold4906 _21316_/A _23679_/Q VPWR VGND sg13g2_dlygate4sd3_1
Xhold4917 _22195_/A _24087_/Q VPWR VGND sg13g2_dlygate4sd3_1
Xhold4928 _22395_/A _24184_/Q VPWR VGND sg13g2_dlygate4sd3_1
XFILLER_86_1775 VPWR VGND sg13g2_decap_4
Xhold4939 _21779_/A _23890_/Q VPWR VGND sg13g2_dlygate4sd3_1
X_20010_ _20010_/Y _20009_/B _20085_/B _20009_/Y VPWR VGND sg13g2_a21oi_1
XFILLER_101_704 VPWR VGND sg13g2_decap_8
XFILLER_86_404 VPWR VGND sg13g2_decap_4
XFILLER_115_1117 VPWR VGND sg13g2_decap_8
XFILLER_113_575 VPWR VGND sg13g2_decap_8
XFILLER_99_798 VPWR VGND sg13g2_fill_1
XFILLER_59_629 VPWR VGND sg13g2_fill_1
XFILLER_98_286 VPWR VGND sg13g2_decap_8
XFILLER_86_426 VPWR VGND sg13g2_decap_4
XFILLER_98_297 VPWR VGND sg13g2_fill_2
XFILLER_39_331 VPWR VGND sg13g2_fill_1
XFILLER_100_258 VPWR VGND sg13g2_decap_4
XFILLER_80_1385 VPWR VGND sg13g2_decap_8
XFILLER_3_1820 VPWR VGND sg13g2_decap_8
X_21961_ _21961_/Y _21961_/A _21961_/B VPWR VGND sg13g2_nand2_1
XFILLER_66_150 VPWR VGND sg13g2_decap_8
XFILLER_82_621 VPWR VGND sg13g2_decap_8
XFILLER_23_1770 VPWR VGND sg13g2_fill_2
XFILLER_55_846 VPWR VGND sg13g2_fill_2
X_23700_ _23700_/Q clkload46/A _23700_/D fanout2650/X VPWR VGND sg13g2_dfrbpq_1
X_20912_ _23503_/D _22177_/A1 _23503_/Q _20918_/S VPWR VGND sg13g2_mux2_1
XFILLER_81_120 VPWR VGND sg13g2_fill_1
XFILLER_27_559 VPWR VGND sg13g2_decap_8
X_21892_ _23941_/D _21958_/A1 _21893_/B _21891_/Y VPWR VGND sg13g2_o21ai_1
XFILLER_58_1811 VPWR VGND sg13g2_decap_8
XFILLER_93_1713 VPWR VGND sg13g2_decap_8
X_20843_ _23469_/D _23469_/Q _21343_/A0 _20852_/S VPWR VGND sg13g2_mux2_1
X_23631_ _23631_/Q clkload30/A _23631_/D fanout2658/X VPWR VGND sg13g2_dfrbpq_1
XFILLER_3_1897 VPWR VGND sg13g2_decap_8
XFILLER_97_1893 VPWR VGND sg13g2_decap_4
XFILLER_81_164 VPWR VGND sg13g2_fill_1
XFILLER_42_529 VPWR VGND sg13g2_decap_8
XFILLER_82_698 VPWR VGND sg13g2_fill_1
XFILLER_78_1292 VPWR VGND sg13g2_decap_8
XFILLER_35_581 VPWR VGND sg13g2_decap_8
XFILLER_39_1243 VPWR VGND sg13g2_decap_8
XFILLER_70_849 VPWR VGND sg13g2_fill_2
XFILLER_74_1123 VPWR VGND sg13g2_decap_8
XFILLER_74_1134 VPWR VGND sg13g2_fill_2
XFILLER_35_592 VPWR VGND sg13g2_fill_2
X_20774_ _23437_/D _23437_/Q _21343_/A0 _20783_/S VPWR VGND sg13g2_mux2_1
X_23562_ _23562_/Q _24131_/CLK _23562_/D fanout2710/X VPWR VGND sg13g2_dfrbpq_1
XFILLER_58_1899 VPWR VGND sg13g2_fill_2
XFILLER_22_253 VPWR VGND sg13g2_decap_8
X_22513_ _22513_/Q _23029_/CLK _22513_/D fanout2825/X VPWR VGND sg13g2_dfrbpq_1
X_23493_ _23493_/Q _23682_/CLK _23493_/D fanout2719/X VPWR VGND sg13g2_dfrbpq_1
XFILLER_11_938 VPWR VGND sg13g2_fill_1
XFILLER_17_1552 VPWR VGND sg13g2_decap_8
XFILLER_52_1443 VPWR VGND sg13g2_fill_2
X_22444_ _22444_/Y _22444_/A _22444_/B VPWR VGND sg13g2_nand2_1
XFILLER_13_1416 VPWR VGND sg13g2_decap_8
XFILLER_109_826 VPWR VGND sg13g2_decap_4
XFILLER_108_314 VPWR VGND sg13g2_decap_8
X_22375_ _24174_/D _22442_/A1 _22377_/B _22374_/Y VPWR VGND sg13g2_o21ai_1
XFILLER_89_49 VPWR VGND sg13g2_fill_1
X_21326_ _21326_/Y _23684_/Q _21337_/B VPWR VGND sg13g2_nand2_1
X_24114_ _24114_/Q clkload29/A _24114_/D fanout2623/X VPWR VGND sg13g2_dfrbpq_1
XFILLER_30_1796 VPWR VGND sg13g2_fill_2
XFILLER_65_1804 VPWR VGND sg13g2_decap_8
X_24045_ _24045_/Q _24205_/CLK _24045_/D fanout2647/X VPWR VGND sg13g2_dfrbpq_1
X_21257_ _23650_/D _21323_/A1 _21264_/B _21256_/Y VPWR VGND sg13g2_o21ai_1
XFILLER_85_1263 VPWR VGND sg13g2_decap_4
XFILLER_2_658 VPWR VGND sg13g2_fill_2
XFILLER_1_135 VPWR VGND sg13g2_decap_8
Xfanout2628 fanout2628/X fanout2644/X VPWR VGND sg13g2_buf_1
XFILLER_89_253 VPWR VGND sg13g2_decap_4
XFILLER_1_146 VPWR VGND sg13g2_fill_1
Xfanout2639 fanout2639/X fanout2640/X VPWR VGND sg13g2_buf_1
X_20208_ _20208_/Y _20208_/A _20208_/B VPWR VGND sg13g2_nor2_1
XFILLER_65_1859 VPWR VGND sg13g2_decap_8
XFILLER_46_1247 VPWR VGND sg13g2_fill_1
XFILLER_104_575 VPWR VGND sg13g2_decap_8
X_21188_ _21188_/Y _23618_/Q _21188_/B VPWR VGND sg13g2_nand2_1
X_20139_ _20140_/D _20139_/A _20139_/B VPWR VGND sg13g2_nor2_1
XFILLER_28_1681 VPWR VGND sg13g2_fill_1
XFILLER_115_1662 VPWR VGND sg13g2_decap_4
XFILLER_8_1797 VPWR VGND sg13g2_decap_8
XFILLER_4_1628 VPWR VGND sg13g2_decap_8
XFILLER_98_1624 VPWR VGND sg13g2_decap_8
X_12961_ _12963_/C _12085_/Y _12958_/Y _12959_/X _12960_/Y VPWR VGND sg13g2_a22oi_1
XFILLER_46_824 VPWR VGND sg13g2_fill_2
XFILLER_98_1657 VPWR VGND sg13g2_decap_8
X_14700_ _14700_/Y _14659_/Y _14694_/B _14699_/Y VPWR VGND sg13g2_o21ai_1
XFILLER_111_1559 VPWR VGND sg13g2_decap_8
XFILLER_57_183 VPWR VGND sg13g2_fill_1
X_11912_ _11912_/X _23226_/Q _23258_/Q _23354_/Q _23386_/Q _12401_/B _11423_/B VPWR
+ VGND sg13g2_mux4_1
X_15680_ _15681_/B _22467_/Q _15945_/A2 _15986_/C1 VPWR VGND sg13g2_a21oi_1
XFILLER_2_1341 VPWR VGND sg13g2_decap_4
X_12892_ _12895_/B _13266_/A1 _12890_/X _12891_/X _11954_/Y VPWR VGND sg13g2_a22oi_1
XFILLER_22_1280 VPWR VGND sg13g2_decap_8
XFILLER_61_816 VPWR VGND sg13g2_decap_4
XFILLER_72_142 VPWR VGND sg13g2_decap_4
X_14631_ _14631_/Y _23190_/Q _14631_/B _14631_/C VPWR VGND sg13g2_nand3b_1
X_23829_ _23829_/Q clkload52/A _23829_/D fanout2689/X VPWR VGND sg13g2_dfrbpq_1
X_11843_ _11844_/B _23417_/Q _23449_/Q _11843_/S VPWR VGND sg13g2_mux2_1
XFILLER_61_827 VPWR VGND sg13g2_fill_1
XFILLER_14_710 VPWR VGND sg13g2_decap_8
XFILLER_60_326 VPWR VGND sg13g2_decap_8
XFILLER_14_721 VPWR VGND sg13g2_fill_1
XFILLER_109_1422 VPWR VGND sg13g2_decap_4
XFILLER_60_337 VPWR VGND sg13g2_fill_2
XFILLER_72_197 VPWR VGND sg13g2_decap_8
X_11774_ _11774_/Y _11774_/A _11861_/B _12414_/A _14196_/B VPWR VGND sg13g2_nand4_1
XFILLER_14_765 VPWR VGND sg13g2_decap_8
X_16301_ _16301_/Y _15024_/Y _16301_/A2 _16314_/C VPWR VGND sg13g2_a21oi_1
XFILLER_41_562 VPWR VGND sg13g2_fill_1
X_13513_ _13514_/B _13513_/A1 _13512_/Y _13854_/A VPWR VGND sg13g2_o21ai_1
XFILLER_105_1319 VPWR VGND sg13g2_decap_8
X_14493_ _14496_/B _22593_/Q _23004_/Q VPWR VGND sg13g2_xor2_1
X_19020_ _19021_/B _19019_/Y _23059_/Q _19045_/C VPWR VGND sg13g2_mux2_1
XFILLER_41_595 VPWR VGND sg13g2_fill_1
XFILLER_110_91 VPWR VGND sg13g2_decap_8
X_16232_ _16232_/X _16237_/D _18619_/A VPWR VGND sg13g2_xor2_1
XFILLER_103_1021 VPWR VGND sg13g2_decap_8
XFILLER_16_1073 VPWR VGND sg13g2_decap_8
XFILLER_10_960 VPWR VGND sg13g2_decap_8
X_16163_ _16163_/X _22504_/Q _16183_/B VPWR VGND sg13g2_and2_1
Xclkload16 clkload16/Y clkload16/A VPWR VGND sg13g2_inv_8
XFILLER_70_1598 VPWR VGND sg13g2_decap_8
Xclkload27 clkload27/Y clkload27/A VPWR VGND sg13g2_inv_16
X_13375_ _13375_/Y _20164_/A _14032_/A _19423_/A VPWR VGND sg13g2_a21oi_1
Xclkload38 clkload38/X clkload38/A VPWR VGND sg13g2_buf_16
Xclkload49 clkload49/Y clkload49/A VPWR VGND sg13g2_inv_2
X_15114_ _15115_/B _22482_/Q _15114_/A2 _14885_/Y _22941_/Q VPWR VGND sg13g2_a22oi_1
X_12326_ _12327_/B _14318_/A _13858_/A VPWR VGND sg13g2_nand2b_1
X_16094_ _16094_/Y _16094_/A _16209_/B VPWR VGND sg13g2_nand2_1
XFILLER_100_1953 VPWR VGND sg13g2_fill_2
X_15045_ _15047_/A _22506_/Q _14998_/B _15075_/B1 _22934_/Q VPWR VGND sg13g2_a22oi_1
X_12257_ _12257_/X _22556_/Q _12413_/B VPWR VGND sg13g2_or2_1
X_11208_ _11606_/A _22943_/Q _14596_/A VPWR VGND sg13g2_nand2b_2
X_12188_ _12195_/A _12473_/A _12188_/B VPWR VGND sg13g2_nor2_1
X_19853_ _19854_/B _19851_/Y _19852_/Y _19946_/C1 VPWR VGND sg13g2_a21oi_1
XFILLER_110_501 VPWR VGND sg13g2_decap_8
XFILLER_29_1478 VPWR VGND sg13g2_fill_2
XFILLER_96_746 VPWR VGND sg13g2_fill_1
XFILLER_95_223 VPWR VGND sg13g2_decap_4
X_18804_ _18804_/Y _17987_/B _23035_/Q _18823_/B1 _19121_/A1 VPWR VGND sg13g2_a22oi_1
XFILLER_81_1672 VPWR VGND sg13g2_decap_8
XFILLER_7_1241 VPWR VGND sg13g2_decap_8
X_19784_ _19784_/Y _19850_/A _19784_/B VPWR VGND sg13g2_nor2_1
X_16996_ _16996_/Y _17187_/A _17021_/B VPWR VGND sg13g2_nand2_1
XFILLER_23_1011 VPWR VGND sg13g2_decap_4
XFILLER_62_1071 VPWR VGND sg13g2_fill_1
XFILLER_110_578 VPWR VGND sg13g2_decap_8
X_18735_ _18735_/Y _18729_/A _18741_/B _15042_/B VPWR VGND sg13g2_o21ai_1
XFILLER_55_109 VPWR VGND sg13g2_fill_2
X_15947_ _15947_/Y _15947_/A1 _15946_/Y _15947_/B1 VPWR VGND sg13g2_o21ai_1
XFILLER_97_1112 VPWR VGND sg13g2_decap_4
XFILLER_3_1138 VPWR VGND sg13g2_fill_2
XFILLER_97_1134 VPWR VGND sg13g2_decap_8
XFILLER_23_1088 VPWR VGND sg13g2_decap_8
X_18666_ _18670_/C _18666_/A _18666_/B _18666_/C _18666_/D VPWR VGND sg13g2_nor4_1
XFILLER_36_334 VPWR VGND sg13g2_decap_4
XFILLER_110_1047 VPWR VGND sg13g2_fill_1
X_15878_ _15882_/C _22476_/Q _15900_/A2 _15992_/B1 _22807_/Q VPWR VGND sg13g2_a22oi_1
XFILLER_20_1954 VPWR VGND sg13g2_fill_1
XFILLER_58_1118 VPWR VGND sg13g2_fill_2
XFILLER_64_676 VPWR VGND sg13g2_fill_2
X_17617_ _17617_/Y _17617_/A _17617_/B VPWR VGND sg13g2_nand2_1
X_14829_ _14829_/Y _14200_/X _14228_/A _14253_/A VPWR VGND sg13g2_a21oi_1
X_18597_ _18598_/B _22483_/Q _14848_/B _14794_/X _22452_/Q VPWR VGND sg13g2_a22oi_1
XFILLER_17_581 VPWR VGND sg13g2_fill_1
XFILLER_75_1432 VPWR VGND sg13g2_fill_1
XFILLER_75_1443 VPWR VGND sg13g2_decap_8
X_17548_ _22878_/D _22878_/Q _17544_/Y _17661_/B VPWR VGND sg13g2_mux2_1
XFILLER_51_359 VPWR VGND sg13g2_fill_2
XFILLER_32_562 VPWR VGND sg13g2_decap_4
XFILLER_75_1498 VPWR VGND sg13g2_fill_2
X_17479_ _17479_/Y _22857_/Q _17489_/B VPWR VGND sg13g2_nand2_1
XFILLER_60_882 VPWR VGND sg13g2_decap_4
XFILLER_81_0 VPWR VGND sg13g2_decap_4
XFILLER_20_746 VPWR VGND sg13g2_fill_2
XFILLER_18_1883 VPWR VGND sg13g2_decap_8
XFILLER_105_1842 VPWR VGND sg13g2_decap_8
XFILLER_20_779 VPWR VGND sg13g2_fill_1
X_19149_ _23125_/D _23125_/Q _19039_/A _19149_/S VPWR VGND sg13g2_mux2_1
XFILLER_69_1203 VPWR VGND sg13g2_fill_2
XFILLER_30_1037 VPWR VGND sg13g2_fill_1
X_22160_ _22160_/Y _22160_/A _22160_/B VPWR VGND sg13g2_nand2_1
XFILLER_69_1247 VPWR VGND sg13g2_decap_4
Xhold4703 _17492_/A _22863_/Q VPWR VGND sg13g2_dlygate4sd3_1
XFILLER_12_1482 VPWR VGND sg13g2_fill_1
X_21111_ _23581_/D _21312_/A1 _21112_/B _21110_/Y VPWR VGND sg13g2_o21ai_1
Xhold4714 _18133_/A _22960_/Q VPWR VGND sg13g2_dlygate4sd3_1
Xhold4725 _20862_/A _23478_/Q VPWR VGND sg13g2_dlygate4sd3_1
X_22091_ _22091_/Y _24037_/Q _22108_/B VPWR VGND sg13g2_nand2_1
Xhold4736 _21596_/A _23813_/Q VPWR VGND sg13g2_dlygate4sd3_1
Xhold4747 _22415_/A _24193_/Q VPWR VGND sg13g2_dlygate4sd3_1
XFILLER_114_851 VPWR VGND sg13g2_decap_8
XFILLER_99_551 VPWR VGND sg13g2_decap_8
XFILLER_47_1545 VPWR VGND sg13g2_decap_4
Xhold4758 _22285_/A _24130_/Q VPWR VGND sg13g2_dlygate4sd3_1
Xhold4769 _21016_/A _23547_/Q VPWR VGND sg13g2_dlygate4sd3_1
X_21042_ _21042_/Y _23555_/Q _21042_/B VPWR VGND sg13g2_nand2_1
XFILLER_115_14 VPWR VGND sg13g2_decap_8
XFILLER_113_361 VPWR VGND sg13g2_decap_4
XFILLER_8_1016 VPWR VGND sg13g2_decap_8
XFILLER_8_1038 VPWR VGND sg13g2_fill_2
XFILLER_101_523 VPWR VGND sg13g2_decap_8
XFILLER_87_757 VPWR VGND sg13g2_fill_2
XFILLER_59_459 VPWR VGND sg13g2_decap_8
XFILLER_86_256 VPWR VGND sg13g2_fill_2
XFILLER_28_802 VPWR VGND sg13g2_fill_1
XFILLER_99_1944 VPWR VGND sg13g2_decap_8
X_22993_ _22993_/Q clkload13/A _22993_/D fanout2908/X VPWR VGND sg13g2_dfrbpq_1
XFILLER_27_301 VPWR VGND sg13g2_fill_1
XFILLER_60_1789 VPWR VGND sg13g2_fill_2
XFILLER_112_1868 VPWR VGND sg13g2_decap_8
XFILLER_39_194 VPWR VGND sg13g2_decap_8
XFILLER_27_356 VPWR VGND sg13g2_decap_4
XFILLER_28_879 VPWR VGND sg13g2_decap_8
XFILLER_54_142 VPWR VGND sg13g2_fill_1
XFILLER_76_1218 VPWR VGND sg13g2_fill_2
XFILLER_54_153 VPWR VGND sg13g2_decap_8
XFILLER_55_687 VPWR VGND sg13g2_decap_8
XFILLER_3_1694 VPWR VGND sg13g2_decap_8
XFILLER_42_304 VPWR VGND sg13g2_fill_2
XFILLER_54_164 VPWR VGND sg13g2_decap_8
XFILLER_70_613 VPWR VGND sg13g2_decap_4
X_21875_ _23933_/D _21941_/A1 _21876_/B _21874_/Y VPWR VGND sg13g2_o21ai_1
XFILLER_42_315 VPWR VGND sg13g2_fill_2
XFILLER_70_646 VPWR VGND sg13g2_fill_1
X_23614_ _23614_/Q clkload59/A _23614_/D fanout2788/X VPWR VGND sg13g2_dfrbpq_1
XFILLER_39_1040 VPWR VGND sg13g2_fill_2
XFILLER_58_1663 VPWR VGND sg13g2_fill_2
X_20826_ _23461_/D _21329_/A1 _20827_/B _20825_/Y VPWR VGND sg13g2_o21ai_1
XFILLER_11_702 VPWR VGND sg13g2_decap_8
XFILLER_51_871 VPWR VGND sg13g2_fill_2
X_23545_ _23545_/Q clkload56/A _23545_/D fanout2748/X VPWR VGND sg13g2_dfrbpq_1
XFILLER_51_882 VPWR VGND sg13g2_decap_8
X_20757_ _23428_/D _21261_/A1 _20768_/B _20756_/Y VPWR VGND sg13g2_o21ai_1
XFILLER_36_1950 VPWR VGND sg13g2_decap_4
XFILLER_17_1360 VPWR VGND sg13g2_decap_8
XFILLER_52_1240 VPWR VGND sg13g2_decap_8
X_11490_ _11490_/Y _11476_/Y _11483_/Y _11484_/X _11489_/X VPWR VGND sg13g2_a22oi_1
XFILLER_109_601 VPWR VGND sg13g2_decap_8
X_20688_ _20688_/Y _20688_/A _20690_/B VPWR VGND sg13g2_nand2_1
X_23476_ _23476_/Q clkload29/A _23476_/D fanout2635/X VPWR VGND sg13g2_dfrbpq_1
X_22427_ _24198_/D _22427_/A1 _22434_/B _22426_/Y VPWR VGND sg13g2_o21ai_1
XFILLER_108_133 VPWR VGND sg13g2_decap_8
XFILLER_100_1216 VPWR VGND sg13g2_decap_4
XFILLER_109_678 VPWR VGND sg13g2_decap_8
X_13160_ _13160_/Y _13166_/B _23497_/Q _13159_/Y VPWR VGND sg13g2_o21ai_1
X_22358_ _24165_/D _22425_/A1 _22359_/B _22357_/Y VPWR VGND sg13g2_o21ai_1
XFILLER_30_1582 VPWR VGND sg13g2_decap_4
X_12111_ _12111_/Y _12340_/A _12111_/B VPWR VGND sg13g2_nor2_1
X_21309_ _23676_/D _21309_/A1 _21308_/B _21308_/Y VPWR VGND sg13g2_o21ai_1
X_13091_ _13091_/X _13098_/A _13098_/C _20147_/B VPWR VGND sg13g2_a21o_1
XFILLER_105_840 VPWR VGND sg13g2_decap_8
XFILLER_46_1000 VPWR VGND sg13g2_decap_4
X_22289_ _22289_/Y _22289_/A _22291_/B VPWR VGND sg13g2_nand2_1
XFILLER_65_1623 VPWR VGND sg13g2_decap_8
XFILLER_105_851 VPWR VGND sg13g2_fill_1
XFILLER_2_444 VPWR VGND sg13g2_decap_8
X_12042_ _12042_/Y _22981_/Q _12042_/B _13008_/B VPWR VGND sg13g2_nand3b_1
XFILLER_2_466 VPWR VGND sg13g2_decap_8
XFILLER_3_989 VPWR VGND sg13g2_decap_8
X_24028_ _24028_/Q clkload44/A _24028_/D fanout2748/X VPWR VGND sg13g2_dfrbpq_1
XFILLER_105_884 VPWR VGND sg13g2_decap_4
XFILLER_85_1093 VPWR VGND sg13g2_decap_8
XFILLER_77_212 VPWR VGND sg13g2_decap_4
X_16850_ _16850_/X _22683_/Q _16850_/B VPWR VGND sg13g2_xor2_1
XFILLER_66_919 VPWR VGND sg13g2_decap_4
X_15801_ _15801_/X _17169_/A _22472_/Q _16000_/S VPWR VGND sg13g2_mux2_1
XFILLER_65_407 VPWR VGND sg13g2_fill_1
XFILLER_8_1583 VPWR VGND sg13g2_decap_8
X_16781_ _16781_/Y _16781_/A _16781_/B _16781_/C VPWR VGND sg13g2_nor3_1
XFILLER_77_278 VPWR VGND sg13g2_fill_2
XFILLER_24_1364 VPWR VGND sg13g2_fill_2
XFILLER_77_289 VPWR VGND sg13g2_decap_4
XFILLER_98_1432 VPWR VGND sg13g2_decap_8
XFILLER_20_1217 VPWR VGND sg13g2_fill_1
X_18520_ _18520_/Y _18504_/A _18516_/Y _18519_/Y VPWR VGND sg13g2_a21oi_1
XFILLER_105_91 VPWR VGND sg13g2_decap_8
X_15732_ _15732_/Y _15947_/A1 _15731_/Y _15947_/B1 VPWR VGND sg13g2_o21ai_1
XFILLER_98_1454 VPWR VGND sg13g2_decap_8
X_12944_ _12948_/B _12951_/A _12949_/A VPWR VGND sg13g2_xnor2_1
XFILLER_98_1465 VPWR VGND sg13g2_decap_8
XFILLER_45_131 VPWR VGND sg13g2_decap_4
XFILLER_98_1476 VPWR VGND sg13g2_fill_1
X_18451_ _18451_/Y _18451_/A _18451_/B _18451_/C VPWR VGND sg13g2_nand3_1
XFILLER_61_602 VPWR VGND sg13g2_decap_8
X_15663_ _15663_/Y _22583_/Q _15306_/B _15986_/C1 VPWR VGND sg13g2_a21oi_1
XFILLER_73_473 VPWR VGND sg13g2_decap_8
X_12875_ _12876_/C _23429_/Q _23493_/Q _23589_/Q _23653_/Q _12733_/S _12982_/S1 VPWR
+ VGND sg13g2_mux4_1
XFILLER_61_635 VPWR VGND sg13g2_fill_2
X_14614_ _14614_/Y _14614_/A _14614_/B _14614_/C VPWR VGND sg13g2_nor3_1
XFILLER_57_1140 VPWR VGND sg13g2_fill_1
X_11826_ _11826_/Y _12039_/A _11823_/X _12922_/A2 _23545_/Q _11390_/A VPWR VGND sg13g2_a221oi_1
X_18382_ _18382_/Y _18443_/A _18382_/B _18382_/C _18382_/D VPWR VGND sg13g2_nor4_1
X_15594_ _15594_/Y _22664_/Q _16774_/D _17056_/C _22728_/Q VPWR VGND sg13g2_a22oi_1
XFILLER_14_540 VPWR VGND sg13g2_decap_8
XFILLER_42_860 VPWR VGND sg13g2_decap_4
XFILLER_37_1758 VPWR VGND sg13g2_decap_8
X_17333_ _17333_/Y _17333_/A _17371_/S VPWR VGND sg13g2_nand2_1
XFILLER_72_1638 VPWR VGND sg13g2_decap_8
X_14545_ _24225_/D _14825_/A _14545_/B _14545_/C VPWR VGND sg13g2_nor3_1
X_11757_ _11757_/Y _23256_/Q _11762_/B VPWR VGND sg13g2_nand2b_1
Xplace4009 _12048_/A _12394_/B VPWR VGND sg13g2_buf_2
XFILLER_14_595 VPWR VGND sg13g2_fill_1
XFILLER_18_1179 VPWR VGND sg13g2_fill_1
X_17264_ _17264_/Y _17264_/A _17270_/B VPWR VGND sg13g2_nand2_1
Xplace3308 _22396_/A1 _19750_/Y VPWR VGND sg13g2_buf_1
X_14476_ _14529_/C _14475_/B _14474_/Y _14475_/Y VPWR VGND sg13g2_a21o_1
Xplace3319 _22446_/A1 _20312_/Y VPWR VGND sg13g2_buf_1
X_11688_ _12774_/B _11688_/A _12203_/S VPWR VGND sg13g2_or2_2
X_19003_ _19003_/Y _19003_/A _23089_/Q _19047_/C VPWR VGND sg13g2_nand3_1
XFILLER_35_1482 VPWR VGND sg13g2_decap_4
X_16215_ _19150_/B _16215_/A _16215_/B VPWR VGND sg13g2_nand2_1
XFILLER_50_1947 VPWR VGND sg13g2_decap_8
XFILLER_11_1909 VPWR VGND sg13g2_decap_8
X_13427_ _13428_/D _13624_/A _13427_/B VPWR VGND sg13g2_nor2_1
XFILLER_70_1395 VPWR VGND sg13g2_decap_8
X_17195_ _17196_/B _17195_/A _17218_/B _17195_/C VPWR VGND sg13g2_nor3_1
XFILLER_10_790 VPWR VGND sg13g2_fill_2
X_16146_ _22501_/D _16145_/B _16143_/Y _16145_/Y VPWR VGND sg13g2_o21ai_1
X_13358_ _20195_/A _13362_/B VPWR VGND sg13g2_inv_1
XFILLER_6_794 VPWR VGND sg13g2_decap_8
XFILLER_48_1821 VPWR VGND sg13g2_fill_2
X_12309_ _12309_/X _24190_/Q _23262_/Q _23326_/Q _23390_/Q _12203_/S _12485_/S VPWR
+ VGND sg13g2_mux4_1
XFILLER_83_1712 VPWR VGND sg13g2_decap_4
XFILLER_64_1100 VPWR VGND sg13g2_decap_8
X_13289_ _13289_/Y _14060_/A _13368_/A VPWR VGND sg13g2_nand2_1
XFILLER_114_147 VPWR VGND sg13g2_decap_8
XFILLER_64_1111 VPWR VGND sg13g2_fill_2
XFILLER_102_309 VPWR VGND sg13g2_decap_8
X_19905_ _19905_/Y _20033_/A1 _19877_/B _19663_/X VPWR VGND sg13g2_a21oi_1
X_15028_ _16304_/B _15028_/A _15028_/B _15028_/C VPWR VGND sg13g2_nand3_1
XFILLER_68_201 VPWR VGND sg13g2_decap_8
XFILLER_111_821 VPWR VGND sg13g2_decap_8
XFILLER_9_1336 VPWR VGND sg13g2_decap_8
XFILLER_44_1729 VPWR VGND sg13g2_fill_1
XFILLER_68_212 VPWR VGND sg13g2_fill_1
XFILLER_9_1369 VPWR VGND sg13g2_decap_4
XFILLER_25_1128 VPWR VGND sg13g2_decap_8
XFILLER_64_1188 VPWR VGND sg13g2_decap_8
XFILLER_110_353 VPWR VGND sg13g2_decap_8
XFILLER_111_898 VPWR VGND sg13g2_decap_8
X_19767_ _19767_/Y _19767_/A VPWR VGND sg13g2_inv_1
XFILLER_84_738 VPWR VGND sg13g2_decap_8
XFILLER_68_289 VPWR VGND sg13g2_decap_4
XFILLER_84_749 VPWR VGND sg13g2_fill_1
XFILLER_83_226 VPWR VGND sg13g2_fill_2
X_16979_ _22705_/D _17007_/A1 _16977_/Y _16978_/Y VPWR VGND sg13g2_o21ai_1
XFILLER_65_941 VPWR VGND sg13g2_decap_4
XFILLER_83_248 VPWR VGND sg13g2_decap_8
X_18718_ _18718_/Y _18721_/A _18719_/B _18713_/A VPWR VGND sg13g2_o21ai_1
XFILLER_65_952 VPWR VGND sg13g2_fill_2
X_19698_ _19698_/X _19869_/A _19698_/B VPWR VGND sg13g2_and2_1
XFILLER_65_974 VPWR VGND sg13g2_decap_4
X_18649_ _18657_/D _23007_/Q _23008_/Q VPWR VGND sg13g2_nand2_1
XFILLER_92_793 VPWR VGND sg13g2_decap_8
XFILLER_0_1845 VPWR VGND sg13g2_decap_4
XFILLER_94_1852 VPWR VGND sg13g2_decap_8
XFILLER_91_292 VPWR VGND sg13g2_fill_2
XFILLER_36_197 VPWR VGND sg13g2_decap_4
XFILLER_51_123 VPWR VGND sg13g2_decap_8
X_21660_ _21660_/Y _21660_/A _21666_/B VPWR VGND sg13g2_nand2_1
XFILLER_101_49 VPWR VGND sg13g2_decap_8
XFILLER_55_1825 VPWR VGND sg13g2_decap_8
XFILLER_55_1836 VPWR VGND sg13g2_fill_1
XFILLER_75_1273 VPWR VGND sg13g2_fill_1
X_20611_ _23359_/D _22412_/A1 _20616_/B _20610_/Y VPWR VGND sg13g2_o21ai_1
XFILLER_55_1858 VPWR VGND sg13g2_decap_8
XFILLER_51_189 VPWR VGND sg13g2_decap_8
X_21591_ _23810_/D _21952_/A1 _21590_/B _21590_/Y VPWR VGND sg13g2_o21ai_1
XFILLER_107_1937 VPWR VGND sg13g2_decap_8
XFILLER_71_1137 VPWR VGND sg13g2_decap_8
Xrebuffer5500 _11243_/B _11314_/A VPWR VGND sg13g2_buf_1
X_20542_ _20542_/Y _23327_/Q _20548_/B VPWR VGND sg13g2_nand2_1
X_23330_ _23330_/Q _23682_/CLK _23330_/D fanout2719/X VPWR VGND sg13g2_dfrbpq_1
Xrebuffer5511 rebuffer5511/X rebuffer5512/X VPWR VGND sg13g2_buf_1
Xrebuffer5522 rebuffer5522/X rebuffer5523/X VPWR VGND sg13g2_buf_1
Xrebuffer5533 rebuffer5533/X rebuffer5534/X VPWR VGND sg13g2_buf_1
XFILLER_20_565 VPWR VGND sg13g2_decap_8
XFILLER_14_1533 VPWR VGND sg13g2_fill_2
Xrebuffer5544 rebuffer5544/X rebuffer5545/X VPWR VGND sg13g2_buf_1
Xplace3820 _20266_/A1 _20362_/A1 VPWR VGND sg13g2_buf_1
XFILLER_14_1544 VPWR VGND sg13g2_fill_1
Xplace3831 _13692_/B _13179_/B VPWR VGND sg13g2_buf_2
X_23261_ _23261_/Q clkload55/A _23261_/D fanout2779/X VPWR VGND sg13g2_dfrbpq_1
Xrebuffer5555 rebuffer5555/X _15074_/Y VPWR VGND sg13g2_buf_1
X_20473_ _20473_/Y _20473_/A _20473_/B VPWR VGND sg13g2_nand2_1
Xplace3842 _14707_/A1 _11819_/B VPWR VGND sg13g2_buf_1
Xrebuffer5566 _11712_/B _22986_/Q VPWR VGND sg13g2_buf_1
Xplace3853 _18403_/A _18479_/D VPWR VGND sg13g2_buf_1
Xhold5201 _21378_/A _23709_/Q VPWR VGND sg13g2_dlygate4sd3_1
Xplace3864 _13649_/A _12668_/A VPWR VGND sg13g2_buf_1
Xplace3875 _13350_/A _11447_/A VPWR VGND sg13g2_buf_1
Xplace3886 _19124_/S _19130_/S VPWR VGND sg13g2_buf_1
X_23192_ _23192_/Q _24214_/CLK _23192_/D fanout2928/X VPWR VGND sg13g2_dfrbpq_1
XFILLER_49_1607 VPWR VGND sg13g2_decap_4
XFILLER_106_615 VPWR VGND sg13g2_decap_8
XFILLER_3_219 VPWR VGND sg13g2_decap_8
Xplace3897 _18279_/A _18562_/A VPWR VGND sg13g2_buf_1
XFILLER_69_1055 VPWR VGND sg13g2_decap_8
XFILLER_88_1678 VPWR VGND sg13g2_decap_8
X_22143_ _24062_/D _19947_/Y _22142_/B _22142_/Y VPWR VGND sg13g2_o21ai_1
XFILLER_10_46 VPWR VGND sg13g2_fill_2
XFILLER_105_147 VPWR VGND sg13g2_decap_8
X_22074_ _24029_/D _19921_/Y _22075_/B _22073_/Y VPWR VGND sg13g2_o21ai_1
XFILLER_82_1255 VPWR VGND sg13g2_fill_2
XFILLER_47_1386 VPWR VGND sg13g2_decap_8
X_21025_ _21025_/Y _23550_/Q _21029_/B VPWR VGND sg13g2_nand2_1
XFILLER_102_843 VPWR VGND sg13g2_fill_1
XFILLER_47_1397 VPWR VGND sg13g2_fill_1
XFILLER_82_1299 VPWR VGND sg13g2_fill_1
XFILLER_47_407 VPWR VGND sg13g2_fill_1
XFILLER_59_267 VPWR VGND sg13g2_decap_8
XFILLER_9_1892 VPWR VGND sg13g2_decap_8
XFILLER_101_375 VPWR VGND sg13g2_decap_4
XFILLER_47_429 VPWR VGND sg13g2_decap_8
XFILLER_28_610 VPWR VGND sg13g2_decap_8
XFILLER_19_77 VPWR VGND sg13g2_decap_8
XFILLER_5_1756 VPWR VGND sg13g2_decap_8
XFILLER_68_790 VPWR VGND sg13g2_decap_8
XFILLER_56_941 VPWR VGND sg13g2_decap_8
XFILLER_74_237 VPWR VGND sg13g2_fill_1
XFILLER_60_1586 VPWR VGND sg13g2_decap_4
XFILLER_95_1605 VPWR VGND sg13g2_fill_1
XFILLER_90_719 VPWR VGND sg13g2_decap_8
X_22976_ _22976_/Q _23187_/CLK _22976_/D fanout2918/X VPWR VGND sg13g2_dfrbpq_1
XFILLER_43_602 VPWR VGND sg13g2_decap_4
X_21927_ _21927_/Y _23959_/Q _21965_/S VPWR VGND sg13g2_nand2_1
XFILLER_82_270 VPWR VGND sg13g2_fill_1
XFILLER_15_315 VPWR VGND sg13g2_decap_8
Xinput4410 _19265_/B data_rvalid_i VPWR VGND sg13g2_buf_1
Xinput4421 _17982_/B instr_rdata_i[15] VPWR VGND sg13g2_buf_1
Xinput4432 _18973_/B instr_rdata_i[25] VPWR VGND sg13g2_buf_1
X_12660_ _12660_/Y _23554_/Q _12998_/A2 _12659_/X _13242_/S1 _12443_/A VPWR VGND sg13g2_a221oi_1
X_21858_ _23925_/D _22258_/A1 _21899_/S _21857_/Y VPWR VGND sg13g2_o21ai_1
XFILLER_70_454 VPWR VGND sg13g2_decap_8
Xinput4443 _19122_/A1 instr_rdata_i[6] VPWR VGND sg13g2_buf_1
Xinput4454 _14211_/A irqs_i[15] VPWR VGND sg13g2_buf_1
XFILLER_54_1313 VPWR VGND sg13g2_decap_8
Xinput4465 _15356_/A software_irq_i VPWR VGND sg13g2_buf_1
X_11611_ _11611_/Y _11608_/X _11611_/B VPWR VGND sg13g2_nand2b_1
XFILLER_93_1384 VPWR VGND sg13g2_fill_1
X_20809_ _20809_/Y _20809_/A _20809_/B VPWR VGND sg13g2_nand2_1
X_12591_ _12591_/X _24161_/Q _24193_/Q _23297_/Q _23329_/Q _12809_/A _12906_/A VPWR
+ VGND sg13g2_mux4_1
XFILLER_51_690 VPWR VGND sg13g2_fill_1
X_14330_ _17034_/A _11821_/A _11981_/B _15140_/A VPWR VGND sg13g2_a21oi_2
X_23528_ _23528_/Q clkload50/A _23528_/D fanout2654/X VPWR VGND sg13g2_dfrbpq_1
X_11542_ _11549_/B _11539_/Y _11541_/Y _11418_/A VPWR VGND sg13g2_a21oi_1
XFILLER_51_42 VPWR VGND sg13g2_fill_1
XFILLER_71_1682 VPWR VGND sg13g2_fill_1
X_14261_ _15123_/B _14560_/B VPWR VGND sg13g2_inv_1
XFILLER_11_587 VPWR VGND sg13g2_decap_4
X_23459_ _23459_/Q clkload34/A _23459_/D fanout2701/X VPWR VGND sg13g2_dfrbpq_1
XFILLER_7_547 VPWR VGND sg13g2_decap_8
XFILLER_52_1081 VPWR VGND sg13g2_fill_2
XFILLER_13_1043 VPWR VGND sg13g2_decap_8
XFILLER_13_1054 VPWR VGND sg13g2_fill_2
X_16000_ _16000_/X _17220_/A _22481_/Q _16000_/S VPWR VGND sg13g2_mux2_1
X_13212_ _13215_/C _13212_/A _13212_/B VPWR VGND sg13g2_nor2_1
XFILLER_109_475 VPWR VGND sg13g2_decap_8
XFILLER_32_1699 VPWR VGND sg13g2_decap_8
X_14192_ _14194_/A _14192_/A _14770_/B _14786_/B VPWR VGND sg13g2_nand3_1
XFILLER_10_1942 VPWR VGND sg13g2_decap_8
XFILLER_10_1953 VPWR VGND sg13g2_fill_2
X_13143_ _13146_/C _14146_/B _13143_/B _13143_/C VPWR VGND sg13g2_nor3_1
XFILLER_98_808 VPWR VGND sg13g2_decap_4
XFILLER_100_1079 VPWR VGND sg13g2_decap_8
XFILLER_83_1019 VPWR VGND sg13g2_fill_2
XFILLER_3_742 VPWR VGND sg13g2_decap_8
XFILLER_112_607 VPWR VGND sg13g2_decap_8
XFILLER_65_1442 VPWR VGND sg13g2_decap_4
X_17951_ _17951_/Y _18053_/S _23036_/Q _17950_/Y VPWR VGND sg13g2_a21oi_1
X_16902_ _16903_/B _22690_/Q _16902_/B VPWR VGND sg13g2_nand2_1
X_12025_ _12026_/D _12318_/A _12024_/X _12316_/A VPWR VGND sg13g2_o21ai_1
X_17882_ _17883_/A _17882_/A1 _17926_/A2 _17930_/B _22925_/Q _17881_/Y VPWR VGND sg13g2_a221oi_1
XFILLER_39_919 VPWR VGND sg13g2_fill_2
XFILLER_78_576 VPWR VGND sg13g2_fill_1
X_19621_ _19621_/Y _19782_/A1 _19619_/Y _19620_/Y VPWR VGND sg13g2_a21oi_1
X_16833_ _16844_/D _16833_/A _16833_/B _16833_/C VPWR VGND sg13g2_nor3_2
XFILLER_38_429 VPWR VGND sg13g2_fill_1
XFILLER_78_598 VPWR VGND sg13g2_decap_8
XFILLER_18_7 VPWR VGND sg13g2_decap_8
XFILLER_43_1773 VPWR VGND sg13g2_fill_2
XFILLER_19_621 VPWR VGND sg13g2_decap_8
XFILLER_65_226 VPWR VGND sg13g2_fill_2
XFILLER_93_546 VPWR VGND sg13g2_decap_4
XFILLER_78_1803 VPWR VGND sg13g2_decap_4
X_19552_ _19552_/X _19335_/Y _19355_/Y _19573_/S VPWR VGND sg13g2_mux2_1
XFILLER_98_1240 VPWR VGND sg13g2_decap_8
X_16764_ _16764_/Y _16818_/A _16764_/B VPWR VGND sg13g2_nor2_1
XFILLER_93_568 VPWR VGND sg13g2_decap_8
X_13976_ _13976_/Y _13976_/A VPWR VGND sg13g2_inv_1
XFILLER_59_1202 VPWR VGND sg13g2_decap_8
XFILLER_4_1277 VPWR VGND sg13g2_fill_1
XFILLER_47_985 VPWR VGND sg13g2_decap_8
X_18503_ _18504_/B _18064_/C _18501_/X _18502_/Y VPWR VGND sg13g2_a21oi_1
XFILLER_46_462 VPWR VGND sg13g2_decap_8
X_15715_ _17147_/A _15714_/A _15713_/Y _15714_/Y VPWR VGND sg13g2_a21o_1
XFILLER_18_164 VPWR VGND sg13g2_decap_8
XFILLER_4_1299 VPWR VGND sg13g2_decap_8
X_12927_ _12927_/Y _22564_/Q _12413_/B _13988_/B1 VPWR VGND sg13g2_o21ai_1
X_16695_ _16696_/B _22654_/Q _16695_/B VPWR VGND sg13g2_xnor2_1
X_19483_ _19536_/B _19483_/A _19483_/B VPWR VGND sg13g2_or2_1
XFILLER_18_175 VPWR VGND sg13g2_decap_8
XFILLER_74_793 VPWR VGND sg13g2_decap_8
XFILLER_34_646 VPWR VGND sg13g2_decap_8
XFILLER_59_1268 VPWR VGND sg13g2_fill_1
X_18434_ _18809_/B _19122_/A1 _23068_/Q _18462_/S VPWR VGND sg13g2_mux2_1
XFILLER_34_657 VPWR VGND sg13g2_fill_2
X_15646_ _15649_/C _15646_/A _15646_/B VPWR VGND sg13g2_nor2_1
XFILLER_15_860 VPWR VGND sg13g2_fill_2
XFILLER_62_999 VPWR VGND sg13g2_fill_2
XFILLER_33_167 VPWR VGND sg13g2_decap_8
X_11809_ _11812_/C _12145_/A _11809_/B VPWR VGND sg13g2_nor2_1
X_18365_ _18366_/B _18274_/B _18362_/Y _18364_/Y VPWR VGND sg13g2_o21ai_1
X_15577_ _15578_/D _15577_/A _15577_/B VPWR VGND sg13g2_or2_1
XFILLER_33_189 VPWR VGND sg13g2_decap_8
X_12789_ _12789_/X _23556_/Q _24004_/Q _12789_/S VPWR VGND sg13g2_mux2_1
X_17316_ _22786_/D _17316_/A1 _17315_/B _17315_/Y VPWR VGND sg13g2_o21ai_1
X_14528_ _14529_/D _14601_/B _14528_/B VPWR VGND sg13g2_nor2_1
Xplace3105 _21398_/B _21406_/B VPWR VGND sg13g2_buf_1
Xplace3116 _21247_/B _21242_/B VPWR VGND sg13g2_buf_1
X_17247_ _22754_/D _17316_/A1 _17246_/B _17246_/Y VPWR VGND sg13g2_o21ai_1
XFILLER_50_1744 VPWR VGND sg13g2_decap_8
Xplace3127 _21071_/B _21085_/B VPWR VGND sg13g2_buf_1
XFILLER_15_1864 VPWR VGND sg13g2_decap_8
X_14459_ _19306_/C _14459_/A VPWR VGND sg13g2_inv_1
Xplace3138 _20983_/B _20921_/Y VPWR VGND sg13g2_buf_1
Xplace3149 _20794_/B _20853_/B VPWR VGND sg13g2_buf_1
XFILLER_11_1717 VPWR VGND sg13g2_decap_8
XFILLER_70_1192 VPWR VGND sg13g2_decap_4
XFILLER_102_1856 VPWR VGND sg13g2_decap_8
XFILLER_31_1165 VPWR VGND sg13g2_decap_8
X_17178_ _17218_/B _22738_/Q _22737_/Q _17178_/C _17178_/D VPWR VGND sg13g2_nand4_1
XFILLER_50_1799 VPWR VGND sg13g2_fill_1
XFILLER_115_467 VPWR VGND sg13g2_decap_8
XFILLER_44_0 VPWR VGND sg13g2_decap_8
XFILLER_103_618 VPWR VGND sg13g2_decap_8
XFILLER_97_874 VPWR VGND sg13g2_decap_8
XFILLER_9_1177 VPWR VGND sg13g2_decap_8
XFILLER_110_161 VPWR VGND sg13g2_decap_8
XFILLER_113_1941 VPWR VGND sg13g2_decap_8
XFILLER_111_695 VPWR VGND sg13g2_decap_8
XFILLER_61_1873 VPWR VGND sg13g2_fill_1
XFILLER_84_546 VPWR VGND sg13g2_fill_2
XFILLER_2_1918 VPWR VGND sg13g2_decap_8
X_22830_ _22830_/Q clkload7/A _22830_/D fanout2794/X VPWR VGND sg13g2_dfrbpq_1
XFILLER_22_1857 VPWR VGND sg13g2_decap_8
XFILLER_96_1925 VPWR VGND sg13g2_decap_8
XFILLER_71_207 VPWR VGND sg13g2_fill_2
X_22761_ _22761_/Q clkload22/A _22761_/D fanout2876/X VPWR VGND sg13g2_dfrbpq_1
XFILLER_77_1357 VPWR VGND sg13g2_fill_1
XFILLER_37_495 VPWR VGND sg13g2_fill_1
XFILLER_52_421 VPWR VGND sg13g2_fill_2
XFILLER_52_432 VPWR VGND sg13g2_fill_2
XFILLER_25_657 VPWR VGND sg13g2_fill_2
X_22692_ _22692_/Q clkload23/A _22692_/D fanout2890/X VPWR VGND sg13g2_dfrbpq_1
XFILLER_94_1660 VPWR VGND sg13g2_fill_2
XFILLER_13_819 VPWR VGND sg13g2_fill_1
XFILLER_25_679 VPWR VGND sg13g2_decap_8
XFILLER_36_1021 VPWR VGND sg13g2_decap_4
X_21643_ _23835_/D _21936_/A1 _21642_/B _21642_/Y VPWR VGND sg13g2_o21ai_1
XFILLER_36_1032 VPWR VGND sg13g2_fill_1
XFILLER_75_1092 VPWR VGND sg13g2_decap_8
XFILLER_90_1568 VPWR VGND sg13g2_decap_4
X_21574_ _21574_/Y _21574_/A _21574_/B VPWR VGND sg13g2_nand2_1
XFILLER_20_340 VPWR VGND sg13g2_decap_8
XFILLER_21_874 VPWR VGND sg13g2_decap_8
Xplace4340 _22050_/B _22974_/Q VPWR VGND sg13g2_buf_1
X_23313_ _23313_/Q clkload50/A _23313_/D fanout2662/X VPWR VGND sg13g2_dfrbpq_1
Xplace4351 _16856_/A _22942_/Q VPWR VGND sg13g2_buf_1
Xrebuffer5330 _13509_/A _13932_/A VPWR VGND sg13g2_buf_1
X_20525_ _23319_/D _21299_/A1 _20578_/B _20524_/Y VPWR VGND sg13g2_o21ai_1
Xrebuffer5341 _12249_/B1 _11910_/B VPWR VGND sg13g2_buf_1
Xrebuffer5352 _12488_/B1 _11484_/X VPWR VGND sg13g2_buf_1
Xrebuffer5363 _14973_/A1 _14970_/Y VPWR VGND sg13g2_buf_2
Xplace3650 _15714_/A _13059_/Y VPWR VGND sg13g2_buf_1
XFILLER_88_1431 VPWR VGND sg13g2_decap_8
XFILLER_14_1374 VPWR VGND sg13g2_decap_8
Xrebuffer5374 _11233_/D _14098_/C VPWR VGND sg13g2_buf_1
Xplace3661 _16145_/B _16199_/B VPWR VGND sg13g2_buf_1
X_23244_ _23244_/Q clkload38/A _23244_/D fanout2629/X VPWR VGND sg13g2_dfrbpq_1
Xrebuffer5385 _13525_/B _13503_/A VPWR VGND sg13g2_buf_1
X_20456_ _20456_/Y _23290_/Q _20458_/B VPWR VGND sg13g2_nand2_1
Xplace3672 _15708_/A2 _15662_/A2 VPWR VGND sg13g2_buf_1
XFILLER_10_1227 VPWR VGND sg13g2_fill_2
Xplace3683 _20338_/A _13929_/A VPWR VGND sg13g2_buf_2
Xhold5020 _22210_/A _24094_/Q VPWR VGND sg13g2_dlygate4sd3_1
Xplace3694 _15103_/B1 _14885_/Y VPWR VGND sg13g2_buf_1
Xhold5031 _22234_/A _24106_/Q VPWR VGND sg13g2_dlygate4sd3_1
XFILLER_21_89 VPWR VGND sg13g2_decap_8
XFILLER_49_1426 VPWR VGND sg13g2_decap_8
Xplace2960 _17024_/A _17019_/A VPWR VGND sg13g2_buf_1
Xhold5042 _17403_/A _22821_/Q VPWR VGND sg13g2_dlygate4sd3_1
Xplace2971 _18565_/B _18286_/A VPWR VGND sg13g2_buf_1
XFILLER_106_445 VPWR VGND sg13g2_decap_8
Xhold5053 _20388_/A _23259_/Q VPWR VGND sg13g2_dlygate4sd3_1
X_20387_ _23258_/D _22401_/A1 _20388_/B _20386_/Y VPWR VGND sg13g2_o21ai_1
X_23175_ _23175_/Q _23187_/CLK _23175_/D fanout2915/X VPWR VGND sg13g2_dfrbpq_1
XFILLER_101_1399 VPWR VGND sg13g2_decap_4
Xhold5064 _21794_/A _23895_/Q VPWR VGND sg13g2_dlygate4sd3_1
Xplace2982 _18194_/A _16376_/B VPWR VGND sg13g2_buf_1
XFILLER_84_1339 VPWR VGND sg13g2_decap_8
Xplace2993 _19042_/S _19044_/B VPWR VGND sg13g2_buf_1
Xhold5075 _22428_/A _24199_/Q VPWR VGND sg13g2_dlygate4sd3_1
XFILLER_97_49 VPWR VGND sg13g2_decap_8
XFILLER_0_701 VPWR VGND sg13g2_decap_4
Xhold5086 _22436_/A _24203_/Q VPWR VGND sg13g2_dlygate4sd3_1
X_22126_ _24054_/D _22260_/A1 _22172_/B _22125_/Y VPWR VGND sg13g2_o21ai_1
XFILLER_106_489 VPWR VGND sg13g2_decap_8
Xhold5097 _20809_/A _23454_/Q VPWR VGND sg13g2_dlygate4sd3_1
X_22057_ _24021_/D _22258_/A1 _22069_/B _22056_/Y VPWR VGND sg13g2_o21ai_1
XFILLER_82_1063 VPWR VGND sg13g2_decap_8
XFILLER_47_1183 VPWR VGND sg13g2_decap_4
XFILLER_102_662 VPWR VGND sg13g2_decap_8
XFILLER_88_885 VPWR VGND sg13g2_decap_8
XFILLER_43_1047 VPWR VGND sg13g2_fill_2
XFILLER_102_673 VPWR VGND sg13g2_fill_2
XFILLER_29_941 VPWR VGND sg13g2_fill_2
XFILLER_5_1575 VPWR VGND sg13g2_decap_4
XFILLER_46_42 VPWR VGND sg13g2_decap_4
XFILLER_63_719 VPWR VGND sg13g2_fill_2
XFILLER_44_900 VPWR VGND sg13g2_fill_1
XFILLER_75_579 VPWR VGND sg13g2_fill_2
XFILLER_29_996 VPWR VGND sg13g2_decap_8
XFILLER_56_782 VPWR VGND sg13g2_fill_1
X_13761_ _13810_/B _20290_/A _13721_/B _13760_/Y VPWR VGND sg13g2_a21o_1
X_22959_ _22959_/Q _23187_/CLK _22959_/D fanout2917/X VPWR VGND sg13g2_dfrbpq_1
XFILLER_15_112 VPWR VGND sg13g2_decap_4
XFILLER_43_421 VPWR VGND sg13g2_decap_4
X_15500_ _15500_/Y _15393_/A _15482_/B _16435_/A VPWR VGND sg13g2_o21ai_1
X_12712_ _12712_/Y _12712_/A _12712_/B _12712_/C VPWR VGND sg13g2_nor3_1
X_16480_ _16480_/Y _22603_/Q _16495_/S VPWR VGND sg13g2_nand2_1
X_13692_ _13692_/X _13692_/A _13692_/B _13692_/C _13692_/D VPWR VGND sg13g2_and4_2
XFILLER_70_240 VPWR VGND sg13g2_decap_8
XFILLER_70_251 VPWR VGND sg13g2_decap_8
XFILLER_73_1711 VPWR VGND sg13g2_decap_8
XFILLER_102_70 VPWR VGND sg13g2_decap_8
X_15431_ _15434_/B _15577_/A _15431_/B VPWR VGND sg13g2_nor2_1
X_12643_ _12663_/C _12642_/X _12643_/B VPWR VGND sg13g2_nand2b_1
XFILLER_54_1121 VPWR VGND sg13g2_decap_8
XFILLER_62_41 VPWR VGND sg13g2_decap_4
XFILLER_73_1744 VPWR VGND sg13g2_decap_4
XFILLER_15_189 VPWR VGND sg13g2_decap_8
XFILLER_58_1290 VPWR VGND sg13g2_decap_4
XFILLER_62_52 VPWR VGND sg13g2_decap_8
XFILLER_54_1154 VPWR VGND sg13g2_fill_2
XFILLER_19_1285 VPWR VGND sg13g2_decap_8
X_12574_ _12574_/X _24161_/Q _24193_/Q _23233_/Q _23265_/Q _13274_/S0 _13260_/A1 VPWR
+ VGND sg13g2_mux4_1
XFILLER_19_1296 VPWR VGND sg13g2_decap_4
X_17101_ _17101_/Y _22725_/Q _17101_/B VPWR VGND sg13g2_xnor2_1
X_14313_ _15287_/A _15233_/B _15294_/C _15165_/C VPWR VGND sg13g2_a21oi_1
X_11525_ _11526_/B _13267_/A _11517_/X _11522_/X _13191_/B1 VPWR VGND sg13g2_a22oi_1
X_18081_ _18081_/Y _18064_/Y _18076_/Y _18485_/A VPWR VGND sg13g2_o21ai_1
X_15293_ _15294_/B _16781_/C VPWR VGND sg13g2_inv_1
X_17032_ _17032_/Y _17228_/B _17032_/B VPWR VGND sg13g2_nand2_1
X_14244_ _14244_/Y _14244_/A _14407_/B VPWR VGND sg13g2_nor2_2
XFILLER_32_1485 VPWR VGND sg13g2_decap_8
X_11456_ _11457_/B _22987_/Q _11456_/B VPWR VGND sg13g2_or2_1
XFILLER_109_283 VPWR VGND sg13g2_fill_2
X_14175_ _14175_/Y _14770_/B _14175_/B VPWR VGND sg13g2_nand2_1
X_11387_ _11387_/X _11387_/A _24054_/Q VPWR VGND sg13g2_and2_1
XFILLER_112_415 VPWR VGND sg13g2_decap_8
X_18983_ _23055_/D _18977_/Y _18980_/Y _18981_/Y _18982_/Y VPWR VGND sg13g2_a22oi_1
XFILLER_79_830 VPWR VGND sg13g2_fill_1
XFILLER_26_1212 VPWR VGND sg13g2_fill_1
XFILLER_97_148 VPWR VGND sg13g2_decap_8
XFILLER_45_1835 VPWR VGND sg13g2_decap_8
X_17934_ _17934_/Y _19306_/C _19235_/C _17934_/C VPWR VGND sg13g2_nor3_1
X_13057_ _13077_/D _15735_/A _13057_/B VPWR VGND sg13g2_xnor2_1
XFILLER_87_71 VPWR VGND sg13g2_decap_8
XFILLER_26_1256 VPWR VGND sg13g2_decap_8
XFILLER_39_716 VPWR VGND sg13g2_decap_8
X_12008_ _12032_/D _11517_/S _12005_/Y _12007_/Y VPWR VGND sg13g2_a21oi_1
XFILLER_79_896 VPWR VGND sg13g2_fill_1
X_17865_ _22919_/D _17865_/A _17865_/B VPWR VGND sg13g2_nand2_1
XFILLER_94_855 VPWR VGND sg13g2_fill_2
X_16816_ _16828_/D _16833_/A _16833_/B VPWR VGND sg13g2_nor2_1
XFILLER_94_877 VPWR VGND sg13g2_decap_8
X_17796_ _17796_/Y _22905_/Q _17796_/B VPWR VGND sg13g2_nor2_1
XFILLER_66_579 VPWR VGND sg13g2_decap_8
XFILLER_81_516 VPWR VGND sg13g2_fill_2
XFILLER_35_911 VPWR VGND sg13g2_decap_8
XFILLER_81_527 VPWR VGND sg13g2_decap_8
X_19535_ _19636_/B _19874_/A _19536_/B _19534_/Y VPWR VGND sg13g2_o21ai_1
X_16747_ _22664_/D _17517_/D _16755_/A _16746_/Y VPWR VGND sg13g2_a21oi_1
X_13959_ _13959_/X _24180_/Q _24212_/Q _23252_/Q _23284_/Q _13959_/S0 _13331_/S VPWR
+ VGND sg13g2_mux4_1
XFILLER_81_549 VPWR VGND sg13g2_decap_4
XFILLER_78_1655 VPWR VGND sg13g2_decap_8
XFILLER_1_1951 VPWR VGND sg13g2_decap_4
XFILLER_46_292 VPWR VGND sg13g2_fill_1
XFILLER_34_443 VPWR VGND sg13g2_fill_1
X_16678_ _22651_/D _16677_/Y _17228_/B _16678_/S VPWR VGND sg13g2_mux2_1
XFILLER_35_977 VPWR VGND sg13g2_decap_8
XFILLER_50_914 VPWR VGND sg13g2_decap_8
XFILLER_107_1008 VPWR VGND sg13g2_decap_8
X_18417_ _18417_/Y _18562_/C _18416_/Y _18427_/B VPWR VGND sg13g2_o21ai_1
XFILLER_72_1210 VPWR VGND sg13g2_fill_1
X_15629_ _16107_/B _15629_/A _16352_/B _20040_/A VPWR VGND sg13g2_nand3_1
X_19397_ _19399_/A _19378_/X _19395_/X _19872_/A VPWR VGND sg13g2_mux2_1
XFILLER_50_969 VPWR VGND sg13g2_decap_8
XFILLER_17_1948 VPWR VGND sg13g2_decap_8
X_18348_ _18461_/A _18539_/A _18348_/B VPWR VGND sg13g2_nor2_1
XFILLER_91_1899 VPWR VGND sg13g2_decap_8
XFILLER_104_1929 VPWR VGND sg13g2_decap_8
X_18279_ _18279_/Y _18279_/A _18501_/S VPWR VGND sg13g2_nand2_1
X_20310_ _20310_/X _20310_/A0 _20310_/A1 _20310_/A2 _20310_/A3 _20310_/S0 _20350_/A
+ VPWR VGND sg13g2_mux4_1
XFILLER_11_1525 VPWR VGND sg13g2_decap_8
X_20241_ _23244_/D _20300_/B _20702_/A1 _20240_/Y VPWR VGND sg13g2_o21ai_1
XFILLER_115_231 VPWR VGND sg13g2_decap_8
XFILLER_89_616 VPWR VGND sg13g2_fill_2
XFILLER_85_1659 VPWR VGND sg13g2_decap_8
X_20172_ _20172_/Y _20345_/A1 _20169_/Y _20171_/Y VPWR VGND sg13g2_o21ai_1
XFILLER_88_115 VPWR VGND sg13g2_decap_8
XFILLER_63_1902 VPWR VGND sg13g2_decap_8
XFILLER_103_448 VPWR VGND sg13g2_decap_8
XFILLER_83_1372 VPWR VGND sg13g2_decap_8
XFILLER_24_1919 VPWR VGND sg13g2_decap_8
XFILLER_69_351 VPWR VGND sg13g2_fill_2
X_23931_ _23931_/Q _23966_/CLK _23931_/D fanout2766/X VPWR VGND sg13g2_dfrbpq_1
XFILLER_97_693 VPWR VGND sg13g2_decap_8
XFILLER_85_844 VPWR VGND sg13g2_decap_4
XFILLER_6_1840 VPWR VGND sg13g2_decap_8
XFILLER_84_321 VPWR VGND sg13g2_fill_1
XFILLER_111_492 VPWR VGND sg13g2_decap_8
XFILLER_61_1670 VPWR VGND sg13g2_fill_1
X_23862_ _23862_/Q clkload58/A _23862_/D fanout2757/X VPWR VGND sg13g2_dfrbpq_1
XFILLER_2_1715 VPWR VGND sg13g2_decap_8
XFILLER_96_1711 VPWR VGND sg13g2_decap_8
X_22813_ _22813_/Q clkload19/A _22813_/D fanout2864/X VPWR VGND sg13g2_dfrbpq_1
XFILLER_22_1687 VPWR VGND sg13g2_decap_8
X_23793_ _23793_/Q _24113_/CLK _23793_/D fanout2685/X VPWR VGND sg13g2_dfrbpq_1
XFILLER_96_1755 VPWR VGND sg13g2_decap_8
X_22744_ _22744_/Q clkload21/A _22744_/D fanout2869/X VPWR VGND sg13g2_dfrbpq_1
XFILLER_77_1165 VPWR VGND sg13g2_decap_8
XFILLER_0_1461 VPWR VGND sg13g2_decap_4
XFILLER_25_465 VPWR VGND sg13g2_decap_8
XFILLER_25_498 VPWR VGND sg13g2_decap_8
X_22675_ _22675_/Q clkload21/A _22675_/D fanout2866/X VPWR VGND sg13g2_dfrbpq_1
XFILLER_16_1403 VPWR VGND sg13g2_decap_8
XFILLER_16_1436 VPWR VGND sg13g2_fill_2
XFILLER_90_1376 VPWR VGND sg13g2_decap_8
XFILLER_103_1406 VPWR VGND sg13g2_decap_8
XFILLER_16_1458 VPWR VGND sg13g2_decap_4
XFILLER_51_1338 VPWR VGND sg13g2_decap_8
X_21557_ _21612_/B _22252_/A _21557_/B VPWR VGND sg13g2_nand2_1
Xplace4170 _13251_/B _13253_/S VPWR VGND sg13g2_buf_4
X_11310_ _11310_/Y _11309_/Y _14122_/B VPWR VGND sg13g2_nand2b_1
Xplace4181 _11815_/S1 _22985_/Q VPWR VGND sg13g2_buf_8
Xplace4192 _12134_/S _11706_/S VPWR VGND sg13g2_buf_2
X_20508_ _20508_/Y _23314_/Q _20512_/B VPWR VGND sg13g2_nand2_1
X_24276_ _24276_/X _24276_/A VPWR VGND sg13g2_buf_1
X_12290_ _12300_/B _12284_/X _13611_/A _12289_/Y VPWR VGND sg13g2_o21ai_1
X_21488_ _23763_/D _23763_/Q _21781_/A1 _21488_/S VPWR VGND sg13g2_mux2_1
XFILLER_88_1250 VPWR VGND sg13g2_decap_4
Xplace3480 _16071_/B _16207_/B VPWR VGND sg13g2_buf_1
XFILLER_101_1152 VPWR VGND sg13g2_fill_2
Xplace3491 _15694_/S _15589_/S VPWR VGND sg13g2_buf_1
X_11241_ _11241_/Y _11492_/B _12870_/B _12583_/C VPWR VGND sg13g2_o21ai_1
X_23227_ _23227_/Q clkload54/A _23227_/D fanout2771/X VPWR VGND sg13g2_dfrbpq_1
X_20439_ _20719_/A _21087_/A _21087_/B VPWR VGND sg13g2_and2_1
XFILLER_4_369 VPWR VGND sg13g2_fill_2
XFILLER_107_798 VPWR VGND sg13g2_decap_8
XFILLER_106_275 VPWR VGND sg13g2_fill_2
X_11172_ _19306_/B _19266_/A _23194_/Q VPWR VGND sg13g2_nor2_1
X_23158_ _23158_/Q clkload27/A _23158_/D fanout2859/X VPWR VGND sg13g2_dfrbpq_1
XFILLER_84_1158 VPWR VGND sg13g2_decap_8
XFILLER_66_1570 VPWR VGND sg13g2_fill_1
X_22109_ _24046_/D _22308_/A1 _22108_/B _22108_/Y VPWR VGND sg13g2_o21ai_1
XFILLER_95_608 VPWR VGND sg13g2_fill_1
X_15980_ _15980_/X _17215_/A _22480_/Q _15980_/S VPWR VGND sg13g2_mux2_1
XFILLER_66_1592 VPWR VGND sg13g2_fill_2
X_23089_ _23089_/Q _23215_/CLK _23089_/D fanout2925/X VPWR VGND sg13g2_dfrbpq_1
XFILLER_76_800 VPWR VGND sg13g2_fill_2
XFILLER_94_107 VPWR VGND sg13g2_fill_1
X_14931_ _16320_/A _14923_/Y _15117_/A _14931_/B1 VPWR VGND sg13g2_a21oi_1
XFILLER_48_535 VPWR VGND sg13g2_decap_8
XFILLER_76_844 VPWR VGND sg13g2_decap_8
XFILLER_57_63 VPWR VGND sg13g2_decap_8
XFILLER_40_1732 VPWR VGND sg13g2_decap_8
X_17650_ _17650_/Y _17710_/A1 _17645_/X _17649_/Y VPWR VGND sg13g2_o21ai_1
X_14862_ _14862_/Y _22910_/Q _22911_/Q _14862_/C VPWR VGND sg13g2_nor3_1
XFILLER_36_719 VPWR VGND sg13g2_fill_1
XFILLER_91_814 VPWR VGND sg13g2_fill_1
XFILLER_75_365 VPWR VGND sg13g2_decap_8
XFILLER_21_1142 VPWR VGND sg13g2_decap_8
X_16601_ _16602_/B _22635_/Q _16601_/B VPWR VGND sg13g2_xnor2_1
X_13813_ _13813_/X _13974_/S _24082_/Q VPWR VGND sg13g2_and2_1
XFILLER_75_387 VPWR VGND sg13g2_decap_8
X_17581_ _17581_/Y _16054_/A _17386_/B _17580_/Y VPWR VGND sg13g2_o21ai_1
XFILLER_17_933 VPWR VGND sg13g2_decap_8
XFILLER_40_1787 VPWR VGND sg13g2_fill_2
XFILLER_91_869 VPWR VGND sg13g2_fill_1
XFILLER_113_91 VPWR VGND sg13g2_decap_8
X_16532_ _16533_/B _22620_/Q _16559_/C VPWR VGND sg13g2_nand2_1
X_19320_ _19320_/Y _19320_/A _19320_/B _19320_/C VPWR VGND sg13g2_nand3_1
X_13744_ _13856_/D _13742_/Y _13530_/A _13743_/Y _13530_/B VPWR VGND sg13g2_a22oi_1
XFILLER_44_763 VPWR VGND sg13g2_fill_1
XFILLER_73_62 VPWR VGND sg13g2_fill_1
XFILLER_17_999 VPWR VGND sg13g2_decap_8
XFILLER_31_402 VPWR VGND sg13g2_fill_2
XFILLER_32_936 VPWR VGND sg13g2_decap_8
X_16463_ _16463_/Y _22595_/Q _16470_/B VPWR VGND sg13g2_nand2_1
X_19251_ _19261_/C _19268_/A _19257_/B VPWR VGND sg13g2_nor2_1
X_13675_ _13675_/Y _13675_/A1 _13670_/Y _13672_/Y _13675_/B2 _13674_/Y VPWR VGND sg13g2_a221oi_1
XFILLER_108_1339 VPWR VGND sg13g2_fill_1
X_18202_ _18202_/Y _18290_/C _18259_/B _18232_/B _18425_/A _18194_/A VPWR VGND sg13g2_a221oi_1
XFILLER_73_1563 VPWR VGND sg13g2_fill_2
X_19182_ _23152_/D _23152_/Q _15092_/X _19185_/S VPWR VGND sg13g2_mux2_1
XFILLER_19_1071 VPWR VGND sg13g2_decap_8
XFILLER_31_468 VPWR VGND sg13g2_decap_8
X_16394_ _22563_/D _23013_/Q _22563_/Q _16421_/S VPWR VGND sg13g2_mux2_1
XFILLER_85_7 VPWR VGND sg13g2_fill_1
XFILLER_12_671 VPWR VGND sg13g2_decap_8
X_18133_ _18133_/Y _18133_/A _18535_/B VPWR VGND sg13g2_nand2_1
XFILLER_8_631 VPWR VGND sg13g2_decap_8
XFILLER_34_1569 VPWR VGND sg13g2_fill_1
X_15345_ _15373_/B _22590_/Q _15317_/Y _15296_/Y _22881_/Q VPWR VGND sg13g2_a22oi_1
X_12557_ _12558_/B _12555_/X _12556_/X _12557_/S VPWR VGND sg13g2_mux2_1
XFILLER_89_1025 VPWR VGND sg13g2_decap_4
XFILLER_11_192 VPWR VGND sg13g2_decap_4
XFILLER_8_664 VPWR VGND sg13g2_fill_1
X_11508_ _11508_/X _24149_/Q _23221_/Q _23285_/Q _23349_/Q _11508_/S0 _11295_/A VPWR
+ VGND sg13g2_mux4_1
XFILLER_12_1834 VPWR VGND sg13g2_decap_8
X_18064_ _18064_/Y _18264_/A _18064_/B _18064_/C VPWR VGND sg13g2_nor3_1
XFILLER_7_163 VPWR VGND sg13g2_decap_8
X_12488_ _12489_/D _12772_/B _12487_/X _12488_/B1 VPWR VGND sg13g2_o21ai_1
X_17015_ _17015_/Y _22712_/Q _17015_/B VPWR VGND sg13g2_xnor2_1
XFILLER_98_70 VPWR VGND sg13g2_decap_8
XFILLER_113_757 VPWR VGND sg13g2_decap_8
X_13109_ _13109_/X _24168_/Q _24200_/Q _23304_/Q _23336_/Q _13610_/S0 _13115_/A VPWR
+ VGND sg13g2_mux4_1
XFILLER_112_245 VPWR VGND sg13g2_decap_8
XFILLER_101_908 VPWR VGND sg13g2_decap_8
X_18966_ _18966_/Y _18999_/A _18966_/B VPWR VGND sg13g2_nand2_1
X_17917_ _17917_/Y _17917_/A _17917_/B VPWR VGND sg13g2_nor2_1
X_18897_ _18897_/Y _18953_/A _18897_/B _18897_/C VPWR VGND sg13g2_nand3_1
XFILLER_39_535 VPWR VGND sg13g2_decap_8
XFILLER_94_652 VPWR VGND sg13g2_decap_4
XFILLER_82_803 VPWR VGND sg13g2_decap_8
X_17848_ _22914_/D _16058_/A _17849_/C _17847_/Y VPWR VGND sg13g2_o21ai_1
XFILLER_96_1007 VPWR VGND sg13g2_decap_8
XFILLER_67_888 VPWR VGND sg13g2_decap_4
XFILLER_110_1922 VPWR VGND sg13g2_decap_8
XFILLER_67_899 VPWR VGND sg13g2_decap_4
XFILLER_78_1441 VPWR VGND sg13g2_decap_8
X_17779_ _17779_/Y _23181_/Q _17801_/A2 _17822_/B1 _22989_/Q VPWR VGND sg13g2_a22oi_1
XFILLER_81_357 VPWR VGND sg13g2_decap_4
X_19518_ _19519_/C _20305_/A _19525_/A VPWR VGND sg13g2_nand2_1
XFILLER_23_903 VPWR VGND sg13g2_decap_8
XFILLER_74_1305 VPWR VGND sg13g2_fill_1
X_20790_ _20790_/Y _20790_/A _20794_/B VPWR VGND sg13g2_nand2_1
XFILLER_90_880 VPWR VGND sg13g2_decap_8
XFILLER_23_936 VPWR VGND sg13g2_decap_8
XFILLER_74_1349 VPWR VGND sg13g2_decap_4
X_19449_ _19589_/B _15491_/A _19443_/B _19448_/Y VPWR VGND sg13g2_a21oi_1
XFILLER_52_1603 VPWR VGND sg13g2_fill_2
XFILLER_37_1171 VPWR VGND sg13g2_decap_8
X_22460_ _22460_/Q clkload18/A _22460_/D fanout2827/X VPWR VGND sg13g2_dfrbpq_1
XFILLER_108_1862 VPWR VGND sg13g2_decap_8
XFILLER_56_1794 VPWR VGND sg13g2_fill_2
XFILLER_31_980 VPWR VGND sg13g2_decap_8
XFILLER_104_1726 VPWR VGND sg13g2_fill_2
X_21411_ _23724_/D _21971_/A1 _21416_/B _21410_/Y VPWR VGND sg13g2_o21ai_1
X_22391_ _22391_/Y _22391_/A _22393_/B VPWR VGND sg13g2_nand2_1
XFILLER_30_1901 VPWR VGND sg13g2_fill_2
XFILLER_104_1748 VPWR VGND sg13g2_decap_8
XFILLER_30_490 VPWR VGND sg13g2_decap_8
X_24130_ _24130_/Q clkload43/A _24130_/D fanout2733/X VPWR VGND sg13g2_dfrbpq_1
X_21342_ _23692_/D _21342_/A1 _21347_/B _21341_/Y VPWR VGND sg13g2_o21ai_1
XFILLER_50_1371 VPWR VGND sg13g2_decap_8
X_24061_ _24061_/Q clkload44/A _24061_/D fanout2744/X VPWR VGND sg13g2_dfrbpq_1
X_21273_ _21273_/Y _23659_/Q _21281_/B VPWR VGND sg13g2_nand2_1
XFILLER_104_702 VPWR VGND sg13g2_decap_8
XFILLER_89_402 VPWR VGND sg13g2_decap_4
X_23012_ _23012_/Q _23029_/CLK _23012_/D fanout2809/X VPWR VGND sg13g2_dfrbpq_1
X_20224_ _20224_/Y _20224_/A _20224_/B VPWR VGND sg13g2_nand2_1
XFILLER_11_1399 VPWR VGND sg13g2_decap_8
XFILLER_89_424 VPWR VGND sg13g2_decap_4
XFILLER_89_446 VPWR VGND sg13g2_decap_8
XFILLER_8_1902 VPWR VGND sg13g2_decap_8
X_20155_ _20155_/Y _20154_/X _20352_/A VPWR VGND sg13g2_nand2b_1
XFILLER_28_1841 VPWR VGND sg13g2_decap_8
XFILLER_76_107 VPWR VGND sg13g2_decap_8
XFILLER_115_1833 VPWR VGND sg13g2_decap_8
XFILLER_103_289 VPWR VGND sg13g2_fill_2
X_20086_ _20086_/Y _20229_/A _20085_/A _20085_/Y VPWR VGND sg13g2_o21ai_1
XFILLER_58_855 VPWR VGND sg13g2_fill_2
X_23914_ _23914_/Q clkload45/A _23914_/D fanout2710/X VPWR VGND sg13g2_dfrbpq_1
XFILLER_84_140 VPWR VGND sg13g2_decap_8
XFILLER_73_814 VPWR VGND sg13g2_decap_8
XFILLER_85_685 VPWR VGND sg13g2_fill_2
XFILLER_73_825 VPWR VGND sg13g2_fill_1
XFILLER_57_387 VPWR VGND sg13g2_fill_2
XFILLER_27_55 VPWR VGND sg13g2_fill_2
X_23845_ _23845_/Q clkload39/A _23845_/D fanout2732/X VPWR VGND sg13g2_dfrbpq_1
XFILLER_73_847 VPWR VGND sg13g2_fill_1
XFILLER_2_1567 VPWR VGND sg13g2_fill_2
XFILLER_22_1495 VPWR VGND sg13g2_fill_2
XFILLER_26_752 VPWR VGND sg13g2_decap_8
XFILLER_57_1514 VPWR VGND sg13g2_fill_2
XFILLER_57_1525 VPWR VGND sg13g2_fill_2
X_23776_ _23776_/Q clkload43/A _23776_/D fanout2732/X VPWR VGND sg13g2_dfrbpq_1
X_11790_ _11791_/B _23225_/Q _23353_/Q _11792_/S VPWR VGND sg13g2_mux2_1
XFILLER_57_1536 VPWR VGND sg13g2_decap_8
X_20988_ _23538_/D _21980_/A1 _20990_/B _20987_/Y VPWR VGND sg13g2_o21ai_1
XFILLER_25_262 VPWR VGND sg13g2_decap_8
XFILLER_81_891 VPWR VGND sg13g2_decap_8
XFILLER_25_273 VPWR VGND sg13g2_fill_2
X_22727_ _22727_/Q clkload22/A _22727_/D fanout2886/X VPWR VGND sg13g2_dfrbpq_1
XFILLER_14_947 VPWR VGND sg13g2_decap_4
XFILLER_43_21 VPWR VGND sg13g2_decap_8
XFILLER_109_1637 VPWR VGND sg13g2_decap_8
XFILLER_25_284 VPWR VGND sg13g2_decap_8
XFILLER_14_969 VPWR VGND sg13g2_decap_8
XFILLER_13_435 VPWR VGND sg13g2_decap_4
XFILLER_25_295 VPWR VGND sg13g2_fill_2
XFILLER_43_43 VPWR VGND sg13g2_decap_8
XFILLER_13_446 VPWR VGND sg13g2_decap_4
X_13460_ _13460_/X _23437_/Q _23501_/Q _23597_/Q _23661_/Q _13643_/S _13639_/S1 VPWR
+ VGND sg13g2_mux4_1
X_22658_ _22658_/Q clkload24/A _22658_/D fanout2889/X VPWR VGND sg13g2_dfrbpq_1
XFILLER_74_1894 VPWR VGND sg13g2_decap_4
XFILLER_9_439 VPWR VGND sg13g2_fill_1
XFILLER_41_799 VPWR VGND sg13g2_fill_2
X_12411_ _12412_/A _12606_/A _12411_/B VPWR VGND sg13g2_nor2_1
X_21609_ _21609_/Y _21609_/A _21615_/B VPWR VGND sg13g2_nand2_1
X_13391_ _13391_/X _13636_/A _13391_/B VPWR VGND sg13g2_or2_1
XFILLER_16_1277 VPWR VGND sg13g2_decap_8
X_22589_ _22589_/Q _22917_/CLK _22589_/D fanout2871/X VPWR VGND sg13g2_dfrbpq_1
XFILLER_12_1119 VPWR VGND sg13g2_decap_8
X_15130_ _24232_/D _18567_/B _15131_/B _15129_/Y VPWR VGND sg13g2_a21oi_1
X_12342_ _12342_/X _12429_/A _14340_/A _12429_/B VPWR VGND sg13g2_and3_1
XFILLER_16_1299 VPWR VGND sg13g2_decap_8
XFILLER_111_0 VPWR VGND sg13g2_decap_8
X_12273_ _12273_/Y _12837_/A _19861_/A VPWR VGND sg13g2_nor2_1
X_24259_ _24259_/X _24259_/A VPWR VGND sg13g2_buf_1
XFILLER_4_144 VPWR VGND sg13g2_decap_8
XFILLER_107_562 VPWR VGND sg13g2_decap_8
XFILLER_29_1616 VPWR VGND sg13g2_fill_2
XFILLER_29_1649 VPWR VGND sg13g2_decap_4
XFILLER_108_91 VPWR VGND sg13g2_decap_8
X_18820_ _23037_/D _18820_/A _18820_/B _18820_/C VPWR VGND sg13g2_nand3_1
XFILLER_89_980 VPWR VGND sg13g2_fill_1
XFILLER_49_822 VPWR VGND sg13g2_decap_8
X_15963_ _16195_/A _20322_/A _15963_/B VPWR VGND sg13g2_nor2_1
XFILLER_42_1838 VPWR VGND sg13g2_decap_8
X_17702_ _17702_/Y _22893_/Q _17702_/B VPWR VGND sg13g2_nor2_1
XFILLER_48_343 VPWR VGND sg13g2_decap_4
XFILLER_23_1248 VPWR VGND sg13g2_fill_1
X_15894_ _15896_/C _22866_/Q _15966_/B1 _16004_/B1 _22831_/Q VPWR VGND sg13g2_a22oi_1
XFILLER_49_888 VPWR VGND sg13g2_decap_8
XFILLER_64_814 VPWR VGND sg13g2_decap_8
XFILLER_97_1338 VPWR VGND sg13g2_decap_8
XFILLER_48_398 VPWR VGND sg13g2_decap_8
XFILLER_90_110 VPWR VGND sg13g2_decap_8
X_14845_ _14845_/Y _22517_/Q VPWR VGND sg13g2_inv_1
XFILLER_29_590 VPWR VGND sg13g2_fill_1
XFILLER_79_1761 VPWR VGND sg13g2_fill_1
XFILLER_91_666 VPWR VGND sg13g2_decap_8
XFILLER_79_1783 VPWR VGND sg13g2_fill_1
X_17564_ _17564_/Y _11247_/B _17573_/A _17563_/Y VPWR VGND sg13g2_o21ai_1
X_14776_ _14777_/A _22912_/Q _14872_/A _14774_/X VPWR VGND sg13g2_o21ai_1
XFILLER_16_262 VPWR VGND sg13g2_fill_1
X_19303_ _23220_/D _23220_/Q _20349_/A2 _19303_/S VPWR VGND sg13g2_mux2_1
XFILLER_44_571 VPWR VGND sg13g2_decap_8
XFILLER_72_880 VPWR VGND sg13g2_decap_8
X_16515_ _22617_/D _16203_/A _16514_/B _16514_/Y VPWR VGND sg13g2_o21ai_1
X_13727_ _13856_/A _13541_/Y _13546_/B _13726_/Y VPWR VGND sg13g2_a21o_1
XFILLER_16_295 VPWR VGND sg13g2_fill_1
X_17495_ _22864_/D _16175_/A _17498_/B _17494_/Y VPWR VGND sg13g2_o21ai_1
X_19234_ _23187_/D _24276_/A _23187_/Q _19234_/S VPWR VGND sg13g2_mux2_1
XFILLER_53_1923 VPWR VGND sg13g2_decap_8
XFILLER_108_1158 VPWR VGND sg13g2_decap_4
X_16446_ _22587_/D _17444_/A1 _16456_/B _16445_/Y VPWR VGND sg13g2_o21ai_1
X_13658_ _20260_/A _13733_/B VPWR VGND sg13g2_inv_2
Xclkbuf_leaf_61_clk_i _24214_/CLK clkbuf_4_8__f_clk_i/X VPWR VGND sg13g2_buf_16
XFILLER_14_1907 VPWR VGND sg13g2_decap_8
XFILLER_20_939 VPWR VGND sg13g2_decap_4
XFILLER_32_799 VPWR VGND sg13g2_decap_8
X_12609_ _12609_/Y _23168_/Q _12640_/B _13182_/B2 _12608_/X VPWR VGND sg13g2_a22oi_1
XFILLER_73_1393 VPWR VGND sg13g2_decap_4
X_19165_ _23137_/D _23137_/Q _14944_/X _19169_/S VPWR VGND sg13g2_mux2_1
X_16377_ _22550_/D _15279_/Y _16376_/B _16376_/Y VPWR VGND sg13g2_o21ai_1
X_13589_ _13589_/Y _24014_/Q _13589_/B VPWR VGND sg13g2_nand2b_1
XFILLER_12_490 VPWR VGND sg13g2_decap_8
X_15328_ _15328_/Y _22622_/Q _15323_/X _15325_/Y _22686_/Q VPWR VGND sg13g2_a22oi_1
X_18116_ _18116_/Y _18116_/A _18119_/S VPWR VGND sg13g2_nand2_1
X_19096_ _19096_/X _18940_/A _23116_/Q _19098_/S VPWR VGND sg13g2_mux2_1
XFILLER_51_1691 VPWR VGND sg13g2_decap_8
XFILLER_69_2 VPWR VGND sg13g2_fill_1
XFILLER_103_1781 VPWR VGND sg13g2_decap_8
X_15259_ _15260_/B _15238_/B _15256_/Y _15258_/Y VPWR VGND sg13g2_a21oi_1
XFILLER_86_1721 VPWR VGND sg13g2_decap_8
X_18047_ _18047_/Y _18009_/A _23039_/Q _18046_/Y VPWR VGND sg13g2_a21oi_1
Xhold4907 _21576_/A _23804_/Q VPWR VGND sg13g2_dlygate4sd3_1
XFILLER_12_1697 VPWR VGND sg13g2_decap_8
Xhold4918 _20426_/A _23278_/Q VPWR VGND sg13g2_dlygate4sd3_1
Xhold4929 _20473_/A _23298_/Q VPWR VGND sg13g2_dlygate4sd3_1
XFILLER_67_1142 VPWR VGND sg13g2_fill_1
XFILLER_98_210 VPWR VGND sg13g2_fill_1
XFILLER_86_1798 VPWR VGND sg13g2_decap_4
XFILLER_99_766 VPWR VGND sg13g2_decap_8
XFILLER_113_554 VPWR VGND sg13g2_decap_8
XFILLER_59_608 VPWR VGND sg13g2_decap_4
XFILLER_63_1039 VPWR VGND sg13g2_decap_8
XFILLER_28_1159 VPWR VGND sg13g2_fill_1
XFILLER_100_215 VPWR VGND sg13g2_fill_2
XFILLER_80_1353 VPWR VGND sg13g2_fill_1
X_18949_ _18949_/Y _23052_/Q _19041_/A _18960_/B1 VPWR VGND sg13g2_o21ai_1
XFILLER_39_310 VPWR VGND sg13g2_decap_8
XFILLER_60_1927 VPWR VGND sg13g2_fill_1
XFILLER_80_1364 VPWR VGND sg13g2_decap_4
XFILLER_79_490 VPWR VGND sg13g2_fill_2
XFILLER_95_950 VPWR VGND sg13g2_fill_2
X_21960_ _23974_/D _21960_/A1 _21961_/B _21959_/Y VPWR VGND sg13g2_o21ai_1
XFILLER_67_674 VPWR VGND sg13g2_decap_8
XFILLER_104_49 VPWR VGND sg13g2_decap_8
XFILLER_23_1760 VPWR VGND sg13g2_fill_1
X_20911_ _23502_/D _22308_/A1 _20913_/B _20910_/Y VPWR VGND sg13g2_o21ai_1
XFILLER_94_493 VPWR VGND sg13g2_decap_8
XFILLER_39_398 VPWR VGND sg13g2_fill_1
XFILLER_66_184 VPWR VGND sg13g2_decap_8
Xclkbuf_leaf_14_clk_i clkload21/A clkbuf_leaf_6_clk_i/A VPWR VGND sg13g2_buf_16
X_21891_ _21891_/Y _21891_/A _21893_/B VPWR VGND sg13g2_nand2_1
XFILLER_3_1876 VPWR VGND sg13g2_decap_8
X_23630_ _23630_/Q clkload36/A _23630_/D fanout2641/X VPWR VGND sg13g2_dfrbpq_1
XFILLER_97_1883 VPWR VGND sg13g2_fill_2
X_20842_ _23468_/D _21342_/A1 _20841_/B _20841_/Y VPWR VGND sg13g2_o21ai_1
XFILLER_54_368 VPWR VGND sg13g2_fill_2
XFILLER_58_1845 VPWR VGND sg13g2_decap_8
XFILLER_110_1796 VPWR VGND sg13g2_decap_8
XFILLER_78_1282 VPWR VGND sg13g2_decap_4
XFILLER_93_1747 VPWR VGND sg13g2_decap_8
XFILLER_63_891 VPWR VGND sg13g2_decap_8
X_23561_ _23561_/Q _24205_/CLK _23561_/D fanout2650/X VPWR VGND sg13g2_dfrbpq_1
X_20773_ _23436_/D _20237_/Y _20772_/B _20772_/Y VPWR VGND sg13g2_o21ai_1
XFILLER_22_221 VPWR VGND sg13g2_fill_2
XFILLER_50_530 VPWR VGND sg13g2_fill_1
X_22512_ _22512_/Q clkload9/A _22512_/D fanout2824/X VPWR VGND sg13g2_dfrbpq_1
Xclkbuf_leaf_29_clk_i clkload52/A clkload3/A VPWR VGND sg13g2_buf_16
XFILLER_17_1531 VPWR VGND sg13g2_decap_4
X_23492_ _23492_/Q clkload41/A _23492_/D fanout2702/X VPWR VGND sg13g2_dfrbpq_1
X_22443_ _24207_/D _24207_/Q _20280_/Y _22449_/S VPWR VGND sg13g2_mux2_1
XFILLER_104_1523 VPWR VGND sg13g2_decap_4
XFILLER_52_1488 VPWR VGND sg13g2_fill_1
XFILLER_30_1720 VPWR VGND sg13g2_fill_1
XFILLER_109_849 VPWR VGND sg13g2_decap_8
X_22374_ _22374_/Y _22374_/A _22374_/B VPWR VGND sg13g2_nand2_1
XFILLER_104_1589 VPWR VGND sg13g2_fill_1
XFILLER_108_348 VPWR VGND sg13g2_fill_2
X_24113_ _24113_/Q _24113_/CLK _24113_/D fanout2682/X VPWR VGND sg13g2_dfrbpq_1
X_21325_ _23683_/D _21325_/A1 _21332_/B _21324_/Y VPWR VGND sg13g2_o21ai_1
X_24044_ _24044_/Q _24210_/CLK _24044_/D fanout2642/X VPWR VGND sg13g2_dfrbpq_1
X_21256_ _21256_/Y _23650_/Q _21264_/B VPWR VGND sg13g2_nand2_1
Xfanout2629 fanout2629/X fanout2631/X VPWR VGND sg13g2_buf_1
X_20207_ _20207_/Y _14399_/B _15816_/B _20367_/B VPWR VGND sg13g2_a21oi_1
XFILLER_104_554 VPWR VGND sg13g2_decap_8
X_21187_ _23617_/D _21321_/A1 _21188_/B _21186_/Y VPWR VGND sg13g2_o21ai_1
XFILLER_46_1259 VPWR VGND sg13g2_decap_8
X_20138_ _20139_/B _20307_/A _20138_/B VPWR VGND sg13g2_nor2_1
XFILLER_115_1641 VPWR VGND sg13g2_decap_8
XFILLER_8_1776 VPWR VGND sg13g2_decap_8
XFILLER_98_1603 VPWR VGND sg13g2_decap_8
XFILLER_111_1505 VPWR VGND sg13g2_fill_1
X_12960_ _12960_/Y _15227_/A _19446_/A VPWR VGND sg13g2_nand2_1
X_20069_ _20069_/Y _20069_/A _20069_/B _20069_/C _20069_/D VPWR VGND sg13g2_nand4_1
XFILLER_92_419 VPWR VGND sg13g2_decap_8
XFILLER_58_674 VPWR VGND sg13g2_decap_8
XFILLER_18_516 VPWR VGND sg13g2_decap_8
XFILLER_79_1013 VPWR VGND sg13g2_decap_8
X_11911_ _11911_/X _11911_/A _13179_/B _13123_/A VPWR VGND sg13g2_and3_1
XFILLER_79_1024 VPWR VGND sg13g2_fill_2
XFILLER_100_793 VPWR VGND sg13g2_fill_2
XFILLER_59_1609 VPWR VGND sg13g2_fill_1
X_12891_ _12891_/X _23557_/Q _24005_/Q _13264_/B VPWR VGND sg13g2_mux2_1
XFILLER_73_644 VPWR VGND sg13g2_fill_2
XFILLER_72_121 VPWR VGND sg13g2_decap_8
XFILLER_73_655 VPWR VGND sg13g2_decap_4
X_14630_ _14631_/C _15407_/A _14699_/B _14629_/Y VPWR VGND sg13g2_o21ai_1
XFILLER_73_666 VPWR VGND sg13g2_decap_8
X_11842_ _11842_/Y _12235_/S _23577_/Q _11841_/Y VPWR VGND sg13g2_o21ai_1
X_23828_ _23828_/Q clkload29/A _23828_/D fanout2670/X VPWR VGND sg13g2_dfrbpq_1
XFILLER_76_1923 VPWR VGND sg13g2_fill_2
XFILLER_96_1371 VPWR VGND sg13g2_fill_1
X_14561_ _14561_/Y _24229_/Q VPWR VGND sg13g2_inv_1
X_23759_ _23759_/Q clkload30/A _23759_/D fanout2656/X VPWR VGND sg13g2_dfrbpq_1
X_11773_ _11773_/Y _23159_/Q VPWR VGND sg13g2_inv_1
XFILLER_18_1317 VPWR VGND sg13g2_decap_8
XFILLER_14_744 VPWR VGND sg13g2_fill_2
XFILLER_109_1445 VPWR VGND sg13g2_decap_4
X_13512_ _13512_/Y _20229_/B VPWR VGND sg13g2_inv_1
XFILLER_13_243 VPWR VGND sg13g2_decap_8
X_16300_ _22534_/D _16300_/A _16314_/C VPWR VGND sg13g2_xnor2_1
XFILLER_53_1219 VPWR VGND sg13g2_decap_8
X_17280_ _22769_/D _16142_/A _17284_/B _17279_/Y VPWR VGND sg13g2_o21ai_1
X_14492_ _14496_/A _22611_/Q _23022_/Q VPWR VGND sg13g2_xor2_1
XFILLER_70_1511 VPWR VGND sg13g2_fill_2
XFILLER_110_70 VPWR VGND sg13g2_decap_8
XFILLER_13_287 VPWR VGND sg13g2_decap_4
X_16231_ _18619_/A _16230_/Y _16231_/B VPWR VGND sg13g2_nand2b_1
XFILLER_103_1000 VPWR VGND sg13g2_decap_8
XFILLER_9_269 VPWR VGND sg13g2_decap_4
XFILLER_70_63 VPWR VGND sg13g2_decap_8
Xclkload17 clkload17/Y clkload17/A VPWR VGND sg13g2_inv_2
X_13374_ _13374_/Y _13970_/A _13187_/Y _13290_/X _13373_/Y _13217_/Y VPWR VGND sg13g2_a221oi_1
XFILLER_6_932 VPWR VGND sg13g2_decap_8
Xclkload28 clkload28/X clkload28/A VPWR VGND sg13g2_buf_16
XFILLER_103_1066 VPWR VGND sg13g2_fill_2
X_15113_ _15115_/A _22513_/Q _15113_/B VPWR VGND sg13g2_nand2_1
Xclkload39 clkload39/Y clkload39/A VPWR VGND sg13g2_inv_2
XFILLER_86_1017 VPWR VGND sg13g2_decap_8
XFILLER_6_954 VPWR VGND sg13g2_fill_2
XFILLER_100_1932 VPWR VGND sg13g2_decap_8
XFILLER_6_965 VPWR VGND sg13g2_decap_8
X_16093_ _16093_/Y _22492_/Q _16119_/B _16092_/Y VPWR VGND sg13g2_a21oi_1
XFILLER_108_860 VPWR VGND sg13g2_decap_8
XFILLER_6_987 VPWR VGND sg13g2_fill_1
X_15044_ _19176_/A _15073_/A _15034_/Y _18712_/A _15043_/Y VPWR VGND sg13g2_a22oi_1
X_19921_ _19921_/Y _19921_/A _19921_/B VPWR VGND sg13g2_nor2_1
X_12256_ _12256_/Y _12256_/A _12256_/B _12256_/C _12256_/D VPWR VGND sg13g2_nor4_2
XFILLER_68_1473 VPWR VGND sg13g2_fill_2
XFILLER_48_7 VPWR VGND sg13g2_decap_8
XFILLER_68_1495 VPWR VGND sg13g2_decap_4
X_19852_ _19852_/Y _20343_/A2 _19514_/Y _19848_/Y _20343_/S0 VPWR VGND sg13g2_a22oi_1
XFILLER_29_1457 VPWR VGND sg13g2_decap_4
XFILLER_64_1337 VPWR VGND sg13g2_decap_8
X_12187_ _12188_/B _23709_/Q _23773_/Q _12191_/S VPWR VGND sg13g2_mux2_1
XFILLER_64_1348 VPWR VGND sg13g2_fill_2
XFILLER_95_202 VPWR VGND sg13g2_fill_1
X_18803_ _18803_/Y _18803_/A _18803_/B VPWR VGND sg13g2_nand2_1
XFILLER_81_1651 VPWR VGND sg13g2_decap_8
XFILLER_7_1231 VPWR VGND sg13g2_fill_2
X_19783_ _19784_/B _19886_/A1 _20310_/A0 _19509_/Y _23217_/Q VPWR VGND sg13g2_a22oi_1
X_16995_ _16995_/Y _22708_/Q _16995_/B VPWR VGND sg13g2_xnor2_1
XFILLER_110_557 VPWR VGND sg13g2_decap_8
XFILLER_23_1023 VPWR VGND sg13g2_fill_2
X_15946_ _15946_/Y _22744_/Q _15946_/A2 _15946_/B1 _22680_/Q VPWR VGND sg13g2_a22oi_1
XFILLER_3_1106 VPWR VGND sg13g2_decap_4
XFILLER_48_151 VPWR VGND sg13g2_fill_2
XFILLER_49_685 VPWR VGND sg13g2_fill_2
XFILLER_23_1067 VPWR VGND sg13g2_decap_8
X_18665_ _18666_/D _23003_/Q _23005_/Q _23006_/Q _23011_/Q VPWR VGND sg13g2_nand4_1
XFILLER_20_1933 VPWR VGND sg13g2_decap_8
XFILLER_48_195 VPWR VGND sg13g2_decap_8
X_15877_ _15882_/B _15944_/A _15877_/B VPWR VGND sg13g2_or2_1
XFILLER_58_1108 VPWR VGND sg13g2_fill_2
XFILLER_64_655 VPWR VGND sg13g2_decap_8
XFILLER_40_1392 VPWR VGND sg13g2_fill_1
X_17616_ _17617_/B _17689_/B1 _17613_/X _17615_/Y _17538_/B VPWR VGND sg13g2_a22oi_1
X_14828_ _16231_/B _14828_/A _15029_/B VPWR VGND sg13g2_nor2_1
X_18596_ _18596_/X _18339_/A _18623_/A _18880_/C VPWR VGND sg13g2_a21o_1
XFILLER_45_880 VPWR VGND sg13g2_fill_2
XFILLER_75_1422 VPWR VGND sg13g2_fill_2
XFILLER_51_327 VPWR VGND sg13g2_fill_1
XFILLER_63_187 VPWR VGND sg13g2_decap_8
XFILLER_45_891 VPWR VGND sg13g2_decap_8
X_14759_ _14760_/C _14175_/Y _14448_/C _14758_/Y VPWR VGND sg13g2_o21ai_1
XFILLER_71_1308 VPWR VGND sg13g2_fill_1
XFILLER_32_552 VPWR VGND sg13g2_decap_4
XFILLER_60_861 VPWR VGND sg13g2_decap_8
X_17478_ _22856_/D _17884_/A _17502_/S _17477_/Y VPWR VGND sg13g2_o21ai_1
XFILLER_18_1851 VPWR VGND sg13g2_decap_4
XFILLER_32_585 VPWR VGND sg13g2_decap_4
X_19217_ _23173_/D _24262_/A _23173_/Q _19234_/S VPWR VGND sg13g2_mux2_1
X_16429_ _16429_/Y _16429_/A _16431_/B VPWR VGND sg13g2_nand2_1
XFILLER_14_1726 VPWR VGND sg13g2_decap_8
XFILLER_20_758 VPWR VGND sg13g2_fill_1
XFILLER_30_1005 VPWR VGND sg13g2_decap_8
XFILLER_74_0 VPWR VGND sg13g2_decap_8
X_19148_ _23124_/D _23124_/Q _19028_/A _19149_/S VPWR VGND sg13g2_mux2_1
XFILLER_101_1729 VPWR VGND sg13g2_decap_8
XFILLER_105_1898 VPWR VGND sg13g2_decap_8
XFILLER_69_1215 VPWR VGND sg13g2_fill_1
XFILLER_106_808 VPWR VGND sg13g2_decap_8
X_19079_ _19079_/X _17994_/B _23108_/Q _19085_/S VPWR VGND sg13g2_mux2_1
Xhold4704 _17433_/A _22837_/Q VPWR VGND sg13g2_dlygate4sd3_1
Xhold4715 _20799_/A _23449_/Q VPWR VGND sg13g2_dlygate4sd3_1
X_21110_ _21110_/Y _21110_/A _21112_/B VPWR VGND sg13g2_nand2_1
Xhold4726 _22129_/A _24056_/Q VPWR VGND sg13g2_dlygate4sd3_1
XFILLER_47_1502 VPWR VGND sg13g2_decap_8
XFILLER_114_830 VPWR VGND sg13g2_decap_8
X_22090_ _24036_/D _22356_/A1 _22075_/B _22089_/Y VPWR VGND sg13g2_o21ai_1
XFILLER_86_1573 VPWR VGND sg13g2_decap_8
Xhold4737 _22181_/A _24082_/Q VPWR VGND sg13g2_dlygate4sd3_1
Xhold4748 _21459_/A _23747_/Q VPWR VGND sg13g2_dlygate4sd3_1
Xhold4759 _22127_/A _24055_/Q VPWR VGND sg13g2_dlygate4sd3_1
XFILLER_86_1595 VPWR VGND sg13g2_decap_8
XFILLER_113_340 VPWR VGND sg13g2_fill_2
XFILLER_82_1448 VPWR VGND sg13g2_decap_8
XFILLER_101_502 VPWR VGND sg13g2_decap_8
XFILLER_86_213 VPWR VGND sg13g2_decap_8
XFILLER_64_1882 VPWR VGND sg13g2_decap_8
XFILLER_60_1724 VPWR VGND sg13g2_fill_1
XFILLER_45_1281 VPWR VGND sg13g2_decap_8
XFILLER_60_1746 VPWR VGND sg13g2_fill_1
XFILLER_101_579 VPWR VGND sg13g2_decap_8
XFILLER_99_1923 VPWR VGND sg13g2_decap_8
XFILLER_5_1938 VPWR VGND sg13g2_decap_8
X_22992_ _22992_/Q _23187_/CLK _22992_/D fanout2916/X VPWR VGND sg13g2_dfrbpq_1
XFILLER_112_1847 VPWR VGND sg13g2_decap_8
XFILLER_25_1899 VPWR VGND sg13g2_decap_8
XFILLER_27_313 VPWR VGND sg13g2_decap_8
XFILLER_28_847 VPWR VGND sg13g2_decap_8
XFILLER_67_482 VPWR VGND sg13g2_fill_1
X_21943_ _23966_/D _21943_/A1 _21942_/B _21942_/Y VPWR VGND sg13g2_o21ai_1
XFILLER_27_335 VPWR VGND sg13g2_decap_8
XFILLER_83_964 VPWR VGND sg13g2_decap_8
XFILLER_3_1651 VPWR VGND sg13g2_decap_4
XFILLER_82_441 VPWR VGND sg13g2_decap_4
XFILLER_82_452 VPWR VGND sg13g2_fill_1
X_21874_ _21874_/Y _23933_/Q _21876_/B VPWR VGND sg13g2_nand2_1
XFILLER_91_29 VPWR VGND sg13g2_fill_1
X_23613_ _23613_/Q clkload59/A _23613_/D fanout2788/X VPWR VGND sg13g2_dfrbpq_1
XFILLER_19_1615 VPWR VGND sg13g2_fill_2
X_20825_ _20825_/Y _23461_/Q _20827_/B VPWR VGND sg13g2_nand2_1
XFILLER_70_658 VPWR VGND sg13g2_fill_2
XFILLER_39_1074 VPWR VGND sg13g2_decap_8
XFILLER_54_1528 VPWR VGND sg13g2_decap_8
X_23544_ _23544_/Q clkload46/A _23544_/D fanout2676/X VPWR VGND sg13g2_dfrbpq_1
X_20756_ _20756_/Y _23428_/Q _20768_/B VPWR VGND sg13g2_nand2_1
XFILLER_71_1831 VPWR VGND sg13g2_decap_4
X_23475_ _23475_/Q clkload51/A _23475_/D fanout2665/X VPWR VGND sg13g2_dfrbpq_1
XFILLER_91_1290 VPWR VGND sg13g2_fill_2
XFILLER_13_1203 VPWR VGND sg13g2_fill_2
XFILLER_10_235 VPWR VGND sg13g2_decap_8
X_20687_ _23396_/D _21261_/A1 _20690_/B _20686_/Y VPWR VGND sg13g2_o21ai_1
X_22426_ _22426_/Y _22426_/A _22434_/B VPWR VGND sg13g2_nand2_1
XFILLER_13_1225 VPWR VGND sg13g2_decap_8
XFILLER_71_1897 VPWR VGND sg13g2_decap_8
XFILLER_108_112 VPWR VGND sg13g2_decap_8
XFILLER_109_657 VPWR VGND sg13g2_decap_8
X_22357_ _22357_/Y _22357_/A _22359_/B VPWR VGND sg13g2_nand2_1
XFILLER_108_189 VPWR VGND sg13g2_decap_8
X_21308_ _21308_/Y _21308_/A _21308_/B VPWR VGND sg13g2_nand2_1
XFILLER_2_423 VPWR VGND sg13g2_decap_8
X_22288_ _24131_/D _22288_/A1 _22300_/B _22287_/Y VPWR VGND sg13g2_o21ai_1
XFILLER_2_434 VPWR VGND sg13g2_fill_2
X_12041_ _12041_/X _23835_/Q _23867_/Q _23931_/Q _23963_/Q _11406_/S _12171_/S1 VPWR
+ VGND sg13g2_mux4_1
XFILLER_105_863 VPWR VGND sg13g2_decap_8
X_24027_ _24027_/Q clkload48/A _24027_/D fanout2755/X VPWR VGND sg13g2_dfrbpq_1
X_21239_ _23642_/D _21305_/A1 _21242_/B _21238_/Y VPWR VGND sg13g2_o21ai_1
XFILLER_49_42 VPWR VGND sg13g2_decap_8
XFILLER_65_1679 VPWR VGND sg13g2_decap_8
XFILLER_77_235 VPWR VGND sg13g2_decap_4
XFILLER_8_1551 VPWR VGND sg13g2_decap_8
XFILLER_46_1089 VPWR VGND sg13g2_fill_2
XFILLER_8_1562 VPWR VGND sg13g2_fill_2
X_15800_ _17169_/A _16154_/A _16154_/B VPWR VGND sg13g2_nand2_1
X_16780_ _16785_/B _15300_/A _16779_/Y _15319_/C VPWR VGND sg13g2_a21oi_1
X_13992_ _14104_/C _20355_/B _20356_/A VPWR VGND sg13g2_and2_1
XFILLER_98_1411 VPWR VGND sg13g2_fill_2
XFILLER_105_70 VPWR VGND sg13g2_decap_8
XFILLER_1_49 VPWR VGND sg13g2_decap_8
XFILLER_18_313 VPWR VGND sg13g2_fill_2
XFILLER_92_238 VPWR VGND sg13g2_decap_4
X_15731_ _15731_/Y _22734_/Q _15946_/A2 _15731_/B1 _22670_/Q VPWR VGND sg13g2_a22oi_1
XFILLER_46_633 VPWR VGND sg13g2_decap_8
XFILLER_92_249 VPWR VGND sg13g2_decap_8
XFILLER_19_858 VPWR VGND sg13g2_decap_8
XFILLER_18_335 VPWR VGND sg13g2_fill_1
XFILLER_85_290 VPWR VGND sg13g2_fill_1
XFILLER_46_655 VPWR VGND sg13g2_decap_8
XFILLER_46_666 VPWR VGND sg13g2_fill_1
X_18450_ _18450_/Y _18562_/B _18415_/B _18445_/Y _18297_/A _18449_/Y VPWR VGND sg13g2_a221oi_1
XFILLER_2_1150 VPWR VGND sg13g2_decap_8
XFILLER_74_986 VPWR VGND sg13g2_fill_1
X_15662_ _15662_/Y _22731_/Q _15662_/A2 _15662_/B1 _22667_/Q VPWR VGND sg13g2_a22oi_1
X_12874_ _12897_/B _13271_/A _12871_/X _12873_/X VPWR VGND sg13g2_o21ai_1
XFILLER_45_187 VPWR VGND sg13g2_decap_4
XFILLER_33_338 VPWR VGND sg13g2_decap_8
X_14613_ _24216_/D _14782_/A _14193_/B _14612_/Y VPWR VGND sg13g2_o21ai_1
XFILLER_92_1021 VPWR VGND sg13g2_decap_8
X_15593_ _15593_/Y _15593_/A VPWR VGND sg13g2_inv_1
X_18381_ _18382_/D _18381_/A _18381_/B VPWR VGND sg13g2_nand2_1
XFILLER_33_349 VPWR VGND sg13g2_fill_1
XFILLER_37_1726 VPWR VGND sg13g2_fill_1
XFILLER_76_1775 VPWR VGND sg13g2_decap_8
XFILLER_60_146 VPWR VGND sg13g2_fill_2
XFILLER_18_1114 VPWR VGND sg13g2_fill_1
XFILLER_37_1737 VPWR VGND sg13g2_decap_8
XFILLER_109_1242 VPWR VGND sg13g2_decap_8
X_17332_ _22793_/D _17869_/A _17351_/B _17331_/Y VPWR VGND sg13g2_o21ai_1
X_14544_ _14545_/C _18446_/S _18771_/B _18857_/S VPWR VGND sg13g2_nor3_1
X_11756_ _11756_/Y _11924_/S0 _23288_/Q _11755_/Y VPWR VGND sg13g2_o21ai_1
XFILLER_14_574 VPWR VGND sg13g2_fill_1
XFILLER_42_894 VPWR VGND sg13g2_decap_8
XFILLER_41_382 VPWR VGND sg13g2_decap_8
X_17263_ _22761_/D _17869_/A _17262_/B _17262_/Y VPWR VGND sg13g2_o21ai_1
X_14475_ _14475_/Y _18573_/A _14475_/B _18771_/B VPWR VGND sg13g2_nor3_1
Xplace3309 _21928_/A1 _22262_/A1 VPWR VGND sg13g2_buf_1
X_11687_ _11701_/A _13210_/A _11687_/B VPWR VGND sg13g2_nor2_1
X_19002_ _19002_/Y _18999_/A _19002_/B _19002_/C VPWR VGND sg13g2_nand3b_1
X_13426_ _13427_/B _13595_/B2 _13421_/Y _13423_/Y _13678_/A1 _13425_/Y VPWR VGND sg13g2_a221oi_1
X_17194_ _17195_/C _22741_/Q _22740_/Q _22739_/Q VPWR VGND sg13g2_nand3_1
X_16145_ _16145_/Y _16145_/A _16145_/B VPWR VGND sg13g2_nand2_1
X_13357_ _13510_/B _13355_/X _13300_/X _13356_/Y VPWR VGND sg13g2_a21oi_1
X_12308_ _12308_/X _12306_/X _12307_/X _12557_/S VPWR VGND sg13g2_mux2_1
XFILLER_115_649 VPWR VGND sg13g2_decap_8
X_16076_ _16076_/Y _22490_/Q _16075_/B _16075_/Y VPWR VGND sg13g2_a21oi_1
XFILLER_114_126 VPWR VGND sg13g2_decap_8
XFILLER_87_1871 VPWR VGND sg13g2_fill_1
XFILLER_83_1702 VPWR VGND sg13g2_fill_1
X_13288_ _13288_/Y _20179_/A _13286_/Y _13287_/Y VPWR VGND sg13g2_o21ai_1
XFILLER_29_1210 VPWR VGND sg13g2_decap_8
XFILLER_46_4 VPWR VGND sg13g2_fill_1
X_19904_ _19904_/Y _20062_/B _19899_/Y _19903_/Y VPWR VGND sg13g2_a21oi_1
X_15027_ _15028_/C _22504_/Q _15067_/B _14966_/B VPWR VGND sg13g2_a21oi_1
X_12239_ _12239_/X _23933_/Q _23965_/Q _12239_/S VPWR VGND sg13g2_mux2_1
XFILLER_111_800 VPWR VGND sg13g2_decap_8
XFILLER_96_500 VPWR VGND sg13g2_decap_8
XFILLER_29_1254 VPWR VGND sg13g2_decap_8
XFILLER_29_1276 VPWR VGND sg13g2_fill_2
XFILLER_64_1156 VPWR VGND sg13g2_fill_1
X_19835_ _19835_/Y _19835_/A _19835_/B VPWR VGND sg13g2_nor2_1
XFILLER_64_1167 VPWR VGND sg13g2_decap_8
XFILLER_69_758 VPWR VGND sg13g2_decap_8
XFILLER_111_877 VPWR VGND sg13g2_decap_8
XFILLER_84_717 VPWR VGND sg13g2_decap_8
X_19766_ _19766_/Y _20005_/A _19711_/Y _19735_/Y VPWR VGND sg13g2_o21ai_1
XFILLER_110_376 VPWR VGND sg13g2_fill_1
XFILLER_83_205 VPWR VGND sg13g2_decap_8
XFILLER_7_1061 VPWR VGND sg13g2_decap_4
X_16978_ _16978_/Y _17169_/A _17026_/B VPWR VGND sg13g2_nand2_1
XFILLER_37_611 VPWR VGND sg13g2_decap_4
XFILLER_65_920 VPWR VGND sg13g2_fill_1
X_18717_ _23021_/D _18714_/A _18713_/Y _18716_/Y _18712_/A VPWR VGND sg13g2_a22oi_1
X_15929_ _20296_/A _15929_/A _15929_/B _15929_/C VPWR VGND sg13g2_nor3_1
XFILLER_49_493 VPWR VGND sg13g2_decap_8
X_19697_ _19698_/B _19696_/B _19580_/B _19696_/Y VPWR VGND sg13g2_o21ai_1
XFILLER_42_1498 VPWR VGND sg13g2_decap_8
XFILLER_64_430 VPWR VGND sg13g2_fill_1
XFILLER_0_1813 VPWR VGND sg13g2_decap_4
XFILLER_92_772 VPWR VGND sg13g2_decap_8
X_18648_ _18648_/Y _18648_/A VPWR VGND sg13g2_inv_1
XFILLER_25_839 VPWR VGND sg13g2_decap_8
XFILLER_91_271 VPWR VGND sg13g2_decap_8
XFILLER_24_327 VPWR VGND sg13g2_decap_8
XFILLER_80_956 VPWR VGND sg13g2_decap_8
XFILLER_18_891 VPWR VGND sg13g2_decap_8
XFILLER_101_28 VPWR VGND sg13g2_decap_8
XFILLER_51_157 VPWR VGND sg13g2_fill_2
X_20610_ _20610_/Y _23359_/Q _20616_/B VPWR VGND sg13g2_nand2_1
XFILLER_107_1916 VPWR VGND sg13g2_decap_8
XFILLER_33_883 VPWR VGND sg13g2_decap_8
XFILLER_36_1236 VPWR VGND sg13g2_fill_2
X_21590_ _21590_/Y _21590_/A _21590_/B VPWR VGND sg13g2_nand2_1
XFILLER_71_1116 VPWR VGND sg13g2_decap_4
XFILLER_75_1296 VPWR VGND sg13g2_fill_2
XFILLER_71_1149 VPWR VGND sg13g2_fill_2
Xrebuffer5501 _11625_/B _11319_/A2 VPWR VGND sg13g2_buf_1
Xrebuffer5512 rebuffer5512/X _13877_/Y VPWR VGND sg13g2_buf_1
Xrebuffer5523 rebuffer5523/X rebuffer5524/X VPWR VGND sg13g2_buf_1
Xrebuffer5534 rebuffer5534/X rebuffer5535/X VPWR VGND sg13g2_buf_1
Xplace3810 _15889_/S _15956_/B VPWR VGND sg13g2_buf_1
X_23260_ _23260_/Q clkload55/A _23260_/D fanout2772/X VPWR VGND sg13g2_dfrbpq_1
Xplace3821 _20362_/A1 _20107_/Y VPWR VGND sg13g2_buf_1
Xrebuffer5545 rebuffer5545/X rebuffer5546/X VPWR VGND sg13g2_buf_1
X_20472_ _23297_/D _22416_/A1 _20473_/B _20471_/Y VPWR VGND sg13g2_o21ai_1
Xrebuffer5556 _16249_/A _14890_/Y VPWR VGND sg13g2_buf_1
Xplace3832 _18290_/C _18301_/A VPWR VGND sg13g2_buf_1
Xrebuffer5567 _12532_/C _12535_/B VPWR VGND sg13g2_buf_1
Xplace3843 _13692_/A place3844/A VPWR VGND sg13g2_buf_1
Xplace3854 _18064_/C _18404_/B VPWR VGND sg13g2_buf_1
XFILLER_88_1635 VPWR VGND sg13g2_decap_4
X_22211_ _24094_/D _22211_/A1 _22210_/B _22210_/Y VPWR VGND sg13g2_o21ai_1
Xhold5202 _21247_/A _23646_/Q VPWR VGND sg13g2_dlygate4sd3_1
Xplace3865 _14342_/A _13858_/A VPWR VGND sg13g2_buf_1
X_23191_ _23191_/Q clkload12/A _23191_/D fanout2913/X VPWR VGND sg13g2_dfrbpq_1
Xplace3876 _12550_/A _13968_/B VPWR VGND sg13g2_buf_1
XFILLER_88_1657 VPWR VGND sg13g2_decap_8
Xplace3887 _19149_/S _19141_/S VPWR VGND sg13g2_buf_1
Xplace3898 _18562_/A _18196_/A VPWR VGND sg13g2_buf_1
X_22142_ _22142_/Y _22142_/A _22142_/B VPWR VGND sg13g2_nand2_1
XFILLER_105_126 VPWR VGND sg13g2_decap_8
X_22073_ _22073_/Y _22073_/A _22075_/B VPWR VGND sg13g2_nand2_1
XFILLER_99_371 VPWR VGND sg13g2_fill_2
XFILLER_86_29 VPWR VGND sg13g2_fill_2
XFILLER_27_1939 VPWR VGND sg13g2_decap_8
XFILLER_114_1909 VPWR VGND sg13g2_decap_8
XFILLER_43_1218 VPWR VGND sg13g2_fill_1
XFILLER_102_866 VPWR VGND sg13g2_decap_8
XFILLER_9_1871 VPWR VGND sg13g2_decap_8
XFILLER_5_1735 VPWR VGND sg13g2_decap_8
XFILLER_112_1622 VPWR VGND sg13g2_decap_4
XFILLER_99_1731 VPWR VGND sg13g2_fill_1
XFILLER_68_780 VPWR VGND sg13g2_decap_4
X_22975_ _22975_/Q _24212_/CLK _22975_/D fanout2921/X VPWR VGND sg13g2_dfrbpq_1
XFILLER_74_249 VPWR VGND sg13g2_fill_1
XFILLER_112_1677 VPWR VGND sg13g2_fill_1
X_21926_ _23958_/D _21926_/A1 _21935_/B _21925_/Y VPWR VGND sg13g2_o21ai_1
XFILLER_83_772 VPWR VGND sg13g2_decap_8
XFILLER_83_783 VPWR VGND sg13g2_fill_2
XFILLER_16_828 VPWR VGND sg13g2_decap_8
XFILLER_3_1470 VPWR VGND sg13g2_fill_2
XFILLER_27_165 VPWR VGND sg13g2_fill_1
XFILLER_55_474 VPWR VGND sg13g2_fill_2
XFILLER_56_997 VPWR VGND sg13g2_decap_8
XFILLER_70_400 VPWR VGND sg13g2_decap_8
XFILLER_71_934 VPWR VGND sg13g2_decap_4
Xinput4400 _20278_/A2 data_rdata_i[2] VPWR VGND sg13g2_buf_1
XFILLER_70_411 VPWR VGND sg13g2_fill_1
XFILLER_42_113 VPWR VGND sg13g2_decap_4
Xinput4411 _16365_/A debug_req_i VPWR VGND sg13g2_buf_1
X_21857_ _21857_/Y _23925_/Q _21899_/S VPWR VGND sg13g2_nand2_1
XFILLER_93_1330 VPWR VGND sg13g2_decap_8
Xinput4422 _18871_/A instr_rdata_i[16] VPWR VGND sg13g2_buf_1
Xinput4433 _18984_/A instr_rdata_i[26] VPWR VGND sg13g2_buf_1
XFILLER_58_1461 VPWR VGND sg13g2_fill_1
Xinput4444 _19123_/A1 instr_rdata_i[7] VPWR VGND sg13g2_buf_1
Xinput4455 _14218_/A irqs_i[1] VPWR VGND sg13g2_buf_1
X_11610_ _11611_/B _11634_/A _14133_/A _11634_/D VPWR VGND sg13g2_nand3_1
XFILLER_73_1937 VPWR VGND sg13g2_decap_8
X_20808_ _23453_/D _21312_/A1 _20809_/B _20807_/Y VPWR VGND sg13g2_o21ai_1
XFILLER_19_1445 VPWR VGND sg13g2_fill_1
Xinput4466 _15479_/B2 timer_irq_i VPWR VGND sg13g2_buf_1
XFILLER_30_319 VPWR VGND sg13g2_fill_2
X_12590_ _12607_/A _12460_/A _12587_/X _12589_/X VPWR VGND sg13g2_o21ai_1
XFILLER_11_500 VPWR VGND sg13g2_fill_1
XFILLER_19_1478 VPWR VGND sg13g2_fill_2
X_11541_ _11541_/Y _11926_/S _11541_/B VPWR VGND sg13g2_nand2_1
X_23527_ _23527_/Q _24196_/CLK _23527_/D fanout2698/X VPWR VGND sg13g2_dfrbpq_1
X_20739_ _23420_/D _21309_/A1 _20738_/B _20738_/Y VPWR VGND sg13g2_o21ai_1
XFILLER_11_544 VPWR VGND sg13g2_fill_1
X_14260_ _14260_/Y _14260_/A _14560_/B _14260_/C VPWR VGND sg13g2_nand3_1
XFILLER_7_526 VPWR VGND sg13g2_fill_1
X_11472_ _11707_/A _11708_/B _12128_/A VPWR VGND sg13g2_nand2b_1
X_23458_ _23458_/Q clkload41/A _23458_/D fanout2726/X VPWR VGND sg13g2_dfrbpq_1
XFILLER_32_1656 VPWR VGND sg13g2_fill_2
XFILLER_109_443 VPWR VGND sg13g2_fill_1
XFILLER_87_1101 VPWR VGND sg13g2_decap_8
X_13211_ _13212_/B _23241_/Q _23369_/Q _13213_/S VPWR VGND sg13g2_mux2_1
XFILLER_87_1112 VPWR VGND sg13g2_fill_2
X_22409_ _24190_/D _22409_/A1 _22408_/B _22408_/Y VPWR VGND sg13g2_o21ai_1
XFILLER_100_1014 VPWR VGND sg13g2_decap_8
XFILLER_104_1194 VPWR VGND sg13g2_fill_2
XFILLER_10_1921 VPWR VGND sg13g2_decap_8
X_23389_ _23389_/Q clkload55/A _23389_/D fanout2775/X VPWR VGND sg13g2_dfrbpq_1
XFILLER_13_1088 VPWR VGND sg13g2_decap_8
XFILLER_67_1708 VPWR VGND sg13g2_fill_2
X_13142_ _13143_/C _24168_/Q _24200_/Q _23240_/Q _23272_/Q _13133_/A _13635_/S1 VPWR
+ VGND sg13g2_mux4_1
XFILLER_100_1058 VPWR VGND sg13g2_decap_8
XFILLER_87_1167 VPWR VGND sg13g2_decap_4
XFILLER_65_1410 VPWR VGND sg13g2_fill_1
XFILLER_4_0 VPWR VGND sg13g2_decap_8
X_17950_ _17950_/Y _18053_/S _19122_/A1 VPWR VGND sg13g2_nor2b_1
X_13073_ _13073_/Y _13069_/Y _13067_/Y _13071_/Y _13072_/Y VPWR VGND sg13g2_a22oi_1
XFILLER_2_253 VPWR VGND sg13g2_decap_8
X_16901_ _22690_/D _16895_/S _16899_/Y _16900_/Y VPWR VGND sg13g2_o21ai_1
X_12024_ _12024_/X _23611_/Q _23675_/Q _12191_/S VPWR VGND sg13g2_mux2_1
X_17881_ _17881_/Y _17881_/A _17917_/B VPWR VGND sg13g2_nor2_1
XFILLER_61_1318 VPWR VGND sg13g2_fill_2
XFILLER_61_1329 VPWR VGND sg13g2_decap_4
XFILLER_113_1408 VPWR VGND sg13g2_decap_8
X_19620_ _19620_/Y _20255_/A3 _19781_/A2 _19781_/B1 _20255_/A1 _19782_/A1 VPWR VGND
+ sg13g2_a221oi_1
XFILLER_43_1741 VPWR VGND sg13g2_fill_2
X_16832_ _16833_/C _22678_/Q _22677_/Q _22676_/Q _22675_/Q VPWR VGND sg13g2_nand4_1
XFILLER_24_1151 VPWR VGND sg13g2_decap_8
XFILLER_76_73 VPWR VGND sg13g2_decap_8
X_19551_ _19794_/B _19712_/B _19548_/X _19550_/Y VPWR VGND sg13g2_o21ai_1
XFILLER_19_633 VPWR VGND sg13g2_decap_8
XFILLER_65_238 VPWR VGND sg13g2_fill_1
XFILLER_115_1290 VPWR VGND sg13g2_decap_8
X_16763_ _16764_/B _22668_/Q _16763_/B VPWR VGND sg13g2_xnor2_1
XFILLER_19_644 VPWR VGND sg13g2_decap_8
X_13975_ _13976_/A _23572_/Q _13975_/A2 _13974_/X _17718_/B2 VPWR VGND sg13g2_a22oi_1
X_18502_ _18502_/Y _18553_/A1 _18494_/B _18351_/B VPWR VGND sg13g2_o21ai_1
XFILLER_19_677 VPWR VGND sg13g2_decap_8
XFILLER_34_603 VPWR VGND sg13g2_decap_8
X_15714_ _15714_/Y _15714_/A _15963_/B VPWR VGND sg13g2_nor2_1
X_19482_ _19482_/Y _19401_/B _19483_/B _19483_/A VPWR VGND sg13g2_a21oi_1
X_12926_ _12926_/Y _23172_/Q _19197_/A VPWR VGND sg13g2_nand2_1
X_16694_ _16695_/B _22653_/Q _16698_/C VPWR VGND sg13g2_nand2_1
XFILLER_98_1285 VPWR VGND sg13g2_fill_1
XFILLER_74_783 VPWR VGND sg13g2_decap_4
XFILLER_98_1296 VPWR VGND sg13g2_decap_8
XFILLER_59_1247 VPWR VGND sg13g2_decap_4
X_18433_ _22985_/D _18431_/Y _18432_/B _18432_/Y VPWR VGND sg13g2_o21ai_1
X_15645_ _15646_/B _15984_/A _15643_/Y _15644_/Y VPWR VGND sg13g2_o21ai_1
X_12857_ _13748_/A _13526_/D _13525_/B VPWR VGND sg13g2_or2_1
X_11808_ _11809_/B _23769_/Q _23929_/Q _11810_/S VPWR VGND sg13g2_mux2_1
X_18364_ _18364_/Y _18301_/A _18363_/Y _18370_/B _18461_/A VPWR VGND sg13g2_a22oi_1
XFILLER_61_488 VPWR VGND sg13g2_fill_1
X_15576_ _15577_/B _22727_/Q _15662_/A2 _15662_/B1 _22663_/Q VPWR VGND sg13g2_a22oi_1
X_12788_ _12791_/A _12788_/A _12788_/B _12788_/C VPWR VGND sg13g2_nor3_1
X_17315_ _17315_/Y _17315_/A _17315_/B VPWR VGND sg13g2_nand2_1
XFILLER_42_691 VPWR VGND sg13g2_fill_1
X_11739_ _11739_/X _24024_/Q _24056_/Q _24088_/Q _24120_/Q _11737_/S _11920_/C1 VPWR
+ VGND sg13g2_mux4_1
X_14527_ _14528_/B _24217_/Q _14527_/B VPWR VGND sg13g2_nor2_1
XFILLER_30_853 VPWR VGND sg13g2_decap_8
X_18295_ _18295_/Y _18406_/A _18294_/Y _18501_/S VPWR VGND sg13g2_a21oi_1
Xplace3106 _21389_/B _21406_/B VPWR VGND sg13g2_buf_1
Xplace3117 _21242_/B _21234_/B VPWR VGND sg13g2_buf_1
XFILLER_15_1843 VPWR VGND sg13g2_decap_8
XFILLER_30_886 VPWR VGND sg13g2_decap_8
X_17246_ _17246_/Y _17246_/A _17246_/B VPWR VGND sg13g2_nand2_1
Xplace3128 _21085_/B _21079_/B VPWR VGND sg13g2_buf_1
X_14458_ _14458_/X _17532_/A _17044_/A _14572_/A VPWR VGND sg13g2_a21o_1
Xplace3139 _20879_/B _20874_/B VPWR VGND sg13g2_buf_1
XFILLER_50_1767 VPWR VGND sg13g2_fill_2
XFILLER_102_1835 VPWR VGND sg13g2_decap_8
X_13409_ _13410_/B _23724_/Q _23756_/Q _23788_/Q _23820_/Q _13586_/A1 _13680_/S1 VPWR
+ VGND sg13g2_mux4_1
X_17177_ _17178_/C _17177_/A VPWR VGND sg13g2_inv_1
X_14389_ _17390_/B _14386_/Y _14387_/Y _14388_/Y VPWR VGND sg13g2_a21o_1
XFILLER_31_1177 VPWR VGND sg13g2_fill_2
XFILLER_85_1819 VPWR VGND sg13g2_decap_8
X_16128_ _17887_/A _15714_/A _15713_/Y _15714_/Y VPWR VGND sg13g2_a21oi_1
XFILLER_66_1207 VPWR VGND sg13g2_decap_8
XFILLER_115_446 VPWR VGND sg13g2_decap_8
XFILLER_48_1652 VPWR VGND sg13g2_fill_1
X_16059_ _16059_/Y _22486_/Q _16075_/B _16058_/Y VPWR VGND sg13g2_a21oi_1
XFILLER_102_107 VPWR VGND sg13g2_fill_2
XFILLER_44_1516 VPWR VGND sg13g2_fill_1
XFILLER_97_853 VPWR VGND sg13g2_fill_2
XFILLER_44_1549 VPWR VGND sg13g2_fill_1
XFILLER_110_140 VPWR VGND sg13g2_decap_8
XFILLER_29_408 VPWR VGND sg13g2_fill_2
XFILLER_111_674 VPWR VGND sg13g2_decap_8
Xfanout2790 fanout2790/X fanout2791/X VPWR VGND sg13g2_buf_1
XFILLER_57_728 VPWR VGND sg13g2_decap_8
XFILLER_113_1920 VPWR VGND sg13g2_decap_8
XFILLER_84_525 VPWR VGND sg13g2_decap_8
XFILLER_22_1814 VPWR VGND sg13g2_fill_2
XFILLER_38_942 VPWR VGND sg13g2_decap_8
X_19749_ _19749_/Y _19747_/Y _19748_/Y _19946_/C1 VPWR VGND sg13g2_a21oi_1
XFILLER_84_569 VPWR VGND sg13g2_decap_8
XFILLER_65_750 VPWR VGND sg13g2_decap_8
XFILLER_77_1303 VPWR VGND sg13g2_decap_4
XFILLER_77_1314 VPWR VGND sg13g2_fill_1
XFILLER_25_603 VPWR VGND sg13g2_decap_4
X_22760_ _22760_/Q _22893_/CLK _22760_/D fanout2817/X VPWR VGND sg13g2_dfrbpq_1
XFILLER_52_400 VPWR VGND sg13g2_decap_4
XFILLER_112_49 VPWR VGND sg13g2_decap_8
XFILLER_77_1336 VPWR VGND sg13g2_decap_8
XFILLER_25_636 VPWR VGND sg13g2_decap_8
XFILLER_53_945 VPWR VGND sg13g2_decap_4
XFILLER_64_271 VPWR VGND sg13g2_decap_8
X_21711_ _23865_/D _21932_/A1 _21725_/B _21710_/Y VPWR VGND sg13g2_o21ai_1
XFILLER_80_731 VPWR VGND sg13g2_decap_8
X_22691_ _22691_/Q clkload23/A _22691_/D fanout2888/X VPWR VGND sg13g2_dfrbpq_1
XFILLER_55_1601 VPWR VGND sg13g2_fill_2
XFILLER_52_466 VPWR VGND sg13g2_fill_2
XFILLER_55_1612 VPWR VGND sg13g2_fill_1
X_21642_ _21642_/Y _21642_/A _21642_/B VPWR VGND sg13g2_nand2_1
XFILLER_90_1514 VPWR VGND sg13g2_decap_8
X_21573_ _23802_/D _21934_/A1 _21572_/B _21572_/Y VPWR VGND sg13g2_o21ai_1
Xplace4330 _11924_/S0 _11755_/B VPWR VGND sg13g2_buf_8
X_23312_ _23312_/Q _24214_/CLK _23312_/D fanout2626/X VPWR VGND sg13g2_dfrbpq_1
Xrebuffer5320 _14535_/C _18742_/B VPWR VGND sg13g2_buf_1
Xplace4341 _21918_/D _22973_/Q VPWR VGND sg13g2_buf_1
X_20524_ _20524_/Y _20524_/A _20578_/B VPWR VGND sg13g2_nand2_1
Xrebuffer5331 _12264_/C _12256_/Y VPWR VGND sg13g2_buf_8
XFILLER_36_1099 VPWR VGND sg13g2_fill_2
Xrebuffer5342 _11365_/B2 _11910_/B VPWR VGND sg13g2_buf_1
XFILLER_88_1410 VPWR VGND sg13g2_decap_8
XFILLER_20_385 VPWR VGND sg13g2_fill_2
Xrebuffer5353 _13713_/A1 _11484_/X VPWR VGND sg13g2_buf_1
Xplace3640 _14701_/B _14718_/B VPWR VGND sg13g2_buf_1
Xrebuffer5364 _12404_/S _12453_/S VPWR VGND sg13g2_buf_1
XFILLER_107_903 VPWR VGND sg13g2_fill_1
X_23243_ _23243_/Q _24212_/CLK _23243_/D fanout2627/X VPWR VGND sg13g2_dfrbpq_1
Xrebuffer5375 _11606_/B _14098_/C VPWR VGND sg13g2_buf_1
Xplace3651 _17388_/B _17540_/B VPWR VGND sg13g2_buf_1
Xrebuffer4630 _13936_/A _13935_/Y VPWR VGND sg13g2_buf_4
Xrebuffer5386 _12151_/B _12149_/Y VPWR VGND sg13g2_buf_2
Xplace3662 _16199_/B _16132_/B VPWR VGND sg13g2_buf_1
X_20455_ _23289_/D _21303_/A1 _20458_/B _20454_/Y VPWR VGND sg13g2_o21ai_1
XFILLER_115_7 VPWR VGND sg13g2_decap_8
Xplace3673 _15662_/A2 _15307_/B VPWR VGND sg13g2_buf_1
Xhold5010 _21976_/A _23984_/Q VPWR VGND sg13g2_dlygate4sd3_1
XFILLER_106_413 VPWR VGND sg13g2_decap_8
Xhold5021 _17728_/A _22896_/Q VPWR VGND sg13g2_dlygate4sd3_1
XFILLER_49_1416 VPWR VGND sg13g2_fill_1
Xplace3684 _20322_/A _13831_/A VPWR VGND sg13g2_buf_1
Xplace2950 _18821_/B _18827_/B VPWR VGND sg13g2_buf_1
Xhold5032 _20557_/A _23334_/Q VPWR VGND sg13g2_dlygate4sd3_1
Xplace3695 _15075_/B1 _15066_/B1 VPWR VGND sg13g2_buf_1
Xhold5043 _20449_/A _23287_/Q VPWR VGND sg13g2_dlygate4sd3_1
Xplace2961 _18729_/A _18697_/A VPWR VGND sg13g2_buf_1
X_23174_ _23174_/Q _23187_/CLK _23174_/D fanout2915/X VPWR VGND sg13g2_dfrbpq_1
X_20386_ _20386_/Y _20386_/A _20388_/B VPWR VGND sg13g2_nand2_1
Xplace2972 _18286_/A _18355_/A VPWR VGND sg13g2_buf_1
Xhold5054 _20078_/A _23235_/Q VPWR VGND sg13g2_dlygate4sd3_1
Xplace2983 _18457_/S _16376_/B VPWR VGND sg13g2_buf_1
XFILLER_106_457 VPWR VGND sg13g2_fill_2
XFILLER_97_28 VPWR VGND sg13g2_decap_8
Xhold5065 _21991_/A _23990_/Q VPWR VGND sg13g2_dlygate4sd3_1
Xplace2994 _19044_/B _18957_/C VPWR VGND sg13g2_buf_1
XFILLER_106_468 VPWR VGND sg13g2_decap_8
Xhold5076 _21973_/A _23982_/Q VPWR VGND sg13g2_dlygate4sd3_1
X_22125_ _22125_/Y _22125_/A _22129_/B VPWR VGND sg13g2_nand2_1
Xhold5087 _22417_/A _24194_/Q VPWR VGND sg13g2_dlygate4sd3_1
Xhold5098 _21079_/A _23570_/Q VPWR VGND sg13g2_dlygate4sd3_1
X_22056_ _22056_/Y _22056_/A _22069_/B VPWR VGND sg13g2_nand2_1
XFILLER_88_853 VPWR VGND sg13g2_decap_8
XFILLER_27_1747 VPWR VGND sg13g2_fill_2
XFILLER_88_864 VPWR VGND sg13g2_fill_2
XFILLER_102_652 VPWR VGND sg13g2_decap_4
XFILLER_43_1026 VPWR VGND sg13g2_decap_8
X_21007_ _23544_/D _22264_/A1 _21085_/B _21006_/Y VPWR VGND sg13g2_o21ai_1
XFILLER_82_1097 VPWR VGND sg13g2_decap_8
XFILLER_87_385 VPWR VGND sg13g2_decap_8
XFILLER_48_739 VPWR VGND sg13g2_fill_2
XFILLER_25_1460 VPWR VGND sg13g2_fill_1
XFILLER_5_1554 VPWR VGND sg13g2_decap_4
XFILLER_47_238 VPWR VGND sg13g2_decap_8
XFILLER_60_1362 VPWR VGND sg13g2_decap_8
XFILLER_25_1493 VPWR VGND sg13g2_fill_2
XFILLER_47_249 VPWR VGND sg13g2_fill_1
XFILLER_75_558 VPWR VGND sg13g2_decap_8
XFILLER_46_32 VPWR VGND sg13g2_decap_4
XFILLER_28_441 VPWR VGND sg13g2_decap_8
XFILLER_29_975 VPWR VGND sg13g2_decap_8
XFILLER_5_1598 VPWR VGND sg13g2_decap_4
X_13760_ _13760_/Y _13757_/Y _13758_/Y _13759_/Y VPWR VGND sg13g2_a21oi_2
X_22958_ _22958_/Q _24212_/CLK _22958_/D fanout2919/X VPWR VGND sg13g2_dfrbpq_1
XFILLER_44_923 VPWR VGND sg13g2_decap_8
XFILLER_21_1379 VPWR VGND sg13g2_fill_1
XFILLER_56_794 VPWR VGND sg13g2_decap_8
X_21909_ _23951_/D _21975_/A0 _23951_/Q _21915_/S VPWR VGND sg13g2_mux2_1
XFILLER_15_124 VPWR VGND sg13g2_decap_4
X_12711_ _12712_/C _12820_/S _12711_/B VPWR VGND sg13g2_nor2_1
XFILLER_44_956 VPWR VGND sg13g2_fill_2
XFILLER_15_135 VPWR VGND sg13g2_decap_8
X_13691_ _13692_/D _14129_/A _13687_/Y _13690_/X _12048_/A VPWR VGND sg13g2_a22oi_1
XFILLER_16_669 VPWR VGND sg13g2_fill_2
X_22889_ _22889_/Q _22917_/CLK _22889_/D fanout2872/X VPWR VGND sg13g2_dfrbpq_1
XFILLER_71_775 VPWR VGND sg13g2_decap_4
X_15430_ _15431_/B _22721_/Q _15487_/A2 _15487_/B1 _22657_/Q VPWR VGND sg13g2_a22oi_1
X_12642_ _12642_/X _24162_/Q _24194_/Q _23234_/Q _23266_/Q _12802_/B _13243_/S1 VPWR
+ VGND sg13g2_mux4_1
XFILLER_71_786 VPWR VGND sg13g2_decap_8
XFILLER_38_1854 VPWR VGND sg13g2_fill_1
XFILLER_102_93 VPWR VGND sg13g2_fill_1
XFILLER_34_1718 VPWR VGND sg13g2_decap_4
X_15361_ _15365_/C _22817_/Q _15308_/Y _15359_/Y _22839_/Q VPWR VGND sg13g2_a22oi_1
XFILLER_30_149 VPWR VGND sg13g2_decap_4
X_12573_ _12582_/C _12562_/X _12740_/A _12572_/Y VPWR VGND sg13g2_o21ai_1
XFILLER_11_341 VPWR VGND sg13g2_fill_1
XFILLER_106_1256 VPWR VGND sg13g2_decap_8
X_17100_ _17101_/B _17100_/A _17122_/B _17110_/B VPWR VGND sg13g2_nor3_1
X_14312_ _14312_/Y _15247_/A _15478_/C VPWR VGND sg13g2_nor2_1
X_15292_ _15332_/A _22784_/Q _15284_/Y _15289_/X _22912_/Q VPWR VGND sg13g2_a22oi_1
XFILLER_7_312 VPWR VGND sg13g2_fill_2
XFILLER_8_857 VPWR VGND sg13g2_decap_8
XFILLER_7_334 VPWR VGND sg13g2_fill_1
X_17031_ _17031_/Y _22715_/Q _17031_/B VPWR VGND sg13g2_xnor2_1
X_14243_ _14407_/B _14596_/B _24242_/Q _14583_/B VPWR VGND sg13g2_nor3_1
X_11455_ _11455_/Y _11451_/Y _11452_/Y _11454_/Y VPWR VGND sg13g2_o21ai_1
XFILLER_7_367 VPWR VGND sg13g2_decap_4
XFILLER_109_262 VPWR VGND sg13g2_decap_4
XFILLER_7_389 VPWR VGND sg13g2_decap_8
X_14174_ _14175_/B _14758_/A _24238_/Q _14445_/B _14174_/D VPWR VGND sg13g2_nor4_1
X_11386_ _11386_/Y _11387_/A VPWR VGND sg13g2_inv_1
X_18982_ _18982_/Y _23055_/Q _19008_/A _19048_/B1 VPWR VGND sg13g2_o21ai_1
XFILLER_10_1795 VPWR VGND sg13g2_decap_8
XFILLER_97_127 VPWR VGND sg13g2_decap_8
XFILLER_30_7 VPWR VGND sg13g2_fill_1
X_13056_ _15735_/A _13037_/Y _13038_/Y _13055_/X VPWR VGND sg13g2_a21oi_2
X_17933_ _22942_/D _14788_/A _14837_/B _17932_/Y VPWR VGND sg13g2_o21ai_1
XFILLER_61_1126 VPWR VGND sg13g2_decap_8
X_12007_ _12007_/Y _11517_/S _12006_/X _13191_/B1 VPWR VGND sg13g2_o21ai_1
XFILLER_79_875 VPWR VGND sg13g2_decap_8
XFILLER_78_352 VPWR VGND sg13g2_fill_1
XFILLER_79_886 VPWR VGND sg13g2_fill_1
XFILLER_78_363 VPWR VGND sg13g2_decap_8
X_17864_ _17865_/B _22919_/Q _17927_/B VPWR VGND sg13g2_nand2_1
XFILLER_61_1148 VPWR VGND sg13g2_fill_1
XFILLER_94_834 VPWR VGND sg13g2_fill_2
XFILLER_93_322 VPWR VGND sg13g2_fill_2
X_19603_ _20354_/B _19608_/A _19603_/B VPWR VGND sg13g2_nand2_1
XFILLER_93_333 VPWR VGND sg13g2_fill_1
X_16815_ _16833_/B _22674_/Q _22673_/Q _22672_/Q _22671_/Q VPWR VGND sg13g2_nand4_1
X_17795_ _17795_/Y _17202_/A _17810_/A2 _17810_/B1 _17794_/Y VPWR VGND sg13g2_a22oi_1
XFILLER_47_761 VPWR VGND sg13g2_fill_2
X_19534_ _19534_/Y _19874_/A _19534_/B VPWR VGND sg13g2_nand2_1
X_16746_ _16746_/Y _16755_/A _16746_/B VPWR VGND sg13g2_nor2_1
XFILLER_93_388 VPWR VGND sg13g2_fill_1
XFILLER_53_219 VPWR VGND sg13g2_fill_1
XFILLER_1_1930 VPWR VGND sg13g2_decap_8
X_13958_ _13958_/X _23316_/Q _23348_/Q _23380_/Q _23412_/Q _13959_/S0 _13331_/S VPWR
+ VGND sg13g2_mux4_1
XFILLER_19_485 VPWR VGND sg13g2_decap_8
XFILLER_78_1667 VPWR VGND sg13g2_fill_2
XFILLER_34_433 VPWR VGND sg13g2_fill_2
XFILLER_35_956 VPWR VGND sg13g2_decap_8
XFILLER_39_1618 VPWR VGND sg13g2_fill_2
X_19465_ _19465_/Y _19462_/Y _19464_/Y _19708_/S VPWR VGND sg13g2_a21oi_1
X_12909_ _12909_/Y _23877_/Q _12909_/B VPWR VGND sg13g2_nand2b_1
X_16677_ _16677_/Y _22651_/Q _16677_/B VPWR VGND sg13g2_xnor2_1
XFILLER_61_230 VPWR VGND sg13g2_fill_2
X_13889_ _13889_/Y _24019_/Q _13889_/B VPWR VGND sg13g2_nor2_1
XFILLER_56_1921 VPWR VGND sg13g2_decap_4
X_18416_ _18416_/Y _18416_/A VPWR VGND sg13g2_inv_1
XFILLER_62_786 VPWR VGND sg13g2_fill_2
X_15628_ _20040_/A _15628_/A _15628_/B _15628_/C _15628_/D VPWR VGND sg13g2_nand4_1
XFILLER_50_948 VPWR VGND sg13g2_decap_8
XFILLER_56_1954 VPWR VGND sg13g2_fill_1
XFILLER_15_680 VPWR VGND sg13g2_fill_2
XFILLER_76_1391 VPWR VGND sg13g2_fill_1
XFILLER_17_1927 VPWR VGND sg13g2_decap_8
XFILLER_21_138 VPWR VGND sg13g2_fill_1
XFILLER_37_1364 VPWR VGND sg13g2_decap_8
X_18347_ _18348_/B _18385_/A _18351_/B VPWR VGND sg13g2_nand2_1
X_15559_ _15560_/B _22461_/Q _15639_/B _15684_/B _22888_/Q _15558_/Y VPWR VGND sg13g2_a221oi_1
XFILLER_104_1908 VPWR VGND sg13g2_decap_8
XFILLER_72_1277 VPWR VGND sg13g2_decap_4
XFILLER_33_1239 VPWR VGND sg13g2_fill_1
X_18278_ _22973_/D _18432_/B _18276_/Y _18277_/Y VPWR VGND sg13g2_o21ai_1
XFILLER_50_1531 VPWR VGND sg13g2_fill_2
X_17229_ _22747_/D _17229_/A _17229_/B _17229_/C _17229_/D VPWR VGND sg13g2_nand4_1
XFILLER_15_1695 VPWR VGND sg13g2_decap_4
XFILLER_115_210 VPWR VGND sg13g2_decap_8
X_20240_ _20240_/Y _20240_/A _20300_/B VPWR VGND sg13g2_nand2_1
XFILLER_102_1698 VPWR VGND sg13g2_decap_8
X_20171_ _20171_/Y _20344_/A1 _20170_/X _20107_/Y VPWR VGND sg13g2_o21ai_1
XFILLER_104_939 VPWR VGND sg13g2_fill_1
XFILLER_115_287 VPWR VGND sg13g2_decap_8
XFILLER_107_49 VPWR VGND sg13g2_decap_8
XFILLER_103_427 VPWR VGND sg13g2_decap_8
XFILLER_44_1313 VPWR VGND sg13g2_decap_4
XFILLER_97_650 VPWR VGND sg13g2_decap_4
XFILLER_112_961 VPWR VGND sg13g2_decap_8
XFILLER_85_812 VPWR VGND sg13g2_fill_2
X_23930_ _23930_/Q clkload58/A _23930_/D fanout2756/X VPWR VGND sg13g2_dfrbpq_1
XFILLER_97_672 VPWR VGND sg13g2_fill_1
XFILLER_84_300 VPWR VGND sg13g2_fill_1
X_23861_ _23861_/Q clkload52/A _23861_/D fanout2689/X VPWR VGND sg13g2_dfrbpq_1
XFILLER_113_1761 VPWR VGND sg13g2_decap_4
XFILLER_6_1896 VPWR VGND sg13g2_decap_8
X_22812_ _22812_/Q clkload10/A _22812_/D fanout2813/X VPWR VGND sg13g2_dfrbpq_1
XFILLER_113_1794 VPWR VGND sg13g2_decap_8
X_23792_ _23792_/Q clkload56/A _23792_/D fanout2675/X VPWR VGND sg13g2_dfrbpq_1
XFILLER_77_1144 VPWR VGND sg13g2_decap_8
XFILLER_65_591 VPWR VGND sg13g2_decap_8
X_22743_ _22743_/Q clkload21/A _22743_/D fanout2868/X VPWR VGND sg13g2_dfrbpq_1
XFILLER_16_57 VPWR VGND sg13g2_fill_1
XFILLER_41_915 VPWR VGND sg13g2_fill_1
X_22674_ _22674_/Q clkload20/A _22674_/D fanout2866/X VPWR VGND sg13g2_dfrbpq_1
XFILLER_12_116 VPWR VGND sg13g2_fill_2
XFILLER_107_1510 VPWR VGND sg13g2_decap_8
XFILLER_40_436 VPWR VGND sg13g2_decap_8
XFILLER_107_1521 VPWR VGND sg13g2_fill_2
XFILLER_55_1464 VPWR VGND sg13g2_fill_2
X_21625_ _21687_/B _22363_/B _21756_/B VPWR VGND sg13g2_or2_1
XFILLER_21_672 VPWR VGND sg13g2_decap_8
XFILLER_32_45 VPWR VGND sg13g2_fill_2
X_21556_ _23796_/D _21622_/A1 _21555_/B _21555_/Y VPWR VGND sg13g2_o21ai_1
XFILLER_107_1598 VPWR VGND sg13g2_decap_8
Xplace4160 _13795_/S1 _13797_/S VPWR VGND sg13g2_buf_1
Xplace4171 _13270_/S1 _12974_/A VPWR VGND sg13g2_buf_2
X_20507_ _23313_/D _23313_/Q _22446_/A1 _20511_/S VPWR VGND sg13g2_mux2_1
Xplace4182 _12570_/S _22985_/Q VPWR VGND sg13g2_buf_1
X_24275_ _24275_/X _24275_/A VPWR VGND sg13g2_buf_1
Xplace4193 _11706_/S _11449_/B VPWR VGND sg13g2_buf_2
XFILLER_5_827 VPWR VGND sg13g2_decap_8
X_21487_ _23762_/D _21619_/A1 _21486_/B _21486_/Y VPWR VGND sg13g2_o21ai_1
XFILLER_5_838 VPWR VGND sg13g2_fill_1
XFILLER_4_304 VPWR VGND sg13g2_decap_8
Xplace3470 _16561_/A _16678_/S VPWR VGND sg13g2_buf_1
XFILLER_68_1814 VPWR VGND sg13g2_decap_8
Xplace3481 _16197_/B _16183_/B VPWR VGND sg13g2_buf_1
XFILLER_68_1825 VPWR VGND sg13g2_decap_4
X_23226_ _23226_/Q clkload44/A _23226_/D fanout2751/X VPWR VGND sg13g2_dfrbpq_1
XFILLER_10_1036 VPWR VGND sg13g2_decap_4
Xplace3492 _15589_/S _15496_/S VPWR VGND sg13g2_buf_1
XFILLER_10_1047 VPWR VGND sg13g2_fill_1
XFILLER_4_348 VPWR VGND sg13g2_decap_8
XFILLER_68_1847 VPWR VGND sg13g2_decap_8
XFILLER_10_1058 VPWR VGND sg13g2_fill_2
XFILLER_107_777 VPWR VGND sg13g2_decap_8
XFILLER_49_1246 VPWR VGND sg13g2_decap_8
X_11171_ _24215_/D _11171_/A _24215_/Q VPWR VGND sg13g2_or2_1
X_23157_ _23157_/Q _23187_/CLK _23157_/D fanout2916/X VPWR VGND sg13g2_dfrbpq_1
X_20369_ _22252_/A _21087_/A _20514_/B VPWR VGND sg13g2_nor2_1
XFILLER_49_1279 VPWR VGND sg13g2_decap_8
XFILLER_106_287 VPWR VGND sg13g2_fill_2
XFILLER_106_298 VPWR VGND sg13g2_fill_2
XFILLER_79_138 VPWR VGND sg13g2_decap_8
X_22108_ _22108_/Y _22108_/A _22108_/B VPWR VGND sg13g2_nand2_1
XFILLER_79_149 VPWR VGND sg13g2_fill_1
X_23088_ _23088_/Q _23215_/CLK _23088_/D fanout2925/X VPWR VGND sg13g2_dfrbpq_1
XFILLER_66_1582 VPWR VGND sg13g2_fill_2
XFILLER_103_972 VPWR VGND sg13g2_decap_8
XFILLER_23_1408 VPWR VGND sg13g2_fill_2
X_14930_ _14930_/Y _17873_/A1 _15029_/B _18635_/A2 _19211_/A0 _14929_/Y VPWR VGND
+ sg13g2_a221oi_1
X_22039_ _22039_/Y _22039_/A _22039_/B VPWR VGND sg13g2_nand2_1
XFILLER_48_514 VPWR VGND sg13g2_decap_8
XFILLER_57_42 VPWR VGND sg13g2_decap_8
XFILLER_62_1479 VPWR VGND sg13g2_decap_4
XFILLER_97_1509 VPWR VGND sg13g2_decap_8
X_14861_ _14862_/C _14861_/A _14861_/B VPWR VGND sg13g2_or2_1
XFILLER_75_344 VPWR VGND sg13g2_decap_4
XFILLER_91_804 VPWR VGND sg13g2_decap_8
XFILLER_75_355 VPWR VGND sg13g2_fill_1
XFILLER_5_1362 VPWR VGND sg13g2_decap_4
XFILLER_76_889 VPWR VGND sg13g2_decap_8
X_16600_ _16601_/B _22634_/Q _16604_/C VPWR VGND sg13g2_nand2_1
XFILLER_112_1260 VPWR VGND sg13g2_decap_8
XFILLER_91_826 VPWR VGND sg13g2_decap_8
XFILLER_1_1215 VPWR VGND sg13g2_fill_2
X_13812_ _13812_/X _23922_/Q _24018_/Q _24114_/Q _24146_/Q _13974_/S _17718_/B2 VPWR
+ VGND sg13g2_mux4_1
X_17580_ _17580_/Y _17579_/Y _17580_/B VPWR VGND sg13g2_nand2b_1
XFILLER_99_1380 VPWR VGND sg13g2_decap_8
XFILLER_21_1165 VPWR VGND sg13g2_fill_1
X_14792_ _14882_/B _16856_/C _14792_/B VPWR VGND sg13g2_nor2_1
XFILLER_113_70 VPWR VGND sg13g2_decap_8
XFILLER_112_1282 VPWR VGND sg13g2_fill_2
XFILLER_95_1222 VPWR VGND sg13g2_fill_2
XFILLER_28_271 VPWR VGND sg13g2_decap_8
XFILLER_112_1293 VPWR VGND sg13g2_decap_8
XFILLER_95_1233 VPWR VGND sg13g2_fill_2
XFILLER_21_1176 VPWR VGND sg13g2_decap_4
XFILLER_75_1807 VPWR VGND sg13g2_decap_8
X_16531_ _22620_/D _17444_/A1 _16547_/A _16530_/Y VPWR VGND sg13g2_a21oi_1
XFILLER_17_956 VPWR VGND sg13g2_fill_1
XFILLER_17_967 VPWR VGND sg13g2_decap_8
X_13743_ _13743_/Y _13743_/A _13742_/A VPWR VGND sg13g2_nor2b_1
XFILLER_32_915 VPWR VGND sg13g2_decap_4
XFILLER_108_1307 VPWR VGND sg13g2_decap_4
X_19250_ _23190_/D _19268_/A _19246_/Y _19249_/Y VPWR VGND sg13g2_o21ai_1
XFILLER_73_1520 VPWR VGND sg13g2_decap_8
X_13674_ _13674_/Y _13674_/A _13674_/B VPWR VGND sg13g2_nor2_1
XFILLER_19_1050 VPWR VGND sg13g2_decap_8
X_15413_ _15413_/Y _22455_/Q VPWR VGND sg13g2_inv_1
X_19181_ _23151_/D _23151_/Q _15083_/Y _19181_/S VPWR VGND sg13g2_mux2_1
X_12625_ _12625_/Y _20013_/A _12762_/B _12622_/Y _12623_/X _12759_/A VPWR VGND sg13g2_a221oi_1
XFILLER_12_650 VPWR VGND sg13g2_decap_8
XFILLER_40_970 VPWR VGND sg13g2_fill_1
XFILLER_106_1053 VPWR VGND sg13g2_decap_8
X_12556_ _12556_/X _23713_/Q _23777_/Q _23841_/Q _23937_/Q _12478_/S _12487_/S VPWR
+ VGND sg13g2_mux4_1
XFILLER_106_1064 VPWR VGND sg13g2_fill_2
XFILLER_11_171 VPWR VGND sg13g2_decap_8
XFILLER_7_120 VPWR VGND sg13g2_fill_2
XFILLER_12_1813 VPWR VGND sg13g2_decap_8
X_11507_ _11507_/X _24181_/Q _23253_/Q _23317_/Q _23381_/Q _11960_/S _11295_/A VPWR
+ VGND sg13g2_mux4_1
XFILLER_103_1952 VPWR VGND sg13g2_fill_2
XFILLER_32_1261 VPWR VGND sg13g2_fill_1
X_15275_ _16029_/B _14167_/A _15274_/Y _15133_/A VPWR VGND sg13g2_a21oi_1
X_12487_ _12487_/X _23776_/Q _23936_/Q _12487_/S VPWR VGND sg13g2_mux2_1
X_17014_ _17015_/B _17024_/A _17018_/B VPWR VGND sg13g2_nor2b_1
XFILLER_86_1925 VPWR VGND sg13g2_fill_2
X_14226_ _14831_/B _14226_/A _14226_/B VPWR VGND sg13g2_and2_1
X_11438_ _20272_/A _14274_/A _15216_/B VPWR VGND sg13g2_nand2b_1
XFILLER_47_1909 VPWR VGND sg13g2_decap_8
XFILLER_67_1335 VPWR VGND sg13g2_fill_1
XFILLER_4_860 VPWR VGND sg13g2_decap_8
X_14157_ _16858_/A _15268_/A _14463_/B VPWR VGND sg13g2_or2_1
XFILLER_113_736 VPWR VGND sg13g2_decap_8
XFILLER_112_224 VPWR VGND sg13g2_decap_8
XFILLER_49_1780 VPWR VGND sg13g2_decap_8
X_13108_ _13108_/Y _13770_/A _13105_/X _13107_/X VPWR VGND sg13g2_a21oi_1
XFILLER_98_458 VPWR VGND sg13g2_fill_1
X_18965_ _18966_/B _18964_/Y _23054_/Q _19001_/C VPWR VGND sg13g2_mux2_1
X_14088_ _19489_/C _11602_/Y _11607_/Y _11611_/Y _11612_/X VPWR VGND sg13g2_a22oi_1
XFILLER_45_1633 VPWR VGND sg13g2_decap_4
XFILLER_80_1524 VPWR VGND sg13g2_fill_1
X_17916_ _22936_/D _17916_/A _17916_/B VPWR VGND sg13g2_nand2_1
X_13039_ _13039_/X _24039_/Q _24071_/Q _13039_/S VPWR VGND sg13g2_mux2_1
XFILLER_39_514 VPWR VGND sg13g2_decap_8
X_18896_ _18897_/C _18926_/A _23080_/Q VPWR VGND sg13g2_nand2_1
XFILLER_41_1519 VPWR VGND sg13g2_decap_8
XFILLER_66_311 VPWR VGND sg13g2_decap_8
XFILLER_26_1076 VPWR VGND sg13g2_fill_2
X_17847_ _17847_/Y _22914_/Q _17853_/B _17849_/C VPWR VGND sg13g2_nand3_1
XFILLER_14_2 VPWR VGND sg13g2_fill_1
XFILLER_110_1901 VPWR VGND sg13g2_decap_8
XFILLER_82_815 VPWR VGND sg13g2_fill_2
XFILLER_54_506 VPWR VGND sg13g2_fill_2
XFILLER_82_837 VPWR VGND sg13g2_decap_8
XFILLER_78_1420 VPWR VGND sg13g2_decap_8
X_17778_ _17778_/Y _17784_/A _17784_/B VPWR VGND sg13g2_xnor2_1
XFILLER_82_859 VPWR VGND sg13g2_decap_4
XFILLER_81_336 VPWR VGND sg13g2_decap_8
XFILLER_47_591 VPWR VGND sg13g2_decap_8
X_19517_ _19525_/A _19513_/Y _19516_/Y _20100_/C1 VPWR VGND sg13g2_a21o_1
X_16729_ _22661_/D _16080_/Y _16711_/A _16728_/Y VPWR VGND sg13g2_a21oi_1
XFILLER_39_1415 VPWR VGND sg13g2_fill_2
X_19448_ _19448_/Y _19448_/A _19448_/B VPWR VGND sg13g2_nor2_1
XFILLER_50_734 VPWR VGND sg13g2_fill_2
XFILLER_72_1030 VPWR VGND sg13g2_decap_4
XFILLER_108_1841 VPWR VGND sg13g2_decap_8
XFILLER_91_1653 VPWR VGND sg13g2_decap_8
X_19379_ _19708_/S _19605_/A _19379_/B VPWR VGND sg13g2_xnor2_1
XFILLER_56_1784 VPWR VGND sg13g2_fill_2
XFILLER_33_1003 VPWR VGND sg13g2_decap_8
X_21410_ _21410_/Y _21410_/A _21416_/B VPWR VGND sg13g2_nand2_1
X_22390_ _24181_/D _22390_/A1 _22393_/B _22389_/Y VPWR VGND sg13g2_o21ai_1
XFILLER_31_992 VPWR VGND sg13g2_decap_8
XFILLER_33_1036 VPWR VGND sg13g2_decap_4
X_21341_ _21341_/Y _23692_/Q _21347_/B VPWR VGND sg13g2_nand2_1
XFILLER_11_1312 VPWR VGND sg13g2_decap_8
XFILLER_11_1323 VPWR VGND sg13g2_fill_2
X_24060_ _24060_/Q clkload56/A _24060_/D fanout2678/X VPWR VGND sg13g2_dfrbpq_1
X_21272_ _23658_/D _21606_/A1 _21271_/B _21271_/Y VPWR VGND sg13g2_o21ai_1
X_23011_ _23011_/Q clkload15/A _23011_/D fanout2853/X VPWR VGND sg13g2_dfrbpq_1
X_20223_ _20224_/B _20316_/S0 _23220_/Q _20222_/Y VPWR VGND sg13g2_o21ai_1
XFILLER_1_318 VPWR VGND sg13g2_decap_8
XFILLER_104_736 VPWR VGND sg13g2_decap_4
XFILLER_28_1831 VPWR VGND sg13g2_decap_4
X_20154_ _20154_/X _20278_/A3 _23215_/Q _20278_/A2 _20278_/A1 _19501_/A _20154_/S1
+ VPWR VGND sg13g2_mux4_1
XFILLER_115_1812 VPWR VGND sg13g2_decap_8
XFILLER_28_1875 VPWR VGND sg13g2_fill_2
X_20085_ _20085_/Y _20085_/A _20085_/B VPWR VGND sg13g2_nand2_1
XFILLER_85_620 VPWR VGND sg13g2_decap_8
XFILLER_44_1165 VPWR VGND sg13g2_decap_8
XFILLER_57_333 VPWR VGND sg13g2_decap_8
X_23913_ _23913_/Q _24205_/CLK _23913_/D fanout2650/X VPWR VGND sg13g2_dfrbpq_1
XFILLER_115_1889 VPWR VGND sg13g2_decap_8
XFILLER_85_653 VPWR VGND sg13g2_decap_8
XFILLER_73_804 VPWR VGND sg13g2_fill_1
XFILLER_6_1693 VPWR VGND sg13g2_decap_8
X_23844_ _23844_/Q clkload41/A _23844_/D fanout2729/X VPWR VGND sg13g2_dfrbpq_1
XFILLER_2_1546 VPWR VGND sg13g2_decap_8
XFILLER_73_859 VPWR VGND sg13g2_fill_2
X_23775_ _23775_/Q clkload43/A _23775_/D fanout2740/X VPWR VGND sg13g2_dfrbpq_1
XFILLER_25_241 VPWR VGND sg13g2_decap_8
X_20987_ _20987_/Y _20987_/A _20990_/B VPWR VGND sg13g2_nand2_1
XFILLER_96_1586 VPWR VGND sg13g2_decap_4
XFILLER_14_915 VPWR VGND sg13g2_fill_1
XFILLER_92_1428 VPWR VGND sg13g2_fill_1
XFILLER_53_561 VPWR VGND sg13g2_fill_2
X_22726_ _22726_/Q clkload22/A _22726_/D fanout2884/X VPWR VGND sg13g2_dfrbpq_1
XFILLER_74_1840 VPWR VGND sg13g2_fill_2
XFILLER_109_1649 VPWR VGND sg13g2_fill_2
XFILLER_80_391 VPWR VGND sg13g2_decap_8
XFILLER_74_1862 VPWR VGND sg13g2_decap_8
XFILLER_16_1201 VPWR VGND sg13g2_fill_2
X_22657_ _22657_/Q clkload24/A _22657_/D fanout2889/X VPWR VGND sg13g2_dfrbpq_1
XFILLER_55_1261 VPWR VGND sg13g2_fill_1
XFILLER_35_1846 VPWR VGND sg13g2_decap_8
XFILLER_70_1726 VPWR VGND sg13g2_decap_8
XFILLER_107_1351 VPWR VGND sg13g2_decap_8
XFILLER_16_1234 VPWR VGND sg13g2_fill_2
X_12410_ _12411_/B _12408_/X _12409_/X _12707_/S VPWR VGND sg13g2_mux2_1
XFILLER_70_1737 VPWR VGND sg13g2_fill_2
X_21608_ _23819_/D _21677_/A1 _21615_/B _21607_/Y VPWR VGND sg13g2_o21ai_1
X_13390_ _13391_/B _23308_/Q _23340_/Q _23372_/Q _23404_/Q _13555_/S0 _13016_/S VPWR
+ VGND sg13g2_mux4_1
XFILLER_16_1256 VPWR VGND sg13g2_decap_8
X_22588_ _22588_/Q _22917_/CLK _22588_/D fanout2895/X VPWR VGND sg13g2_dfrbpq_1
X_12341_ _12429_/B _12341_/A _12341_/B _12533_/A _12533_/B VPWR VGND sg13g2_nand4_1
XFILLER_5_602 VPWR VGND sg13g2_fill_2
X_21539_ _21539_/Y _21539_/A _21539_/B VPWR VGND sg13g2_nand2_1
X_15060_ _18726_/A _15060_/A _15060_/B VPWR VGND sg13g2_or2_1
X_12272_ _12277_/B _12531_/A _12968_/B _16781_/A _19861_/A VPWR VGND sg13g2_or4_1
X_24258_ _24258_/X _24258_/A VPWR VGND sg13g2_buf_1
XFILLER_4_123 VPWR VGND sg13g2_decap_8
XFILLER_107_541 VPWR VGND sg13g2_decap_8
X_14011_ _17041_/A _14011_/A _14427_/D _14427_/C _14427_/B VPWR VGND sg13g2_nand4_1
XFILLER_68_1644 VPWR VGND sg13g2_decap_8
XFILLER_104_0 VPWR VGND sg13g2_decap_8
X_23209_ _23209_/Q clkload33/A _23209_/D fanout2930/X VPWR VGND sg13g2_dfrbpq_1
X_11223_ _11929_/B _23193_/Q _11239_/A2 _11222_/X VPWR VGND sg13g2_a21o_1
X_24189_ _24189_/Q _24190_/CLK _24189_/D fanout2773/X VPWR VGND sg13g2_dfrbpq_1
XFILLER_108_70 VPWR VGND sg13g2_decap_8
XFILLER_46_1953 VPWR VGND sg13g2_fill_2
XFILLER_49_801 VPWR VGND sg13g2_decap_8
X_18750_ _18756_/B _23027_/Q _23028_/Q _18750_/C VPWR VGND sg13g2_nand3_1
XFILLER_81_1866 VPWR VGND sg13g2_fill_1
XFILLER_7_1435 VPWR VGND sg13g2_fill_1
X_15962_ _16199_/A _15960_/Y _15956_/B _15961_/Y VPWR VGND sg13g2_o21ai_1
XFILLER_0_373 VPWR VGND sg13g2_decap_4
XFILLER_27_1374 VPWR VGND sg13g2_fill_2
XFILLER_103_791 VPWR VGND sg13g2_decap_8
X_17701_ _17701_/Y _17135_/A _17382_/A _17580_/B _17700_/Y VPWR VGND sg13g2_a22oi_1
XFILLER_76_631 VPWR VGND sg13g2_fill_2
X_14913_ _14916_/C _22921_/Q _14885_/D _14788_/B VPWR VGND sg13g2_o21ai_1
XFILLER_102_290 VPWR VGND sg13g2_fill_1
X_18681_ _18690_/B _23014_/Q _23015_/Q _18684_/B VPWR VGND sg13g2_nand3_1
X_15893_ _15896_/B _22508_/Q _15893_/A2 _15893_/B1 _14202_/A VPWR VGND sg13g2_a22oi_1
XFILLER_75_141 VPWR VGND sg13g2_decap_8
XFILLER_91_601 VPWR VGND sg13g2_decap_8
XFILLER_84_40 VPWR VGND sg13g2_decap_8
X_17632_ _22886_/D _17661_/B _17630_/Y _17631_/Y VPWR VGND sg13g2_a21oi_1
X_14844_ _14844_/X _23128_/Q _16241_/A _14933_/S VPWR VGND sg13g2_mux2_1
XFILLER_63_314 VPWR VGND sg13g2_decap_8
XFILLER_90_144 VPWR VGND sg13g2_decap_8
X_17563_ _17563_/Y _17622_/A _22950_/Q VPWR VGND sg13g2_nand2_1
XFILLER_90_155 VPWR VGND sg13g2_fill_1
X_19302_ _23219_/D _23219_/Q _20343_/A0 _19303_/S VPWR VGND sg13g2_mux2_1
XFILLER_1_1089 VPWR VGND sg13g2_fill_1
X_16514_ _16514_/Y _22617_/Q _16514_/B VPWR VGND sg13g2_nand2_1
X_13726_ _13726_/Y _13722_/Y _13723_/X _13724_/Y _14103_/A _13725_/Y VPWR VGND sg13g2_a221oi_1
XFILLER_108_1104 VPWR VGND sg13g2_fill_1
X_17494_ _17494_/Y _17494_/A _17498_/B VPWR VGND sg13g2_nand2_1
XFILLER_56_1036 VPWR VGND sg13g2_decap_8
XFILLER_92_1951 VPWR VGND sg13g2_decap_4
X_19233_ _23186_/D _14427_/B _19232_/B _19232_/Y VPWR VGND sg13g2_o21ai_1
X_16445_ _16445_/Y _22587_/Q _16456_/B VPWR VGND sg13g2_nand2_1
XFILLER_32_767 VPWR VGND sg13g2_decap_8
X_13657_ _13657_/X _13657_/A _13657_/B _13657_/C VPWR VGND sg13g2_or3_1
XFILLER_31_266 VPWR VGND sg13g2_decap_8
X_19164_ _23136_/D _23136_/Q _14933_/X _19171_/S VPWR VGND sg13g2_mux2_1
XFILLER_31_288 VPWR VGND sg13g2_decap_8
X_12608_ _12608_/X _22560_/Q _13181_/B VPWR VGND sg13g2_or2_1
X_16376_ _16376_/Y _22550_/Q _16376_/B VPWR VGND sg13g2_nand2_1
XFILLER_31_299 VPWR VGND sg13g2_fill_1
X_13588_ _13597_/C _13582_/X _13587_/Y _13419_/A VPWR VGND sg13g2_a21oi_1
XFILLER_34_1367 VPWR VGND sg13g2_fill_1
XFILLER_9_974 VPWR VGND sg13g2_decap_8
X_18115_ _18115_/Y _18530_/A VPWR VGND sg13g2_inv_1
X_15327_ _15327_/Y _22654_/Q _15323_/X _15325_/Y _22718_/Q VPWR VGND sg13g2_a22oi_1
XFILLER_34_1389 VPWR VGND sg13g2_decap_8
X_19095_ _23083_/D _23083_/Q _19094_/X _19099_/S VPWR VGND sg13g2_mux2_1
X_12539_ _12539_/Y _12539_/A1 _12623_/B _12538_/X VPWR VGND sg13g2_a21oi_1
XFILLER_12_1632 VPWR VGND sg13g2_decap_4
XFILLER_69_1419 VPWR VGND sg13g2_decap_8
X_18046_ _18046_/Y _24225_/Q _19126_/A1 VPWR VGND sg13g2_nor2b_1
X_15258_ _15258_/Y _19773_/A _16782_/B _16782_/C _16782_/D VPWR VGND sg13g2_nor4_1
Xhold4908 _22289_/A _24132_/Q VPWR VGND sg13g2_dlygate4sd3_1
Xhold4919 _21742_/A _23875_/Q VPWR VGND sg13g2_dlygate4sd3_1
XFILLER_67_1121 VPWR VGND sg13g2_decap_8
X_14209_ _14210_/B _15969_/A _22834_/Q VPWR VGND sg13g2_nand2_1
XFILLER_47_1706 VPWR VGND sg13g2_fill_2
XFILLER_99_723 VPWR VGND sg13g2_decap_8
X_15189_ _17373_/A _17034_/C _15210_/B VPWR VGND sg13g2_nor2b_1
XFILLER_99_745 VPWR VGND sg13g2_decap_8
XFILLER_113_533 VPWR VGND sg13g2_decap_8
XFILLER_98_222 VPWR VGND sg13g2_decap_8
XFILLER_63_1018 VPWR VGND sg13g2_decap_8
X_19997_ _19997_/Y _20266_/B2 _19991_/Y _19996_/Y VPWR VGND sg13g2_a21oi_1
XFILLER_101_728 VPWR VGND sg13g2_decap_8
XFILLER_58_119 VPWR VGND sg13g2_fill_2
X_18948_ _18948_/Y _18959_/A _23084_/Q _18959_/C VPWR VGND sg13g2_nand3_1
XFILLER_104_28 VPWR VGND sg13g2_decap_8
X_18879_ _18879_/Y _18899_/A _18879_/B _18879_/C VPWR VGND sg13g2_nand3b_1
X_20910_ _20910_/Y _20910_/A _20913_/B VPWR VGND sg13g2_nand2_1
XFILLER_67_697 VPWR VGND sg13g2_fill_1
X_21890_ _23940_/D _21956_/A1 _21893_/B _21889_/Y VPWR VGND sg13g2_o21ai_1
XFILLER_3_1855 VPWR VGND sg13g2_decap_8
XFILLER_55_859 VPWR VGND sg13g2_decap_4
XFILLER_66_196 VPWR VGND sg13g2_fill_2
X_20841_ _20841_/Y _23468_/Q _20841_/B VPWR VGND sg13g2_nand2_1
XFILLER_81_144 VPWR VGND sg13g2_decap_8
XFILLER_78_1250 VPWR VGND sg13g2_decap_4
XFILLER_42_509 VPWR VGND sg13g2_fill_1
XFILLER_82_689 VPWR VGND sg13g2_decap_8
XFILLER_35_561 VPWR VGND sg13g2_fill_1
XFILLER_63_870 VPWR VGND sg13g2_decap_8
XFILLER_74_1103 VPWR VGND sg13g2_decap_8
XFILLER_23_723 VPWR VGND sg13g2_decap_8
X_23560_ _23560_/Q clkload32/A _23560_/D fanout2649/X VPWR VGND sg13g2_dfrbpq_1
XFILLER_22_200 VPWR VGND sg13g2_decap_8
X_20772_ _20772_/Y _23436_/Q _20772_/B VPWR VGND sg13g2_nand2_1
XFILLER_22_233 VPWR VGND sg13g2_decap_8
XFILLER_23_756 VPWR VGND sg13g2_fill_2
X_22511_ _22511_/Q clkload8/A _22511_/D fanout2807/X VPWR VGND sg13g2_dfrbpq_1
XFILLER_39_1278 VPWR VGND sg13g2_decap_8
XFILLER_74_1158 VPWR VGND sg13g2_decap_8
XFILLER_11_907 VPWR VGND sg13g2_fill_2
X_23491_ _23491_/Q clkload34/A _23491_/D fanout2701/X VPWR VGND sg13g2_dfrbpq_1
XFILLER_22_244 VPWR VGND sg13g2_fill_1
XFILLER_50_553 VPWR VGND sg13g2_decap_8
XFILLER_52_1401 VPWR VGND sg13g2_fill_1
XFILLER_50_575 VPWR VGND sg13g2_decap_4
XFILLER_108_1660 VPWR VGND sg13g2_decap_4
XFILLER_10_417 VPWR VGND sg13g2_decap_8
XFILLER_56_1592 VPWR VGND sg13g2_fill_1
XFILLER_108_1671 VPWR VGND sg13g2_decap_4
XFILLER_10_428 VPWR VGND sg13g2_decap_8
X_22442_ _24206_/D _22442_/A1 _22444_/B _22441_/Y VPWR VGND sg13g2_o21ai_1
XFILLER_10_439 VPWR VGND sg13g2_fill_2
XFILLER_22_299 VPWR VGND sg13g2_fill_2
XFILLER_52_1456 VPWR VGND sg13g2_fill_2
X_22373_ _24173_/D _24173_/Q _22373_/A1 _22382_/S VPWR VGND sg13g2_mux2_1
XFILLER_104_1568 VPWR VGND sg13g2_decap_8
X_24112_ _24112_/Q _24210_/CLK _24112_/D fanout2635/X VPWR VGND sg13g2_dfrbpq_1
X_21324_ _21324_/Y _21324_/A _21332_/B VPWR VGND sg13g2_nand2_1
XFILLER_69_1953 VPWR VGND sg13g2_fill_2
XFILLER_30_1798 VPWR VGND sg13g2_fill_1
X_24043_ _24043_/Q clkload16/A _24043_/D fanout2633/X VPWR VGND sg13g2_dfrbpq_1
X_21255_ _23649_/D _21321_/A1 _21264_/B _21254_/Y VPWR VGND sg13g2_o21ai_1
XFILLER_2_627 VPWR VGND sg13g2_fill_1
XFILLER_104_533 VPWR VGND sg13g2_decap_8
X_20206_ _23242_/D _20269_/B _22435_/A1 _20205_/Y VPWR VGND sg13g2_o21ai_1
XFILLER_8_1700 VPWR VGND sg13g2_fill_2
X_21186_ _21186_/Y _23617_/Q _21188_/B VPWR VGND sg13g2_nand2_1
XFILLER_78_929 VPWR VGND sg13g2_decap_8
X_20137_ _20139_/A _20294_/A _20137_/B VPWR VGND sg13g2_nor2_1
XFILLER_49_119 VPWR VGND sg13g2_fill_1
XFILLER_115_1620 VPWR VGND sg13g2_decap_8
XFILLER_8_1755 VPWR VGND sg13g2_decap_8
XFILLER_58_620 VPWR VGND sg13g2_decap_4
XFILLER_86_940 VPWR VGND sg13g2_decap_8
XFILLER_86_951 VPWR VGND sg13g2_fill_2
X_20068_ _20069_/D _20063_/Y _20085_/B _19861_/B _20067_/Y _15650_/C VPWR VGND sg13g2_a221oi_1
XFILLER_100_750 VPWR VGND sg13g2_decap_4
XFILLER_115_1686 VPWR VGND sg13g2_decap_8
XFILLER_85_461 VPWR VGND sg13g2_decap_8
XFILLER_24_1569 VPWR VGND sg13g2_decap_8
XFILLER_86_995 VPWR VGND sg13g2_decap_4
X_11910_ _11911_/A _11910_/A _11910_/B _11910_/C VPWR VGND sg13g2_nand3_1
XFILLER_57_163 VPWR VGND sg13g2_decap_8
XFILLER_58_697 VPWR VGND sg13g2_fill_2
XFILLER_57_174 VPWR VGND sg13g2_fill_2
X_12890_ _12890_/X _24037_/Q _24101_/Q _13264_/B VPWR VGND sg13g2_mux2_1
XFILLER_76_1902 VPWR VGND sg13g2_decap_8
X_23827_ _23827_/Q clkload51/A _23827_/D fanout2666/X VPWR VGND sg13g2_dfrbpq_1
X_11841_ _11841_/Y _23609_/Q _12235_/S VPWR VGND sg13g2_nand2b_1
XFILLER_54_870 VPWR VGND sg13g2_fill_2
XFILLER_109_1402 VPWR VGND sg13g2_fill_2
XFILLER_92_1214 VPWR VGND sg13g2_decap_8
XFILLER_92_1225 VPWR VGND sg13g2_fill_1
X_11772_ _11772_/Y _11738_/Y _11743_/Y _11771_/Y VPWR VGND sg13g2_o21ai_1
X_14560_ _24228_/D _19150_/A _14560_/B VPWR VGND sg13g2_nor2_1
XFILLER_13_200 VPWR VGND sg13g2_fill_1
XFILLER_57_1345 VPWR VGND sg13g2_decap_8
XFILLER_18_1307 VPWR VGND sg13g2_decap_4
XFILLER_26_594 VPWR VGND sg13g2_fill_1
X_23758_ _23758_/Q _24131_/CLK _23758_/D fanout2744/X VPWR VGND sg13g2_dfrbpq_1
XFILLER_41_553 VPWR VGND sg13g2_fill_2
X_22709_ _22709_/Q clkload19/A _22709_/D fanout2862/X VPWR VGND sg13g2_dfrbpq_1
X_14491_ _14497_/C _14491_/A _14491_/B _14491_/C _14491_/D VPWR VGND sg13g2_nor4_1
XFILLER_74_1670 VPWR VGND sg13g2_decap_8
X_23689_ _23689_/Q clkload47/A _23689_/D fanout2680/X VPWR VGND sg13g2_dfrbpq_1
XFILLER_14_789 VPWR VGND sg13g2_decap_8
XFILLER_74_1681 VPWR VGND sg13g2_fill_2
XFILLER_9_226 VPWR VGND sg13g2_fill_1
X_16230_ _16230_/Y _24249_/A _14879_/A _14840_/Y VPWR VGND sg13g2_a21oi_1
X_13442_ _13442_/Y _13099_/Y _13436_/Y _13440_/Y _13438_/Y VPWR VGND sg13g2_a22oi_1
XFILLER_16_1042 VPWR VGND sg13g2_decap_8
XFILLER_35_1665 VPWR VGND sg13g2_decap_8
XFILLER_55_1091 VPWR VGND sg13g2_fill_1
XFILLER_70_42 VPWR VGND sg13g2_decap_8
XFILLER_6_911 VPWR VGND sg13g2_decap_8
X_16161_ _16161_/X _16161_/A _17835_/B VPWR VGND sg13g2_and2_1
X_13373_ _13373_/Y _13373_/A _13373_/B _13373_/C _13373_/D VPWR VGND sg13g2_nor4_1
XFILLER_103_1045 VPWR VGND sg13g2_decap_8
XFILLER_13_1941 VPWR VGND sg13g2_decap_8
Xclkload18 clkload18/X clkload18/A VPWR VGND sg13g2_buf_8
Xclkload29 clkload29/Y clkload29/A VPWR VGND sg13g2_inv_8
XFILLER_100_1911 VPWR VGND sg13g2_decap_8
X_15112_ _15112_/Y _22543_/Q VPWR VGND sg13g2_inv_1
XFILLER_5_421 VPWR VGND sg13g2_decap_8
X_12324_ _14318_/A _12324_/A _12324_/B _12324_/C VPWR VGND sg13g2_and3_2
XFILLER_5_432 VPWR VGND sg13g2_fill_2
X_16092_ _16092_/Y _17866_/A _16119_/B VPWR VGND sg13g2_nor2_1
XFILLER_103_1089 VPWR VGND sg13g2_fill_1
X_19920_ _19921_/B _20100_/A1 _19916_/Y _19918_/Y _20352_/A _19946_/C1 VPWR VGND sg13g2_a221oi_1
X_15043_ _15043_/Y _15073_/A _15043_/B VPWR VGND sg13g2_nor2_1
X_12255_ _12256_/A _12820_/S _12252_/Y _12254_/Y VPWR VGND sg13g2_a21oi_1
XFILLER_5_487 VPWR VGND sg13g2_decap_8
XFILLER_29_1414 VPWR VGND sg13g2_fill_2
X_11206_ _12583_/C _11614_/A _11255_/B VPWR VGND sg13g2_or2_1
X_19851_ _19851_/Y _19848_/Y _19850_/Y _19884_/A VPWR VGND sg13g2_o21ai_1
X_18802_ _18807_/A _23035_/Q _18827_/B _18865_/C VPWR VGND sg13g2_nand3_1
X_19782_ _19782_/Y _19782_/A1 _19780_/Y _19781_/Y VPWR VGND sg13g2_a21oi_1
X_16994_ _16995_/B _17004_/B _17008_/D VPWR VGND sg13g2_nor2b_1
XFILLER_62_1040 VPWR VGND sg13g2_decap_4
XFILLER_68_439 VPWR VGND sg13g2_fill_2
XFILLER_110_536 VPWR VGND sg13g2_decap_8
XFILLER_46_1783 VPWR VGND sg13g2_decap_8
XFILLER_42_1625 VPWR VGND sg13g2_fill_1
XFILLER_114_1130 VPWR VGND sg13g2_fill_2
X_18733_ _18741_/B _23023_/Q _23024_/Q _23025_/Q _18733_/D VPWR VGND sg13g2_nand4_1
XFILLER_95_258 VPWR VGND sg13g2_fill_2
X_15945_ _15949_/C _22479_/Q _15945_/A2 _15945_/B1 _22810_/Q VPWR VGND sg13g2_a22oi_1
XFILLER_42_1658 VPWR VGND sg13g2_fill_2
XFILLER_95_72 VPWR VGND sg13g2_fill_2
XFILLER_95_94 VPWR VGND sg13g2_decap_8
XFILLER_92_921 VPWR VGND sg13g2_fill_1
XFILLER_7_1298 VPWR VGND sg13g2_decap_8
XFILLER_20_1912 VPWR VGND sg13g2_decap_8
X_18664_ _18666_/C _23002_/Q _23004_/Q VPWR VGND sg13g2_nand2_1
XFILLER_92_943 VPWR VGND sg13g2_fill_2
X_15876_ _15877_/B _22709_/Q _15898_/A2 _15898_/B1 _22645_/Q VPWR VGND sg13g2_a22oi_1
XFILLER_76_494 VPWR VGND sg13g2_decap_8
XFILLER_110_1038 VPWR VGND sg13g2_decap_8
XFILLER_40_1360 VPWR VGND sg13g2_fill_2
X_17615_ _17615_/Y _22555_/Q _17615_/B VPWR VGND sg13g2_xnor2_1
X_18595_ _22998_/D _22998_/Q _18595_/A1 _19130_/S VPWR VGND sg13g2_mux2_1
XFILLER_63_155 VPWR VGND sg13g2_fill_1
XFILLER_64_678 VPWR VGND sg13g2_fill_1
XFILLER_91_486 VPWR VGND sg13g2_decap_4
X_14758_ _14758_/Y _14758_/A _14758_/B _14758_/C VPWR VGND sg13g2_nand3_1
XFILLER_17_594 VPWR VGND sg13g2_decap_8
XFILLER_75_1467 VPWR VGND sg13g2_decap_8
X_13709_ _13709_/X _23568_/Q _24016_/Q _13955_/S VPWR VGND sg13g2_mux2_1
XFILLER_75_1478 VPWR VGND sg13g2_fill_2
XFILLER_18_1830 VPWR VGND sg13g2_decap_8
X_17477_ _17477_/Y _17477_/A _17507_/S VPWR VGND sg13g2_nand2_1
X_14689_ _14689_/Y _14689_/A _14694_/B VPWR VGND sg13g2_nand2_1
XFILLER_53_1721 VPWR VGND sg13g2_decap_4
X_19216_ _23172_/D _20123_/A1 _19234_/S _19215_/Y VPWR VGND sg13g2_o21ai_1
X_16428_ _22581_/D _17517_/D _16431_/B _16427_/Y VPWR VGND sg13g2_o21ai_1
XFILLER_53_1754 VPWR VGND sg13g2_fill_2
XFILLER_73_1180 VPWR VGND sg13g2_decap_8
XFILLER_53_1787 VPWR VGND sg13g2_decap_8
X_19147_ _23123_/D _23123_/Q _19017_/A _19149_/S VPWR VGND sg13g2_mux2_1
X_16359_ _16359_/Y _22748_/Q _16364_/B VPWR VGND sg13g2_nand2_1
XFILLER_105_1877 VPWR VGND sg13g2_decap_8
XFILLER_34_1197 VPWR VGND sg13g2_fill_1
XFILLER_67_0 VPWR VGND sg13g2_decap_8
X_19078_ _23075_/D _23075_/Q _19077_/X _19078_/S VPWR VGND sg13g2_mux2_1
XFILLER_86_1530 VPWR VGND sg13g2_fill_1
XFILLER_12_1473 VPWR VGND sg13g2_decap_8
X_18029_ _18030_/B _19116_/A1 _23030_/Q _18029_/S VPWR VGND sg13g2_mux2_1
Xhold4705 _21957_/A _23973_/Q VPWR VGND sg13g2_dlygate4sd3_1
Xhold4716 _17362_/A _22808_/Q VPWR VGND sg13g2_dlygate4sd3_1
Xhold4727 _20807_/A _23453_/Q VPWR VGND sg13g2_dlygate4sd3_1
Xhold4738 _20934_/A _23513_/Q VPWR VGND sg13g2_dlygate4sd3_1
XFILLER_47_1525 VPWR VGND sg13g2_fill_2
Xhold4749 _20997_/A _23541_/Q VPWR VGND sg13g2_dlygate4sd3_1
XFILLER_5_70 VPWR VGND sg13g2_fill_1
XFILLER_47_1536 VPWR VGND sg13g2_decap_4
XFILLER_113_352 VPWR VGND sg13g2_fill_1
XFILLER_114_886 VPWR VGND sg13g2_decap_8
XFILLER_114_897 VPWR VGND sg13g2_fill_2
XFILLER_99_586 VPWR VGND sg13g2_decap_8
XFILLER_25_1801 VPWR VGND sg13g2_decap_8
XFILLER_25_1812 VPWR VGND sg13g2_fill_1
XFILLER_59_428 VPWR VGND sg13g2_fill_2
XFILLER_64_1861 VPWR VGND sg13g2_decap_8
XFILLER_60_1703 VPWR VGND sg13g2_decap_8
XFILLER_115_49 VPWR VGND sg13g2_decap_8
XFILLER_87_759 VPWR VGND sg13g2_fill_1
XFILLER_45_1260 VPWR VGND sg13g2_decap_8
XFILLER_80_1151 VPWR VGND sg13g2_decap_8
XFILLER_101_558 VPWR VGND sg13g2_decap_8
XFILLER_5_1917 VPWR VGND sg13g2_decap_8
XFILLER_25_1867 VPWR VGND sg13g2_fill_2
XFILLER_112_1826 VPWR VGND sg13g2_decap_8
XFILLER_25_1878 VPWR VGND sg13g2_decap_4
X_22991_ _22991_/Q _23187_/CLK _22991_/D fanout2917/X VPWR VGND sg13g2_dfrbpq_1
XFILLER_60_1758 VPWR VGND sg13g2_decap_8
XFILLER_39_152 VPWR VGND sg13g2_fill_1
XFILLER_68_984 VPWR VGND sg13g2_fill_2
XFILLER_41_1157 VPWR VGND sg13g2_decap_8
XFILLER_55_623 VPWR VGND sg13g2_decap_8
X_21942_ _21942_/Y _23966_/Q _21942_/B VPWR VGND sg13g2_nand2_1
XFILLER_3_1630 VPWR VGND sg13g2_decap_8
XFILLER_54_111 VPWR VGND sg13g2_fill_2
XFILLER_94_291 VPWR VGND sg13g2_decap_4
XFILLER_110_1583 VPWR VGND sg13g2_decap_8
X_23612_ _23612_/Q clkload53/A _23612_/D fanout2782/X VPWR VGND sg13g2_dfrbpq_1
X_20824_ _23460_/D _21327_/A1 _20827_/B _20823_/Y VPWR VGND sg13g2_o21ai_1
XFILLER_42_328 VPWR VGND sg13g2_decap_8
XFILLER_93_1534 VPWR VGND sg13g2_decap_4
XFILLER_39_1042 VPWR VGND sg13g2_fill_1
XFILLER_58_1665 VPWR VGND sg13g2_fill_1
XFILLER_39_1053 VPWR VGND sg13g2_decap_8
XFILLER_54_1507 VPWR VGND sg13g2_fill_2
X_23543_ _23543_/Q clkload46/A _23543_/D fanout2686/X VPWR VGND sg13g2_dfrbpq_1
X_20755_ _23427_/D _21325_/A1 _20768_/B _20754_/Y VPWR VGND sg13g2_o21ai_1
XFILLER_51_862 VPWR VGND sg13g2_fill_1
XFILLER_50_350 VPWR VGND sg13g2_fill_2
XFILLER_71_1821 VPWR VGND sg13g2_decap_4
XFILLER_23_586 VPWR VGND sg13g2_fill_2
X_23474_ _23474_/Q _24210_/CLK _23474_/D fanout2623/X VPWR VGND sg13g2_dfrbpq_1
X_20686_ _20686_/Y _23396_/Q _20690_/B VPWR VGND sg13g2_nand2_1
XFILLER_11_759 VPWR VGND sg13g2_decap_8
X_22425_ _24197_/D _22425_/A1 _22424_/B _22424_/Y VPWR VGND sg13g2_o21ai_1
XFILLER_17_1395 VPWR VGND sg13g2_decap_8
XFILLER_32_1849 VPWR VGND sg13g2_fill_2
XFILLER_109_636 VPWR VGND sg13g2_decap_8
XFILLER_104_1354 VPWR VGND sg13g2_fill_2
XFILLER_104_1365 VPWR VGND sg13g2_fill_1
X_22356_ _24164_/D _22356_/A1 _22359_/B _22355_/Y VPWR VGND sg13g2_o21ai_1
XFILLER_108_168 VPWR VGND sg13g2_decap_8
XFILLER_87_1349 VPWR VGND sg13g2_decap_8
X_21307_ _23675_/D _21307_/A1 _21313_/B _21306_/Y VPWR VGND sg13g2_o21ai_1
XFILLER_3_925 VPWR VGND sg13g2_decap_8
X_22287_ _22287_/Y _22287_/A _22300_/B VPWR VGND sg13g2_nand2_1
X_24026_ _24026_/Q clkload48/A _24026_/D fanout2686/X VPWR VGND sg13g2_dfrbpq_1
X_21238_ _21238_/Y _23642_/Q _21242_/B VPWR VGND sg13g2_nand2_1
XFILLER_49_21 VPWR VGND sg13g2_decap_8
X_21169_ _21169_/Y _21169_/A _21179_/B VPWR VGND sg13g2_nand2_1
XFILLER_77_247 VPWR VGND sg13g2_fill_1
Xclkbuf_leaf_60_clk_i clkload12/A clkbuf_4_2__f_clk_i/X VPWR VGND sg13g2_buf_16
XFILLER_1_28 VPWR VGND sg13g2_decap_8
X_13991_ _14104_/B _20355_/B _20356_/A VPWR VGND sg13g2_nor2_1
XFILLER_63_1393 VPWR VGND sg13g2_decap_8
XFILLER_92_206 VPWR VGND sg13g2_decap_8
XFILLER_115_1483 VPWR VGND sg13g2_decap_8
XFILLER_24_1366 VPWR VGND sg13g2_fill_1
XFILLER_46_612 VPWR VGND sg13g2_decap_4
XFILLER_59_995 VPWR VGND sg13g2_decap_4
XFILLER_4_1438 VPWR VGND sg13g2_decap_4
XFILLER_20_1208 VPWR VGND sg13g2_decap_8
X_15730_ _15734_/C _22469_/Q _15900_/A2 _15992_/B1 _22800_/Q VPWR VGND sg13g2_a22oi_1
X_12942_ _12942_/X _13503_/B _13503_/A _13526_/D VPWR VGND sg13g2_a21o_1
XFILLER_24_1388 VPWR VGND sg13g2_decap_4
XFILLER_24_1399 VPWR VGND sg13g2_decap_4
X_15661_ _15665_/A _15661_/A _15661_/B VPWR VGND sg13g2_nand2_1
XFILLER_59_1429 VPWR VGND sg13g2_fill_2
X_12873_ _12873_/X _12873_/A _12873_/B VPWR VGND sg13g2_or2_1
XFILLER_92_1000 VPWR VGND sg13g2_decap_8
X_14612_ _14612_/Y _14599_/C _14612_/B VPWR VGND sg13g2_nand2b_1
XFILLER_57_1120 VPWR VGND sg13g2_decap_4
XFILLER_61_637 VPWR VGND sg13g2_fill_1
X_18380_ _18381_/B _18380_/A _18380_/B VPWR VGND sg13g2_nand2_1
XFILLER_60_114 VPWR VGND sg13g2_decap_8
X_11824_ _11824_/Y _12285_/A _12166_/B VPWR VGND sg13g2_nor2b_1
X_15592_ _15593_/A _22632_/Q _16774_/D _17056_/C _22696_/Q VPWR VGND sg13g2_a22oi_1
XFILLER_57_1131 VPWR VGND sg13g2_fill_1
XFILLER_60_125 VPWR VGND sg13g2_fill_1
XFILLER_61_648 VPWR VGND sg13g2_fill_1
X_17331_ _17331_/Y _17331_/A _17351_/B VPWR VGND sg13g2_nand2_1
XFILLER_92_1055 VPWR VGND sg13g2_decap_4
XFILLER_81_41 VPWR VGND sg13g2_fill_2
XFILLER_18_1126 VPWR VGND sg13g2_fill_1
XFILLER_57_1175 VPWR VGND sg13g2_decap_8
X_11755_ _11755_/Y _23320_/Q _11755_/B VPWR VGND sg13g2_nand2b_1
XFILLER_57_1186 VPWR VGND sg13g2_decap_8
XFILLER_14_586 VPWR VGND sg13g2_decap_8
X_17262_ _17262_/Y _17262_/A _17262_/B VPWR VGND sg13g2_nand2_1
X_14474_ _14474_/Y _24226_/Q _18803_/A VPWR VGND sg13g2_nor2_1
X_11686_ _11687_/B _24184_/Q _23320_/Q _11699_/S VPWR VGND sg13g2_mux2_1
X_19001_ _19002_/C _23057_/Q _19045_/B _19001_/C VPWR VGND sg13g2_or3_1
XFILLER_35_1462 VPWR VGND sg13g2_fill_2
X_16213_ _22514_/D _16213_/A _16241_/C VPWR VGND sg13g2_xnor2_1
XFILLER_50_1927 VPWR VGND sg13g2_decap_4
X_13425_ _13425_/Y _23564_/Q _13975_/A2 _13424_/X _13582_/A _13686_/A VPWR VGND sg13g2_a221oi_1
X_17193_ _22741_/D _17197_/B _17191_/Y _17192_/Y VPWR VGND sg13g2_a21oi_1
XFILLER_60_7 VPWR VGND sg13g2_decap_4
X_13356_ _13356_/Y _13528_/A _13356_/B _13356_/C _13356_/D VPWR VGND sg13g2_nor4_1
Xclkbuf_leaf_13_clk_i clkload20/A clkbuf_leaf_6_clk_i/A VPWR VGND sg13g2_buf_16
XFILLER_115_628 VPWR VGND sg13g2_decap_8
XFILLER_114_105 VPWR VGND sg13g2_decap_8
X_12307_ _12307_/X _23710_/Q _23774_/Q _23838_/Q _23934_/Q _12193_/S _12015_/S VPWR
+ VGND sg13g2_mux4_1
X_16075_ _16075_/Y _17858_/A _16075_/B VPWR VGND sg13g2_nor2_1
XFILLER_108_680 VPWR VGND sg13g2_fill_1
X_13287_ _13287_/Y _14030_/A _20179_/B VPWR VGND sg13g2_xnor2_1
X_19903_ _19903_/Y _19903_/A _19903_/B VPWR VGND sg13g2_nand2_1
X_15026_ _15028_/B _22473_/Q _14874_/B _15066_/B1 _22932_/Q VPWR VGND sg13g2_a22oi_1
X_12238_ _12241_/C _12247_/A _12238_/B VPWR VGND sg13g2_nor2_1
XFILLER_48_1878 VPWR VGND sg13g2_decap_8
XFILLER_69_726 VPWR VGND sg13g2_decap_4
XFILLER_25_1108 VPWR VGND sg13g2_fill_2
X_19834_ _20263_/B _19663_/A _19936_/B _19543_/Y VPWR VGND sg13g2_o21ai_1
X_12169_ _12169_/Y _11921_/A _12159_/X _12163_/Y _12168_/Y _12175_/B VPWR VGND sg13g2_a221oi_1
XFILLER_110_311 VPWR VGND sg13g2_fill_1
XFILLER_68_225 VPWR VGND sg13g2_fill_2
Xclkbuf_leaf_28_clk_i _24113_/CLK clkload3/A VPWR VGND sg13g2_buf_16
XFILLER_111_856 VPWR VGND sg13g2_decap_8
XFILLER_96_578 VPWR VGND sg13g2_decap_8
X_19765_ _20294_/B _19764_/A _19759_/Y _19764_/Y VPWR VGND sg13g2_o21ai_1
X_16977_ _16977_/Y _22705_/Q _16977_/B VPWR VGND sg13g2_xnor2_1
XFILLER_110_388 VPWR VGND sg13g2_decap_8
XFILLER_49_472 VPWR VGND sg13g2_decap_8
X_18716_ _18716_/Y _18729_/A _18723_/B _14990_/B VPWR VGND sg13g2_o21ai_1
X_15928_ _15929_/C _15928_/A _15928_/B _15928_/C VPWR VGND sg13g2_nand3_1
XFILLER_77_792 VPWR VGND sg13g2_fill_1
X_19696_ _19696_/Y _19574_/B _19696_/B VPWR VGND sg13g2_nand2b_1
XFILLER_42_1488 VPWR VGND sg13g2_decap_4
XFILLER_65_954 VPWR VGND sg13g2_fill_1
XFILLER_92_751 VPWR VGND sg13g2_decap_8
X_18647_ _23007_/D _18651_/B _18646_/Y _14899_/A VPWR VGND sg13g2_a21oi_1
XFILLER_36_155 VPWR VGND sg13g2_fill_1
X_15859_ _15864_/B _15944_/A _15859_/B VPWR VGND sg13g2_or2_1
XFILLER_25_829 VPWR VGND sg13g2_decap_8
XFILLER_65_998 VPWR VGND sg13g2_decap_8
XFILLER_111_1892 VPWR VGND sg13g2_decap_8
XFILLER_52_626 VPWR VGND sg13g2_decap_8
X_18578_ _18585_/B _18575_/Y _18576_/Y _18780_/S VPWR VGND sg13g2_mux2_1
XFILLER_52_648 VPWR VGND sg13g2_decap_8
XFILLER_75_1231 VPWR VGND sg13g2_decap_4
XFILLER_0_1869 VPWR VGND sg13g2_decap_4
XFILLER_17_391 VPWR VGND sg13g2_decap_8
XFILLER_51_147 VPWR VGND sg13g2_decap_4
XFILLER_94_1887 VPWR VGND sg13g2_decap_8
X_17529_ _17529_/Y _15375_/Y _17528_/B _17528_/Y VPWR VGND sg13g2_o21ai_1
X_20540_ _23326_/D _22409_/A1 _20539_/B _20539_/Y VPWR VGND sg13g2_o21ai_1
Xrebuffer5502 _11319_/A2 _11314_/A VPWR VGND sg13g2_buf_1
Xrebuffer5513 _11257_/B _11315_/D VPWR VGND sg13g2_buf_1
Xplace3800 _18564_/A1 _18198_/X VPWR VGND sg13g2_buf_1
Xrebuffer5524 rebuffer5524/X rebuffer5525/X VPWR VGND sg13g2_buf_1
Xrebuffer5535 rebuffer5535/X rebuffer5536/X VPWR VGND sg13g2_buf_1
Xplace3811 _15956_/B _16023_/B VPWR VGND sg13g2_buf_1
XFILLER_105_1652 VPWR VGND sg13g2_decap_4
XFILLER_14_1535 VPWR VGND sg13g2_fill_1
Xplace3822 _18301_/B _18144_/Y VPWR VGND sg13g2_buf_1
X_20471_ _20471_/Y _20471_/A _20473_/B VPWR VGND sg13g2_nand2_1
Xrebuffer5546 rebuffer5546/X rebuffer5547/X VPWR VGND sg13g2_buf_1
Xrebuffer5557 _16253_/A _14890_/Y VPWR VGND sg13g2_buf_1
Xplace3833 _15930_/A _15905_/A VPWR VGND sg13g2_buf_1
XFILLER_88_1614 VPWR VGND sg13g2_fill_2
XFILLER_14_1568 VPWR VGND sg13g2_decap_8
Xrebuffer5568 _12859_/C _12529_/Y VPWR VGND sg13g2_buf_1
X_22210_ _22210_/Y _22210_/A _22210_/B VPWR VGND sg13g2_nand2_1
Xplace3844 _13123_/A place3844/A VPWR VGND sg13g2_buf_2
Xplace3855 _17822_/B1 _17815_/B1 VPWR VGND sg13g2_buf_1
XFILLER_14_1579 VPWR VGND sg13g2_fill_2
X_23190_ _23190_/Q _24214_/CLK _23190_/D fanout2928/X VPWR VGND sg13g2_dfrbpq_1
Xplace3866 _13858_/A _13383_/A VPWR VGND sg13g2_buf_1
Xhold5203 _20633_/A _23371_/Q VPWR VGND sg13g2_dlygate4sd3_1
Xplace3877 _13968_/B _11234_/X VPWR VGND sg13g2_buf_1
Xplace3888 _19141_/S _19134_/S VPWR VGND sg13g2_buf_1
XFILLER_105_105 VPWR VGND sg13g2_decap_8
Xplace3899 _18399_/A _18504_/A VPWR VGND sg13g2_buf_1
X_22141_ _24061_/D _19921_/Y _22142_/B _22140_/Y VPWR VGND sg13g2_o21ai_1
XFILLER_12_1292 VPWR VGND sg13g2_fill_1
XFILLER_10_48 VPWR VGND sg13g2_fill_1
XFILLER_82_1202 VPWR VGND sg13g2_fill_1
X_22072_ _24028_/D _22272_/A1 _22065_/B _22071_/Y VPWR VGND sg13g2_o21ai_1
XFILLER_47_1333 VPWR VGND sg13g2_fill_2
XFILLER_82_1224 VPWR VGND sg13g2_decap_4
XFILLER_27_1918 VPWR VGND sg13g2_decap_8
XFILLER_0_928 VPWR VGND sg13g2_fill_1
X_21023_ _23549_/D _19921_/Y _21029_/B _21022_/Y VPWR VGND sg13g2_o21ai_1
XFILLER_114_683 VPWR VGND sg13g2_decap_8
XFILLER_102_823 VPWR VGND sg13g2_fill_1
XFILLER_87_523 VPWR VGND sg13g2_fill_1
XFILLER_102_834 VPWR VGND sg13g2_decap_8
XFILLER_82_1268 VPWR VGND sg13g2_fill_2
XFILLER_9_1850 VPWR VGND sg13g2_decap_8
XFILLER_113_182 VPWR VGND sg13g2_decap_8
XFILLER_102_856 VPWR VGND sg13g2_fill_1
XFILLER_60_1511 VPWR VGND sg13g2_decap_4
XFILLER_19_35 VPWR VGND sg13g2_decap_8
XFILLER_101_355 VPWR VGND sg13g2_decap_4
XFILLER_5_1714 VPWR VGND sg13g2_decap_8
XFILLER_87_589 VPWR VGND sg13g2_decap_4
XFILLER_19_46 VPWR VGND sg13g2_fill_2
XFILLER_75_729 VPWR VGND sg13g2_fill_2
XFILLER_25_1675 VPWR VGND sg13g2_decap_8
XFILLER_112_1634 VPWR VGND sg13g2_fill_2
XFILLER_101_388 VPWR VGND sg13g2_fill_1
XFILLER_99_1743 VPWR VGND sg13g2_decap_4
XFILLER_27_100 VPWR VGND sg13g2_decap_4
XFILLER_27_111 VPWR VGND sg13g2_decap_8
X_22974_ _22974_/Q clkload29/A _22974_/D fanout2935/X VPWR VGND sg13g2_dfrbpq_1
XFILLER_112_1656 VPWR VGND sg13g2_fill_2
XFILLER_83_740 VPWR VGND sg13g2_decap_4
XFILLER_27_122 VPWR VGND sg13g2_fill_2
XFILLER_28_645 VPWR VGND sg13g2_fill_2
XFILLER_55_431 VPWR VGND sg13g2_decap_8
XFILLER_60_1599 VPWR VGND sg13g2_decap_4
XFILLER_99_1787 VPWR VGND sg13g2_decap_8
XFILLER_95_1618 VPWR VGND sg13g2_fill_2
XFILLER_27_144 VPWR VGND sg13g2_decap_8
XFILLER_55_453 VPWR VGND sg13g2_decap_8
X_21925_ _21925_/Y _23958_/Q _21935_/B VPWR VGND sg13g2_nand2_1
XFILLER_112_1689 VPWR VGND sg13g2_decap_8
XFILLER_71_913 VPWR VGND sg13g2_fill_2
XFILLER_76_1017 VPWR VGND sg13g2_decap_4
XFILLER_27_177 VPWR VGND sg13g2_fill_1
XFILLER_35_34 VPWR VGND sg13g2_fill_2
Xinput4401 _20343_/A0 data_rdata_i[30] VPWR VGND sg13g2_buf_1
XFILLER_15_339 VPWR VGND sg13g2_decap_8
Xinput4412 _11171_/A fetch_enable_i VPWR VGND sg13g2_buf_1
XFILLER_70_423 VPWR VGND sg13g2_decap_8
Xinput4423 _18884_/A instr_rdata_i[17] VPWR VGND sg13g2_buf_1
XFILLER_42_125 VPWR VGND sg13g2_fill_2
Xinput4434 _18995_/A instr_rdata_i[27] VPWR VGND sg13g2_buf_1
XFILLER_42_147 VPWR VGND sg13g2_decap_8
Xinput4445 _19124_/A1 instr_rdata_i[8] VPWR VGND sg13g2_buf_1
XFILLER_58_1473 VPWR VGND sg13g2_decap_4
X_20807_ _20807_/Y _20807_/A _20809_/B VPWR VGND sg13g2_nand2_1
Xinput4456 _14215_/A irqs_i[2] VPWR VGND sg13g2_buf_1
XFILLER_24_873 VPWR VGND sg13g2_fill_1
XFILLER_106_1405 VPWR VGND sg13g2_decap_8
XFILLER_24_884 VPWR VGND sg13g2_fill_2
XFILLER_54_1348 VPWR VGND sg13g2_fill_1
X_11540_ _11541_/B _24149_/Q _24181_/Q _23221_/Q _23253_/Q _11923_/S0 _12171_/S1 VPWR
+ VGND sg13g2_mux4_1
X_23526_ _23526_/Q clkload42/A _23526_/D fanout2720/X VPWR VGND sg13g2_dfrbpq_1
XFILLER_11_523 VPWR VGND sg13g2_fill_2
XFILLER_23_383 VPWR VGND sg13g2_fill_2
X_20738_ _20738_/Y _23420_/Q _20738_/B VPWR VGND sg13g2_nand2_1
XFILLER_36_1760 VPWR VGND sg13g2_decap_8
XFILLER_50_180 VPWR VGND sg13g2_decap_8
XFILLER_71_1640 VPWR VGND sg13g2_fill_1
XFILLER_17_1170 VPWR VGND sg13g2_fill_2
X_11471_ _11471_/Y _11706_/S _23414_/Q _11470_/Y VPWR VGND sg13g2_o21ai_1
X_20669_ _23388_/D _22405_/A1 _20673_/B _20668_/Y VPWR VGND sg13g2_o21ai_1
X_23457_ _23457_/Q _23682_/CLK _23457_/D fanout2726/X VPWR VGND sg13g2_dfrbpq_1
XFILLER_52_1083 VPWR VGND sg13g2_fill_1
X_13210_ _13215_/B _13210_/A _13210_/B VPWR VGND sg13g2_nor2_1
XFILLER_10_1900 VPWR VGND sg13g2_decap_8
X_22408_ _22408_/Y _24190_/Q _22408_/B VPWR VGND sg13g2_nand2_1
XFILLER_104_1173 VPWR VGND sg13g2_decap_8
X_14190_ _14786_/B _24236_/Q _24237_/Q _24235_/Q VPWR VGND sg13g2_nor3_1
X_23388_ _23388_/Q clkload55/A _23388_/D fanout2772/X VPWR VGND sg13g2_dfrbpq_1
XFILLER_13_1067 VPWR VGND sg13g2_decap_8
XFILLER_87_1146 VPWR VGND sg13g2_decap_8
X_13141_ _13143_/B _14144_/C _13141_/B VPWR VGND sg13g2_nand2b_1
X_22339_ _22339_/Y _22339_/A _22341_/B VPWR VGND sg13g2_nand2_1
X_13072_ _13072_/Y _13072_/A _13072_/B VPWR VGND sg13g2_nand2_1
XFILLER_3_777 VPWR VGND sg13g2_decap_8
XFILLER_78_501 VPWR VGND sg13g2_fill_2
X_16900_ _16900_/Y _17087_/A _17032_/B VPWR VGND sg13g2_nand2_1
X_12023_ _12026_/C _12788_/B _12023_/B VPWR VGND sg13g2_nor2_1
XFILLER_3_788 VPWR VGND sg13g2_fill_2
XFILLER_111_119 VPWR VGND sg13g2_decap_8
XFILLER_105_683 VPWR VGND sg13g2_decap_4
X_24009_ _24009_/Q _24205_/CLK _24009_/D fanout2671/X VPWR VGND sg13g2_dfrbpq_1
XFILLER_78_523 VPWR VGND sg13g2_decap_8
XFILLER_26_1417 VPWR VGND sg13g2_decap_8
X_17880_ _22924_/D _17880_/A VPWR VGND sg13g2_inv_1
XFILLER_104_171 VPWR VGND sg13g2_fill_1
XFILLER_43_1720 VPWR VGND sg13g2_decap_8
XFILLER_43_1731 VPWR VGND sg13g2_fill_1
X_16831_ _22678_/D _16504_/Y _16774_/Y _16830_/Y VPWR VGND sg13g2_o21ai_1
XFILLER_38_409 VPWR VGND sg13g2_fill_2
XFILLER_24_1141 VPWR VGND sg13g2_decap_4
XFILLER_65_206 VPWR VGND sg13g2_fill_1
X_19550_ _19550_/Y _19549_/X _19712_/B VPWR VGND sg13g2_nand2b_1
X_16762_ _16763_/B _22667_/Q _16770_/D VPWR VGND sg13g2_nand2_1
X_13974_ _13974_/X _24052_/Q _24084_/Q _13974_/S VPWR VGND sg13g2_mux2_1
XFILLER_47_943 VPWR VGND sg13g2_decap_8
XFILLER_111_1133 VPWR VGND sg13g2_decap_4
XFILLER_78_1816 VPWR VGND sg13g2_fill_2
XFILLER_20_1027 VPWR VGND sg13g2_fill_2
X_18501_ _18501_/X _17977_/A _18498_/C _18501_/S VPWR VGND sg13g2_mux2_1
XFILLER_18_133 VPWR VGND sg13g2_fill_1
XFILLER_47_976 VPWR VGND sg13g2_decap_4
X_15713_ _15713_/Y _15930_/A _20140_/A VPWR VGND sg13g2_nor2_1
X_12925_ _12925_/X _12912_/Y _13008_/B _12924_/Y VPWR VGND sg13g2_a21o_2
X_16693_ _22653_/D _16043_/A _16711_/A _16692_/Y VPWR VGND sg13g2_a21oi_1
XFILLER_94_1106 VPWR VGND sg13g2_decap_8
XFILLER_73_250 VPWR VGND sg13g2_decap_4
XFILLER_74_773 VPWR VGND sg13g2_decap_4
XFILLER_111_1188 VPWR VGND sg13g2_decap_8
X_18432_ _18432_/Y _18432_/A _18432_/B VPWR VGND sg13g2_nand2_1
XFILLER_46_497 VPWR VGND sg13g2_fill_2
X_15644_ _15644_/Y _22924_/Q _15552_/B _15986_/C1 VPWR VGND sg13g2_a21oi_1
XFILLER_76_1540 VPWR VGND sg13g2_decap_8
XFILLER_37_1502 VPWR VGND sg13g2_decap_4
X_11807_ _11812_/B _13210_/A _11807_/B VPWR VGND sg13g2_nor2_1
XFILLER_15_862 VPWR VGND sg13g2_fill_1
X_18363_ _18363_/Y _18363_/A _18363_/B VPWR VGND sg13g2_nor2_1
XFILLER_33_158 VPWR VGND sg13g2_decap_4
XFILLER_76_1573 VPWR VGND sg13g2_decap_8
X_15575_ _15578_/C _22462_/Q _15575_/B VPWR VGND sg13g2_nand2_1
XFILLER_15_873 VPWR VGND sg13g2_decap_8
XFILLER_72_1415 VPWR VGND sg13g2_decap_4
X_12787_ _12788_/C _24036_/Q _24100_/Q _12789_/S VPWR VGND sg13g2_mux2_1
XFILLER_42_670 VPWR VGND sg13g2_fill_2
XFILLER_30_821 VPWR VGND sg13g2_fill_2
X_17314_ _22785_/D _16054_/A _17351_/B _17313_/Y VPWR VGND sg13g2_o21ai_1
XFILLER_14_383 VPWR VGND sg13g2_decap_8
XFILLER_30_832 VPWR VGND sg13g2_decap_8
X_14526_ _14527_/B _14263_/A _14596_/C _14596_/B VPWR VGND sg13g2_a21oi_1
XFILLER_109_1073 VPWR VGND sg13g2_fill_2
X_11738_ _11738_/Y _23544_/Q _13911_/A2 _11737_/X _11920_/C1 _13774_/A VPWR VGND sg13g2_a221oi_1
X_18294_ _18294_/Y _18458_/B VPWR VGND sg13g2_inv_1
XFILLER_15_1822 VPWR VGND sg13g2_decap_8
XFILLER_54_1882 VPWR VGND sg13g2_fill_2
Xplace3107 _21352_/S _21353_/B VPWR VGND sg13g2_buf_1
XFILLER_30_876 VPWR VGND sg13g2_decap_4
X_17245_ _22753_/D _16054_/A _17266_/B _17244_/Y VPWR VGND sg13g2_o21ai_1
XFILLER_70_1150 VPWR VGND sg13g2_fill_1
X_14457_ _14572_/A _14444_/X _16681_/A _14596_/C VPWR VGND sg13g2_a21o_1
Xplace3118 _21234_/B _21287_/B VPWR VGND sg13g2_buf_1
X_11669_ _11669_/Y _11867_/C _11867_/A _11867_/B _11867_/D VPWR VGND sg13g2_nand4_1
Xplace3129 _21051_/B _21079_/B VPWR VGND sg13g2_buf_1
XFILLER_70_1172 VPWR VGND sg13g2_decap_8
XFILLER_89_1934 VPWR VGND sg13g2_decap_8
X_13408_ _13408_/X _23852_/Q _23884_/Q _23948_/Q _23980_/Q _13586_/A1 _12050_/C VPWR
+ VGND sg13g2_mux4_1
X_17176_ _22738_/D _17209_/B _17174_/Y _17175_/Y VPWR VGND sg13g2_a21oi_1
XFILLER_15_1899 VPWR VGND sg13g2_decap_8
X_14388_ _14388_/Y _22748_/Q _14387_/B _19928_/B VPWR VGND sg13g2_a21oi_1
X_16127_ _22498_/D _16177_/B _16125_/Y _16126_/Y VPWR VGND sg13g2_o21ai_1
XFILLER_115_425 VPWR VGND sg13g2_decap_8
X_13339_ _13339_/X _23435_/Q _23467_/Q _23499_/Q _23531_/Q _13707_/S0 _13251_/B VPWR
+ VGND sg13g2_mux4_1
XFILLER_100_1560 VPWR VGND sg13g2_fill_2
XFILLER_48_1620 VPWR VGND sg13g2_fill_1
XFILLER_88_309 VPWR VGND sg13g2_fill_1
XFILLER_83_1522 VPWR VGND sg13g2_decap_8
X_16058_ _16058_/Y _16058_/A _16075_/B VPWR VGND sg13g2_nor2_1
XFILLER_83_1533 VPWR VGND sg13g2_fill_2
XFILLER_97_810 VPWR VGND sg13g2_fill_2
X_15009_ _15010_/B _17896_/A1 _15029_/B _18679_/A2 _15009_/B2 _15008_/Y VPWR VGND
+ sg13g2_a221oi_1
XFILLER_9_1124 VPWR VGND sg13g2_decap_8
XFILLER_44_1506 VPWR VGND sg13g2_fill_2
XFILLER_48_1675 VPWR VGND sg13g2_decap_8
XFILLER_9_1135 VPWR VGND sg13g2_fill_2
XFILLER_29_1063 VPWR VGND sg13g2_fill_2
XFILLER_29_1085 VPWR VGND sg13g2_fill_2
XFILLER_69_556 VPWR VGND sg13g2_decap_8
XFILLER_111_653 VPWR VGND sg13g2_decap_8
Xfanout2780 fanout2780/X fanout2791/X VPWR VGND sg13g2_buf_1
X_19817_ _19817_/Y _20329_/B2 _19808_/Y _19816_/Y VPWR VGND sg13g2_a21oi_1
Xfanout2791 fanout2791/X fanout2792/X VPWR VGND sg13g2_buf_1
XFILLER_61_1864 VPWR VGND sg13g2_decap_8
X_19748_ _19748_/Y _20284_/A2 _19514_/Y _19744_/Y _20154_/S1 VPWR VGND sg13g2_a22oi_1
XFILLER_61_1886 VPWR VGND sg13g2_fill_1
XFILLER_110_196 VPWR VGND sg13g2_decap_8
XFILLER_84_559 VPWR VGND sg13g2_fill_2
XFILLER_42_1285 VPWR VGND sg13g2_fill_2
XFILLER_53_902 VPWR VGND sg13g2_decap_8
XFILLER_112_28 VPWR VGND sg13g2_decap_8
XFILLER_71_209 VPWR VGND sg13g2_fill_1
XFILLER_80_710 VPWR VGND sg13g2_decap_8
XFILLER_92_581 VPWR VGND sg13g2_decap_8
X_21710_ _21710_/Y _23865_/Q _21725_/B VPWR VGND sg13g2_nand2_1
XFILLER_92_592 VPWR VGND sg13g2_fill_1
X_22690_ _22690_/Q clkload23/A _22690_/D fanout2888/X VPWR VGND sg13g2_dfrbpq_1
XFILLER_94_1640 VPWR VGND sg13g2_decap_8
XFILLER_94_1662 VPWR VGND sg13g2_fill_1
X_21641_ _23834_/D _21934_/A1 _21642_/B _21640_/Y VPWR VGND sg13g2_o21ai_1
XFILLER_94_1684 VPWR VGND sg13g2_decap_8
XFILLER_40_629 VPWR VGND sg13g2_decap_8
XFILLER_52_489 VPWR VGND sg13g2_fill_2
XFILLER_94_1695 VPWR VGND sg13g2_fill_1
XFILLER_21_810 VPWR VGND sg13g2_decap_4
XFILLER_36_1045 VPWR VGND sg13g2_decap_8
X_21572_ _21572_/Y _21572_/A _21572_/B VPWR VGND sg13g2_nand2_1
XFILLER_32_180 VPWR VGND sg13g2_decap_4
Xplace4320 _12235_/S _12239_/S VPWR VGND sg13g2_buf_2
Xplace4331 _11755_/B place4331/A VPWR VGND sg13g2_buf_2
Xrebuffer5310 _14086_/A1 _11559_/Y VPWR VGND sg13g2_buf_1
X_23311_ _23311_/Q clkload31/A _23311_/D fanout2646/X VPWR VGND sg13g2_dfrbpq_1
X_20523_ _23318_/D _19628_/Y _20533_/B _20522_/Y VPWR VGND sg13g2_o21ai_1
Xrebuffer5321 _18630_/B _18742_/B VPWR VGND sg13g2_buf_1
XFILLER_33_1944 VPWR VGND sg13g2_decap_8
Xplace4342 _11311_/A _22970_/Q VPWR VGND sg13g2_buf_1
Xrebuffer5332 _13513_/A1 _13433_/A VPWR VGND sg13g2_buf_1
Xrebuffer5343 _13616_/A _11754_/B1 VPWR VGND sg13g2_buf_1
Xrebuffer5354 _11724_/B1 _11484_/X VPWR VGND sg13g2_buf_1
Xplace3630 _15946_/B1 _15662_/B1 VPWR VGND sg13g2_buf_1
XFILLER_21_14 VPWR VGND sg13g2_fill_2
XFILLER_14_1354 VPWR VGND sg13g2_fill_2
Xplace3641 _14642_/B _14720_/B VPWR VGND sg13g2_buf_1
XFILLER_20_397 VPWR VGND sg13g2_fill_1
Xrebuffer4620 _12849_/B _12507_/Y VPWR VGND sg13g2_buf_2
XFILLER_101_1313 VPWR VGND sg13g2_decap_8
Xrebuffer5365 place4331/A _12453_/S VPWR VGND sg13g2_buf_1
XFILLER_14_1365 VPWR VGND sg13g2_fill_2
X_23242_ _23242_/Q clkload34/A _23242_/D fanout2697/X VPWR VGND sg13g2_dfrbpq_1
X_20454_ _20454_/Y _23289_/Q _20464_/B VPWR VGND sg13g2_nand2_1
XFILLER_107_915 VPWR VGND sg13g2_decap_8
Xplace3652 _17382_/A _17670_/A2 VPWR VGND sg13g2_buf_1
Xrebuffer5376 _12506_/B _12505_/Y VPWR VGND sg13g2_buf_8
Xrebuffer4631 _20334_/A _13935_/Y VPWR VGND sg13g2_buf_1
Xhold5000 _21989_/A _23989_/Q VPWR VGND sg13g2_dlygate4sd3_1
Xplace3663 _16132_/B _16209_/B VPWR VGND sg13g2_buf_1
Xrebuffer5387 _12539_/A1 _12623_/A VPWR VGND sg13g2_buf_1
XFILLER_107_926 VPWR VGND sg13g2_fill_2
Xhold5011 _20754_/A _23427_/Q VPWR VGND sg13g2_dlygate4sd3_1
XFILLER_10_1229 VPWR VGND sg13g2_fill_1
Xplace3674 _15029_/B _14936_/B VPWR VGND sg13g2_buf_1
Xplace2940 _22258_/A1 _21295_/A1 VPWR VGND sg13g2_buf_1
XFILLER_101_1346 VPWR VGND sg13g2_decap_8
Xplace3685 _15906_/A _13734_/A VPWR VGND sg13g2_buf_2
XFILLER_101_1357 VPWR VGND sg13g2_fill_1
Xhold5022 _22067_/A _24026_/Q VPWR VGND sg13g2_dlygate4sd3_1
Xplace3696 _15066_/B1 _14885_/Y VPWR VGND sg13g2_buf_1
Xplace2951 _18827_/B _18865_/B VPWR VGND sg13g2_buf_1
X_23173_ _23173_/Q _23187_/CLK _23173_/D fanout2918/X VPWR VGND sg13g2_dfrbpq_1
XFILLER_84_1308 VPWR VGND sg13g2_fill_2
Xplace2962 _18697_/A _16413_/S VPWR VGND sg13g2_buf_1
X_20385_ _23257_/D _19788_/Y _20395_/B _20384_/Y VPWR VGND sg13g2_o21ai_1
Xhold5033 _22125_/A _24054_/Q VPWR VGND sg13g2_dlygate4sd3_1
XFILLER_108_7 VPWR VGND sg13g2_decap_8
Xhold5044 _21164_/A _23607_/Q VPWR VGND sg13g2_dlygate4sd3_1
XFILLER_84_1319 VPWR VGND sg13g2_fill_1
Xplace2973 _18355_/A _18471_/S VPWR VGND sg13g2_buf_1
Xhold5055 _22154_/A _24067_/Q VPWR VGND sg13g2_dlygate4sd3_1
X_22124_ _24053_/D _22258_/A1 _22129_/B _22123_/Y VPWR VGND sg13g2_o21ai_1
Xplace2984 _16376_/B _16417_/B VPWR VGND sg13g2_buf_2
Xhold5066 _21486_/A _23762_/Q VPWR VGND sg13g2_dlygate4sd3_1
Xplace2995 _18957_/C _18889_/B VPWR VGND sg13g2_buf_1
Xhold5077 _20432_/A _23282_/Q VPWR VGND sg13g2_dlygate4sd3_1
XFILLER_115_970 VPWR VGND sg13g2_decap_8
Xhold5088 _22310_/A _24144_/Q VPWR VGND sg13g2_dlygate4sd3_1
Xhold5099 _21800_/A _23898_/Q VPWR VGND sg13g2_dlygate4sd3_1
XFILLER_88_810 VPWR VGND sg13g2_decap_8
XFILLER_114_480 VPWR VGND sg13g2_decap_8
XFILLER_102_631 VPWR VGND sg13g2_decap_8
XFILLER_82_1054 VPWR VGND sg13g2_decap_4
XFILLER_62_1639 VPWR VGND sg13g2_decap_4
X_21006_ _21006_/Y _23544_/Q _21085_/B VPWR VGND sg13g2_nand2_1
XFILLER_48_718 VPWR VGND sg13g2_decap_8
XFILLER_101_152 VPWR VGND sg13g2_fill_2
XFILLER_40_1904 VPWR VGND sg13g2_decap_8
XFILLER_28_420 VPWR VGND sg13g2_decap_8
XFILLER_29_954 VPWR VGND sg13g2_fill_2
XFILLER_16_604 VPWR VGND sg13g2_fill_2
XFILLER_62_209 VPWR VGND sg13g2_decap_8
X_22957_ _22957_/Q _24212_/CLK _22957_/D fanout2919/X VPWR VGND sg13g2_dfrbpq_1
XFILLER_83_570 VPWR VGND sg13g2_fill_2
XFILLER_46_77 VPWR VGND sg13g2_decap_8
XFILLER_112_1497 VPWR VGND sg13g2_fill_2
XFILLER_46_88 VPWR VGND sg13g2_fill_2
X_12710_ _12711_/B _23235_/Q _23267_/Q _23363_/Q _23395_/Q _13001_/S0 _12452_/A VPWR
+ VGND sg13g2_mux4_1
XFILLER_71_732 VPWR VGND sg13g2_fill_2
X_21908_ _23950_/D _21974_/A1 _21910_/B _21907_/Y VPWR VGND sg13g2_o21ai_1
X_13690_ _13690_/X _13688_/X _13689_/X _14129_/B VPWR VGND sg13g2_mux2_1
X_22888_ _22888_/Q clkload19/A _22888_/D fanout2870/X VPWR VGND sg13g2_dfrbpq_1
XFILLER_70_231 VPWR VGND sg13g2_decap_4
XFILLER_19_1221 VPWR VGND sg13g2_decap_8
XFILLER_31_618 VPWR VGND sg13g2_decap_8
X_12641_ _12641_/Y _22561_/Q _13181_/B _13182_/B2 VPWR VGND sg13g2_o21ai_1
X_21839_ _23917_/D _22373_/A1 _23917_/Q _21848_/B VPWR VGND sg13g2_mux2_1
XFILLER_30_106 VPWR VGND sg13g2_decap_8
XFILLER_19_1243 VPWR VGND sg13g2_decap_8
XFILLER_12_832 VPWR VGND sg13g2_fill_2
XFILLER_106_1224 VPWR VGND sg13g2_fill_1
X_12572_ _12572_/Y _12572_/A _12572_/B VPWR VGND sg13g2_nand2_1
XFILLER_106_1235 VPWR VGND sg13g2_decap_8
XFILLER_8_814 VPWR VGND sg13g2_decap_4
XFILLER_62_98 VPWR VGND sg13g2_fill_1
X_14311_ _15478_/C _16781_/A _14340_/C VPWR VGND sg13g2_nand2_1
X_23509_ _23509_/Q clkload58/A _23509_/D fanout2762/X VPWR VGND sg13g2_dfrbpq_1
XFILLER_32_1410 VPWR VGND sg13g2_decap_8
X_11523_ _13256_/A _12577_/B _12778_/A VPWR VGND sg13g2_nor2_1
XFILLER_54_1189 VPWR VGND sg13g2_fill_2
X_17030_ _17031_/B _17030_/A _17052_/C VPWR VGND sg13g2_nor2b_1
XFILLER_11_397 VPWR VGND sg13g2_decap_8
XFILLER_7_346 VPWR VGND sg13g2_decap_8
X_14242_ _14583_/B _24241_/Q _14242_/B VPWR VGND sg13g2_nor2_1
X_11454_ _11454_/Y _13708_/B _11454_/B VPWR VGND sg13g2_nand2_1
XFILLER_109_285 VPWR VGND sg13g2_fill_1
XFILLER_67_1517 VPWR VGND sg13g2_decap_8
XFILLER_109_296 VPWR VGND sg13g2_decap_4
XFILLER_101_1880 VPWR VGND sg13g2_decap_8
XFILLER_10_1774 VPWR VGND sg13g2_decap_8
X_13124_ _20164_/A _13373_/A _13373_/B VPWR VGND sg13g2_nor2_2
X_18981_ _18981_/Y _19003_/A _23087_/Q _19047_/C VPWR VGND sg13g2_nand3_1
XFILLER_106_981 VPWR VGND sg13g2_decap_4
X_13055_ _13055_/X _13692_/A _13692_/B _13055_/C _13055_/D VPWR VGND sg13g2_and4_1
X_17932_ _17932_/Y _22942_/Q _17932_/B VPWR VGND sg13g2_nand2_1
XFILLER_61_1105 VPWR VGND sg13g2_decap_8
X_12006_ _12006_/X _24027_/Q _24059_/Q _24091_/Q _24123_/Q _12028_/A _12006_/S1 VPWR
+ VGND sg13g2_mux4_1
XFILLER_23_7 VPWR VGND sg13g2_fill_1
X_16814_ _22674_/D _17175_/A _16813_/X _16846_/A VPWR VGND sg13g2_mux2_1
XFILLER_43_1572 VPWR VGND sg13g2_fill_2
X_17794_ _17794_/Y _17809_/A1 _17792_/X _17793_/Y VPWR VGND sg13g2_o21ai_1
X_16745_ _16746_/B _22664_/Q _16796_/B VPWR VGND sg13g2_xnor2_1
XFILLER_19_464 VPWR VGND sg13g2_decap_8
X_13957_ _13957_/Y _13957_/A VPWR VGND sg13g2_inv_1
XFILLER_35_946 VPWR VGND sg13g2_decap_4
X_19464_ _19464_/Y _19582_/A _19464_/B VPWR VGND sg13g2_nand2_1
X_12908_ _12908_/Y _12909_/B _23941_/Q _12907_/Y VPWR VGND sg13g2_o21ai_1
X_16676_ _16677_/B _16676_/A _16683_/B _16683_/C VPWR VGND sg13g2_or3_1
X_13888_ _13888_/Y _23923_/Q VPWR VGND sg13g2_inv_1
XFILLER_34_456 VPWR VGND sg13g2_fill_2
X_18415_ _18415_/Y _18562_/B _18415_/B VPWR VGND sg13g2_nand2_1
XFILLER_59_1089 VPWR VGND sg13g2_decap_8
X_15627_ _15628_/D _15624_/Y _15667_/B VPWR VGND sg13g2_nand2b_1
X_19395_ _19395_/X _19704_/A _19534_/B _19394_/X VPWR VGND sg13g2_a21o_1
XFILLER_22_618 VPWR VGND sg13g2_decap_4
XFILLER_17_1906 VPWR VGND sg13g2_decap_8
XFILLER_50_938 VPWR VGND sg13g2_decap_4
XFILLER_37_1343 VPWR VGND sg13g2_fill_1
X_18346_ _18346_/Y _18332_/B _18350_/A _18343_/Y _18274_/B _18345_/Y VPWR VGND sg13g2_a221oi_1
XFILLER_72_1234 VPWR VGND sg13g2_decap_4
X_15558_ _15558_/Y _16014_/A _15558_/B VPWR VGND sg13g2_nor2_1
XFILLER_33_1207 VPWR VGND sg13g2_fill_2
X_14509_ _14513_/A _22599_/Q _23010_/Q VPWR VGND sg13g2_xnor2_1
X_18277_ _18277_/Y _22973_/Q _18432_/B VPWR VGND sg13g2_nand2_1
X_15489_ _15489_/Y _15489_/A _15489_/B _15489_/C VPWR VGND sg13g2_nor3_1
XFILLER_50_1521 VPWR VGND sg13g2_fill_1
XFILLER_102_1600 VPWR VGND sg13g2_decap_8
XFILLER_30_695 VPWR VGND sg13g2_decap_4
X_17228_ _17229_/D _17222_/C _17228_/B VPWR VGND sg13g2_nand2b_1
XFILLER_11_1505 VPWR VGND sg13g2_fill_2
XFILLER_102_1622 VPWR VGND sg13g2_decap_8
XFILLER_15_1685 VPWR VGND sg13g2_decap_4
X_17159_ _22735_/D _17209_/B _17157_/Y _17158_/Y VPWR VGND sg13g2_a21oi_1
XFILLER_66_1016 VPWR VGND sg13g2_decap_8
X_20170_ _20170_/X _20284_/A3 _23216_/Q _20284_/A2 _20284_/A1 _20350_/A _20310_/S0
+ VPWR VGND sg13g2_mux4_1
XFILLER_66_1038 VPWR VGND sg13g2_decap_8
XFILLER_107_28 VPWR VGND sg13g2_decap_8
XFILLER_103_406 VPWR VGND sg13g2_decap_8
XFILLER_115_266 VPWR VGND sg13g2_decap_8
XFILLER_48_1450 VPWR VGND sg13g2_fill_1
XFILLER_69_353 VPWR VGND sg13g2_fill_1
XFILLER_57_515 VPWR VGND sg13g2_decap_8
XFILLER_84_312 VPWR VGND sg13g2_decap_8
XFILLER_69_386 VPWR VGND sg13g2_fill_1
XFILLER_29_228 VPWR VGND sg13g2_decap_8
XFILLER_113_1740 VPWR VGND sg13g2_fill_2
X_23860_ _23860_/Q clkload29/A _23860_/D fanout2669/X VPWR VGND sg13g2_dfrbpq_1
XFILLER_85_868 VPWR VGND sg13g2_decap_4
XFILLER_6_1875 VPWR VGND sg13g2_decap_8
XFILLER_38_751 VPWR VGND sg13g2_fill_2
XFILLER_84_367 VPWR VGND sg13g2_fill_2
X_22811_ _22811_/Q clkload10/A _22811_/D fanout2811/X VPWR VGND sg13g2_dfrbpq_1
XFILLER_26_913 VPWR VGND sg13g2_decap_4
X_23791_ _23791_/Q clkload30/A _23791_/D fanout2656/X VPWR VGND sg13g2_dfrbpq_1
XFILLER_53_710 VPWR VGND sg13g2_fill_1
XFILLER_65_570 VPWR VGND sg13g2_decap_8
XFILLER_96_1746 VPWR VGND sg13g2_decap_4
XFILLER_77_1123 VPWR VGND sg13g2_decap_8
XFILLER_26_946 VPWR VGND sg13g2_fill_2
XFILLER_57_1708 VPWR VGND sg13g2_fill_1
XFILLER_57_1719 VPWR VGND sg13g2_decap_8
X_22742_ _22742_/Q clkload20/A _22742_/D fanout2867/X VPWR VGND sg13g2_dfrbpq_1
XFILLER_53_765 VPWR VGND sg13g2_decap_8
XFILLER_80_562 VPWR VGND sg13g2_decap_8
XFILLER_16_69 VPWR VGND sg13g2_decap_4
XFILLER_52_253 VPWR VGND sg13g2_decap_8
X_22673_ _22673_/Q clkload20/A _22673_/D fanout2866/X VPWR VGND sg13g2_dfrbpq_1
XFILLER_34_990 VPWR VGND sg13g2_fill_2
XFILLER_12_139 VPWR VGND sg13g2_fill_2
XFILLER_21_651 VPWR VGND sg13g2_decap_8
XFILLER_51_1329 VPWR VGND sg13g2_decap_4
XFILLER_107_1566 VPWR VGND sg13g2_fill_1
X_21555_ _21555_/Y _23796_/Q _21555_/B VPWR VGND sg13g2_nand2_1
Xplace4150 _13631_/S1 _13643_/S VPWR VGND sg13g2_buf_4
Xplace4161 _13797_/S _11726_/S VPWR VGND sg13g2_buf_2
Xplace4172 _13260_/A1 _12974_/A VPWR VGND sg13g2_buf_1
X_24274_ _24274_/X _24274_/A VPWR VGND sg13g2_buf_1
Xplace4183 _12474_/S _12478_/S VPWR VGND sg13g2_buf_2
X_21486_ _21486_/Y _21486_/A _21486_/B VPWR VGND sg13g2_nand2_1
XFILLER_107_701 VPWR VGND sg13g2_decap_8
Xplace4194 _11449_/B _22985_/Q VPWR VGND sg13g2_buf_4
Xplace3460 _17032_/B _17026_/B VPWR VGND sg13g2_buf_1
XFILLER_33_1796 VPWR VGND sg13g2_decap_4
Xplace3471 _16547_/A _16678_/S VPWR VGND sg13g2_buf_1
XFILLER_107_734 VPWR VGND sg13g2_decap_8
X_20437_ _20649_/B _22050_/A _20437_/B _22050_/C VPWR VGND sg13g2_nor3_1
X_23225_ _23225_/Q clkload55/A _23225_/D fanout2770/X VPWR VGND sg13g2_dfrbpq_1
XFILLER_101_1154 VPWR VGND sg13g2_fill_1
Xplace3482 _16187_/B _16156_/B VPWR VGND sg13g2_buf_1
XFILLER_4_327 VPWR VGND sg13g2_decap_8
Xplace3493 _16043_/A _15221_/A VPWR VGND sg13g2_buf_1
XFILLER_101_1198 VPWR VGND sg13g2_fill_2
XFILLER_84_1138 VPWR VGND sg13g2_decap_8
X_23156_ _23156_/Q _23187_/CLK _23156_/D fanout2916/X VPWR VGND sg13g2_dfrbpq_1
XFILLER_49_1258 VPWR VGND sg13g2_decap_8
X_20368_ _20514_/B _22971_/Q _20831_/C VPWR VGND sg13g2_nand2_1
XFILLER_106_277 VPWR VGND sg13g2_fill_1
X_22107_ _24045_/D _24045_/Q _22440_/A1 _22116_/S VPWR VGND sg13g2_mux2_1
X_23087_ _23087_/Q _23215_/CLK _23087_/D fanout2926/X VPWR VGND sg13g2_dfrbpq_1
XFILLER_103_951 VPWR VGND sg13g2_decap_8
XFILLER_7_1606 VPWR VGND sg13g2_decap_8
XFILLER_88_651 VPWR VGND sg13g2_decap_8
X_22038_ _24013_/D _22373_/A1 _24013_/Q _22047_/S VPWR VGND sg13g2_mux2_1
XFILLER_27_1589 VPWR VGND sg13g2_fill_2
XFILLER_75_323 VPWR VGND sg13g2_decap_8
X_14860_ _14860_/X _23129_/Q _16241_/B _14933_/S VPWR VGND sg13g2_mux2_1
XFILLER_44_1892 VPWR VGND sg13g2_decap_8
XFILLER_25_1280 VPWR VGND sg13g2_decap_4
XFILLER_60_1160 VPWR VGND sg13g2_fill_1
XFILLER_21_1122 VPWR VGND sg13g2_fill_2
XFILLER_21_1133 VPWR VGND sg13g2_decap_4
X_13811_ _24273_/A _14427_/A VPWR VGND sg13g2_inv_4
XFILLER_60_1182 VPWR VGND sg13g2_fill_2
XFILLER_35_209 VPWR VGND sg13g2_fill_2
XFILLER_63_518 VPWR VGND sg13g2_decap_8
XFILLER_63_529 VPWR VGND sg13g2_fill_1
X_23989_ _23989_/Q clkload47/A _23989_/D fanout2680/X VPWR VGND sg13g2_dfrbpq_1
XFILLER_16_401 VPWR VGND sg13g2_decap_8
Xclkbuf_4_10__f_clk_i clkbuf_leaf_55_clk_i/A clkbuf_3_5_0_clk_i/X VPWR VGND sg13g2_buf_8
XFILLER_44_710 VPWR VGND sg13g2_decap_8
XFILLER_40_1789 VPWR VGND sg13g2_fill_1
X_16530_ _16530_/Y _16530_/A _16547_/A VPWR VGND sg13g2_nor2_1
X_13742_ _13742_/Y _13742_/A _13743_/A VPWR VGND sg13g2_nor2b_1
XFILLER_56_592 VPWR VGND sg13g2_decap_8
XFILLER_44_743 VPWR VGND sg13g2_decap_8
XFILLER_16_445 VPWR VGND sg13g2_fill_1
XFILLER_44_754 VPWR VGND sg13g2_fill_1
XFILLER_95_1267 VPWR VGND sg13g2_fill_2
XFILLER_73_53 VPWR VGND sg13g2_decap_8
X_16461_ _22594_/D _17854_/A1 _16470_/B _16460_/Y VPWR VGND sg13g2_o21ai_1
X_13673_ _13674_/B _23440_/Q _23472_/Q _13676_/B VPWR VGND sg13g2_mux2_1
XFILLER_25_990 VPWR VGND sg13g2_fill_1
X_18200_ _18232_/B _18290_/C _18332_/B _18564_/A1 VPWR VGND sg13g2_a21o_1
X_19180_ _23150_/D _23150_/Q _19180_/A1 _19185_/S VPWR VGND sg13g2_mux2_1
X_16392_ _22562_/D _23012_/Q _22562_/Q _16421_/S VPWR VGND sg13g2_mux2_1
XFILLER_8_600 VPWR VGND sg13g2_fill_2
X_18131_ _22959_/D _18385_/B _22959_/Q _18221_/S VPWR VGND sg13g2_mux2_1
X_12555_ _12555_/X _23745_/Q _23809_/Q _23873_/Q _23969_/Q _12478_/S _12487_/S VPWR
+ VGND sg13g2_mux4_1
X_11506_ _11506_/X _11504_/X _11505_/X _11517_/S VPWR VGND sg13g2_mux2_1
XFILLER_103_1931 VPWR VGND sg13g2_decap_8
X_18062_ _18404_/B _18421_/A _18451_/C VPWR VGND sg13g2_nor2_1
X_15274_ _15274_/Y _16856_/A _24221_/Q VPWR VGND sg13g2_nor2b_1
X_12486_ _12489_/C _12486_/A _12486_/B VPWR VGND sg13g2_nor2_1
X_17013_ _17018_/B _22711_/Q _17013_/B VPWR VGND sg13g2_and2_1
X_14225_ _14226_/B _14225_/A _22826_/Q VPWR VGND sg13g2_nand2_1
XFILLER_12_1869 VPWR VGND sg13g2_decap_8
XFILLER_113_715 VPWR VGND sg13g2_decap_8
XFILLER_112_203 VPWR VGND sg13g2_decap_8
X_13107_ _13107_/X _13115_/A _13107_/B VPWR VGND sg13g2_and2_1
XFILLER_4_894 VPWR VGND sg13g2_decap_8
XFILLER_84_1661 VPWR VGND sg13g2_fill_2
X_18964_ _18964_/Y _19008_/A _18964_/B _18964_/C VPWR VGND sg13g2_nand3_1
XFILLER_26_1000 VPWR VGND sg13g2_fill_2
X_14087_ _14095_/A _19489_/A _14087_/B _14087_/C _14087_/D VPWR VGND sg13g2_nand4_1
X_11299_ _11299_/Y _11298_/X _12028_/A VPWR VGND sg13g2_nand2b_1
XFILLER_80_1536 VPWR VGND sg13g2_fill_2
X_17915_ _17916_/B _22936_/Q _17923_/B VPWR VGND sg13g2_nand2_1
XFILLER_26_1033 VPWR VGND sg13g2_fill_2
X_13038_ _13038_/Y _22566_/Q _13692_/B _13988_/B1 VPWR VGND sg13g2_o21ai_1
X_18895_ _18897_/B _18951_/A _18895_/B VPWR VGND sg13g2_nand2_1
XFILLER_113_1014 VPWR VGND sg13g2_fill_2
XFILLER_67_835 VPWR VGND sg13g2_decap_8
XFILLER_23_1954 VPWR VGND sg13g2_fill_1
XFILLER_94_676 VPWR VGND sg13g2_decap_8
XFILLER_93_142 VPWR VGND sg13g2_fill_1
XFILLER_81_315 VPWR VGND sg13g2_fill_2
X_17777_ _17784_/B _22572_/Q _22571_/Q _17777_/C VPWR VGND sg13g2_nand3_1
XFILLER_93_197 VPWR VGND sg13g2_decap_8
X_19516_ _19516_/Y _19505_/A _19508_/Y _19514_/Y _20249_/A2 VPWR VGND sg13g2_a22oi_1
X_16728_ _16728_/Y _16728_/A _16728_/B VPWR VGND sg13g2_nor2_1
XFILLER_34_220 VPWR VGND sg13g2_decap_4
XFILLER_39_1405 VPWR VGND sg13g2_fill_1
XFILLER_78_1487 VPWR VGND sg13g2_decap_8
XFILLER_74_1318 VPWR VGND sg13g2_fill_2
XFILLER_1_1783 VPWR VGND sg13g2_decap_8
XFILLER_34_253 VPWR VGND sg13g2_decap_8
XFILLER_74_1329 VPWR VGND sg13g2_fill_2
X_19447_ _19447_/Y _20260_/A _19463_/S _19446_/Y VPWR VGND sg13g2_a21oi_1
XFILLER_34_264 VPWR VGND sg13g2_fill_1
XFILLER_35_787 VPWR VGND sg13g2_fill_2
XFILLER_22_415 VPWR VGND sg13g2_decap_8
XFILLER_108_1820 VPWR VGND sg13g2_decap_8
XFILLER_97_0 VPWR VGND sg13g2_decap_8
XFILLER_50_757 VPWR VGND sg13g2_decap_8
XFILLER_52_1605 VPWR VGND sg13g2_fill_1
X_19378_ _19378_/X _19634_/A _19376_/Y _19712_/B VPWR VGND sg13g2_mux2_1
XFILLER_91_1676 VPWR VGND sg13g2_decap_4
XFILLER_52_1627 VPWR VGND sg13g2_fill_2
X_18329_ _18336_/B _18238_/A _18327_/X _18328_/Y _18326_/Y VPWR VGND sg13g2_a22oi_1
XFILLER_72_1075 VPWR VGND sg13g2_decap_8
XFILLER_108_1897 VPWR VGND sg13g2_decap_8
XFILLER_72_1097 VPWR VGND sg13g2_decap_8
X_21340_ _23691_/D _21677_/A1 _21347_/B _21339_/Y VPWR VGND sg13g2_o21ai_1
XFILLER_30_1925 VPWR VGND sg13g2_fill_2
XFILLER_89_1550 VPWR VGND sg13g2_decap_4
X_21271_ _21271_/Y _21271_/A _21271_/B VPWR VGND sg13g2_nand2_1
XFILLER_11_1368 VPWR VGND sg13g2_decap_8
X_20222_ _20222_/Y _20098_/A0 _20222_/B VPWR VGND sg13g2_nand2b_1
XFILLER_2_809 VPWR VGND sg13g2_decap_8
X_23010_ _23010_/Q _23029_/CLK _23010_/D fanout2850/X VPWR VGND sg13g2_dfrbpq_1
X_20153_ _20153_/Y _20153_/A _20153_/B _20153_/C _20153_/D VPWR VGND sg13g2_nand4_1
XFILLER_103_236 VPWR VGND sg13g2_fill_1
XFILLER_44_1122 VPWR VGND sg13g2_decap_4
XFILLER_8_1937 VPWR VGND sg13g2_decap_8
XFILLER_24_1707 VPWR VGND sg13g2_fill_1
XFILLER_69_150 VPWR VGND sg13g2_decap_8
X_20084_ _20084_/Y _20087_/A _20085_/A VPWR VGND sg13g2_nor2_1
XFILLER_83_1193 VPWR VGND sg13g2_decap_8
XFILLER_44_1144 VPWR VGND sg13g2_decap_8
XFILLER_24_1729 VPWR VGND sg13g2_decap_8
XFILLER_63_1778 VPWR VGND sg13g2_decap_4
XFILLER_85_632 VPWR VGND sg13g2_decap_8
X_23912_ _23912_/Q clkload32/A _23912_/D fanout2648/X VPWR VGND sg13g2_dfrbpq_1
XFILLER_115_1868 VPWR VGND sg13g2_decap_8
XFILLER_84_120 VPWR VGND sg13g2_fill_2
XFILLER_22_1420 VPWR VGND sg13g2_decap_8
XFILLER_100_976 VPWR VGND sg13g2_fill_1
XFILLER_22_1431 VPWR VGND sg13g2_fill_1
XFILLER_100_987 VPWR VGND sg13g2_decap_4
X_23843_ _23843_/Q clkload40/A _23843_/D fanout2730/X VPWR VGND sg13g2_dfrbpq_1
XFILLER_57_389 VPWR VGND sg13g2_fill_1
XFILLER_73_838 VPWR VGND sg13g2_fill_1
XFILLER_96_1543 VPWR VGND sg13g2_fill_2
XFILLER_72_337 VPWR VGND sg13g2_fill_1
XFILLER_22_1497 VPWR VGND sg13g2_fill_1
X_23774_ _23774_/Q clkload59/A _23774_/D fanout2784/X VPWR VGND sg13g2_dfrbpq_1
XFILLER_25_220 VPWR VGND sg13g2_decap_8
XFILLER_72_359 VPWR VGND sg13g2_decap_8
X_20986_ _23537_/D _22246_/A0 _23537_/Q _20989_/S VPWR VGND sg13g2_mux2_1
XFILLER_57_1516 VPWR VGND sg13g2_fill_1
X_22725_ _22725_/Q clkload22/A _22725_/D fanout2885/X VPWR VGND sg13g2_dfrbpq_1
XFILLER_26_798 VPWR VGND sg13g2_decap_8
XFILLER_41_735 VPWR VGND sg13g2_decap_8
XFILLER_0_1293 VPWR VGND sg13g2_decap_4
XFILLER_40_234 VPWR VGND sg13g2_decap_8
X_22656_ _22656_/Q clkload24/A _22656_/D fanout2889/X VPWR VGND sg13g2_dfrbpq_1
XFILLER_35_1825 VPWR VGND sg13g2_decap_8
XFILLER_74_1874 VPWR VGND sg13g2_decap_8
XFILLER_107_1330 VPWR VGND sg13g2_decap_8
XFILLER_40_245 VPWR VGND sg13g2_fill_1
XFILLER_22_960 VPWR VGND sg13g2_decap_4
XFILLER_22_971 VPWR VGND sg13g2_decap_8
XFILLER_40_267 VPWR VGND sg13g2_decap_4
X_21607_ _21607_/Y _23819_/Q _21615_/B VPWR VGND sg13g2_nand2_1
XFILLER_22_982 VPWR VGND sg13g2_fill_1
X_22587_ _22587_/Q clkload21/A _22587_/D fanout2876/X VPWR VGND sg13g2_dfrbpq_1
XFILLER_51_1148 VPWR VGND sg13g2_decap_8
XFILLER_107_1396 VPWR VGND sg13g2_decap_8
X_12340_ _12340_/Y _12340_/A _14340_/A _12340_/C VPWR VGND sg13g2_nor3_1
X_21538_ _23785_/D _21965_/A0 _23785_/Q _21554_/S VPWR VGND sg13g2_mux2_1
XFILLER_107_520 VPWR VGND sg13g2_decap_8
X_12271_ _12277_/A _12531_/A _12968_/B _12270_/Y VPWR VGND sg13g2_o21ai_1
X_24257_ _24257_/X _24257_/A VPWR VGND sg13g2_buf_1
X_21469_ _21488_/S _22430_/B _21557_/B VPWR VGND sg13g2_nor2b_1
Xplace3290 _21327_/A1 _21261_/A1 VPWR VGND sg13g2_buf_1
XFILLER_88_1071 VPWR VGND sg13g2_fill_2
XFILLER_5_669 VPWR VGND sg13g2_decap_8
X_14010_ _14427_/D _24266_/A _24268_/A _24269_/A VPWR VGND sg13g2_nor3_1
X_23208_ _23208_/Q clkload33/A _23208_/D fanout2930/X VPWR VGND sg13g2_dfrbpq_1
X_11222_ _11222_/X _11222_/A _11222_/B VPWR VGND sg13g2_and2_1
XFILLER_29_1618 VPWR VGND sg13g2_fill_1
X_24188_ _24188_/Q clkload55/A _24188_/D fanout2771/X VPWR VGND sg13g2_dfrbpq_1
XFILLER_4_179 VPWR VGND sg13g2_decap_8
XFILLER_107_597 VPWR VGND sg13g2_decap_8
X_23139_ _23139_/Q clkload5/A _23139_/D fanout2840/X VPWR VGND sg13g2_dfrbpq_1
XFILLER_110_718 VPWR VGND sg13g2_decap_4
XFILLER_95_407 VPWR VGND sg13g2_fill_2
XFILLER_89_971 VPWR VGND sg13g2_decap_8
XFILLER_66_1391 VPWR VGND sg13g2_decap_8
X_15961_ _15961_/Y _22577_/Q _16023_/B VPWR VGND sg13g2_nand2_1
XFILLER_89_993 VPWR VGND sg13g2_decap_8
XFILLER_88_470 VPWR VGND sg13g2_fill_1
XFILLER_42_1818 VPWR VGND sg13g2_decap_4
XFILLER_7_1458 VPWR VGND sg13g2_decap_4
X_17700_ _17700_/Y _17710_/A1 _17696_/Y _17699_/Y VPWR VGND sg13g2_o21ai_1
XFILLER_48_323 VPWR VGND sg13g2_decap_4
X_14912_ _14916_/B _22493_/Q _14912_/B VPWR VGND sg13g2_nand2_1
XFILLER_62_1277 VPWR VGND sg13g2_decap_4
XFILLER_114_1356 VPWR VGND sg13g2_fill_2
X_18680_ _23014_/D _18692_/B _18678_/X _18679_/Y VPWR VGND sg13g2_a21oi_1
X_15892_ _15896_/A _22904_/Q _15937_/B VPWR VGND sg13g2_nand2_1
XFILLER_76_665 VPWR VGND sg13g2_fill_2
XFILLER_40_1531 VPWR VGND sg13g2_decap_4
X_17631_ _17631_/Y _22886_/Q _17631_/B VPWR VGND sg13g2_nor2_1
XFILLER_76_687 VPWR VGND sg13g2_decap_8
XFILLER_36_529 VPWR VGND sg13g2_fill_2
X_17562_ _17569_/A _23158_/Q _17590_/B VPWR VGND sg13g2_nand2_1
X_14774_ _14774_/X _14774_/A _14788_/B VPWR VGND sg13g2_and2_1
XFILLER_75_1605 VPWR VGND sg13g2_fill_2
X_11986_ _14346_/C _14144_/C _11681_/Y _11819_/Y VPWR VGND sg13g2_a21o_1
XFILLER_16_231 VPWR VGND sg13g2_fill_1
X_19301_ _23218_/D _23218_/Q _20316_/A0 _19303_/S VPWR VGND sg13g2_mux2_1
X_16513_ _22616_/D _16197_/A _16512_/B _16512_/Y VPWR VGND sg13g2_o21ai_1
XFILLER_56_1004 VPWR VGND sg13g2_fill_2
X_13725_ _13725_/Y _15884_/A _15906_/A VPWR VGND sg13g2_nor2_1
X_17493_ _22863_/D _16169_/A _17498_/B _17492_/Y VPWR VGND sg13g2_o21ai_1
XFILLER_90_189 VPWR VGND sg13g2_decap_8
XFILLER_32_724 VPWR VGND sg13g2_decap_8
XFILLER_44_584 VPWR VGND sg13g2_decap_8
XFILLER_95_1097 VPWR VGND sg13g2_decap_4
XFILLER_31_212 VPWR VGND sg13g2_fill_1
XFILLER_32_735 VPWR VGND sg13g2_fill_2
XFILLER_31_223 VPWR VGND sg13g2_fill_2
X_19232_ _19232_/Y _23186_/Q _19232_/B VPWR VGND sg13g2_nand2_1
XFILLER_90_7 VPWR VGND sg13g2_fill_2
X_13656_ _13657_/C _15884_/A _20258_/A VPWR VGND sg13g2_nor2b_1
XFILLER_73_1340 VPWR VGND sg13g2_fill_1
XFILLER_38_1471 VPWR VGND sg13g2_decap_8
XFILLER_20_919 VPWR VGND sg13g2_fill_2
X_19163_ _23135_/D _23135_/Q _14922_/Y _19171_/S VPWR VGND sg13g2_mux2_1
X_12607_ _12607_/X _12607_/A _12607_/B _12607_/C _12607_/D VPWR VGND sg13g2_or4_1
XFILLER_13_982 VPWR VGND sg13g2_fill_2
X_16375_ _22549_/D _18339_/A _16376_/B _16374_/Y VPWR VGND sg13g2_o21ai_1
X_13587_ _13587_/Y _13595_/B2 _13584_/Y _13586_/Y _13587_/B2 VPWR VGND sg13g2_a22oi_1
XFILLER_9_953 VPWR VGND sg13g2_decap_4
X_18114_ _22951_/D _18425_/A _22951_/Q _18194_/A VPWR VGND sg13g2_mux2_1
X_19094_ _19094_/X _18929_/A _23115_/Q _19098_/S VPWR VGND sg13g2_mux2_1
X_12538_ _12538_/X _12538_/A _12538_/B VPWR VGND sg13g2_or2_1
XFILLER_9_997 VPWR VGND sg13g2_decap_4
XFILLER_51_1682 VPWR VGND sg13g2_decap_4
X_15257_ _16782_/D _15257_/A _15257_/B VPWR VGND sg13g2_nand2_1
XFILLER_32_1092 VPWR VGND sg13g2_decap_8
X_12469_ _12469_/Y _13383_/A _14342_/B _12668_/B _12899_/S VPWR VGND sg13g2_nor4_1
XFILLER_99_702 VPWR VGND sg13g2_decap_8
X_14208_ _14210_/A _14208_/A _22833_/Q VPWR VGND sg13g2_nand2_1
Xhold4909 _22036_/A _24012_/Q VPWR VGND sg13g2_dlygate4sd3_1
XFILLER_67_1133 VPWR VGND sg13g2_decap_8
X_15188_ _15197_/C _22783_/Q _17303_/A _15182_/X _22879_/Q _15187_/Y VPWR VGND sg13g2_a221oi_1
XFILLER_98_201 VPWR VGND sg13g2_decap_8
XFILLER_113_512 VPWR VGND sg13g2_decap_8
XFILLER_67_1177 VPWR VGND sg13g2_decap_8
X_19996_ _19996_/Y _20100_/A1 _19993_/Y _19995_/Y _19996_/B2 _20100_/C1 VPWR VGND
+ sg13g2_a221oi_1
XFILLER_67_1188 VPWR VGND sg13g2_fill_1
XFILLER_113_589 VPWR VGND sg13g2_decap_8
X_18947_ _18947_/Y _18955_/A _18947_/B _18947_/C VPWR VGND sg13g2_nand3b_1
XFILLER_100_217 VPWR VGND sg13g2_fill_1
XFILLER_67_621 VPWR VGND sg13g2_decap_4
XFILLER_79_492 VPWR VGND sg13g2_fill_1
X_18878_ _18879_/C _23046_/Q _18890_/B _18889_/B VPWR VGND sg13g2_or3_1
XFILLER_12_0 VPWR VGND sg13g2_decap_8
XFILLER_39_367 VPWR VGND sg13g2_fill_2
XFILLER_23_1751 VPWR VGND sg13g2_fill_1
XFILLER_3_1834 VPWR VGND sg13g2_decap_8
XFILLER_66_164 VPWR VGND sg13g2_fill_2
XFILLER_54_326 VPWR VGND sg13g2_fill_2
XFILLER_82_657 VPWR VGND sg13g2_decap_8
X_20840_ _23467_/D _22437_/A1 _20853_/B _20839_/Y VPWR VGND sg13g2_o21ai_1
XFILLER_35_540 VPWR VGND sg13g2_decap_8
XFILLER_70_808 VPWR VGND sg13g2_decap_8
XFILLER_110_1776 VPWR VGND sg13g2_decap_8
XFILLER_39_1213 VPWR VGND sg13g2_fill_1
XFILLER_93_1727 VPWR VGND sg13g2_fill_2
XFILLER_39_1224 VPWR VGND sg13g2_decap_8
X_20771_ _23435_/D _22437_/A1 _20784_/B _20770_/Y VPWR VGND sg13g2_o21ai_1
XFILLER_39_1257 VPWR VGND sg13g2_decap_8
X_22510_ _22510_/Q _23029_/CLK _22510_/D fanout2806/X VPWR VGND sg13g2_dfrbpq_1
X_23490_ _23490_/Q clkload40/A _23490_/D fanout2726/X VPWR VGND sg13g2_dfrbpq_1
XFILLER_23_779 VPWR VGND sg13g2_fill_1
XFILLER_22_267 VPWR VGND sg13g2_decap_4
X_22441_ _22441_/Y _24206_/Q _22444_/B VPWR VGND sg13g2_nand2_1
XFILLER_17_1588 VPWR VGND sg13g2_decap_8
X_22372_ _24172_/D _20237_/Y _22377_/B _22371_/Y VPWR VGND sg13g2_o21ai_1
XFILLER_108_328 VPWR VGND sg13g2_decap_4
X_24111_ _24111_/Q _24205_/CLK _24111_/D fanout2649/X VPWR VGND sg13g2_dfrbpq_1
X_21323_ _23682_/D _21323_/A1 _21330_/B _21322_/Y VPWR VGND sg13g2_o21ai_1
XFILLER_11_1132 VPWR VGND sg13g2_decap_8
XFILLER_69_1932 VPWR VGND sg13g2_decap_8
XFILLER_11_1154 VPWR VGND sg13g2_decap_8
XFILLER_85_1211 VPWR VGND sg13g2_decap_8
XFILLER_85_1222 VPWR VGND sg13g2_fill_1
X_21254_ _21254_/Y _23649_/Q _21264_/B VPWR VGND sg13g2_nand2_1
X_24042_ _24042_/Q clkload37/A _24042_/D fanout2708/X VPWR VGND sg13g2_dfrbpq_1
XFILLER_11_1176 VPWR VGND sg13g2_fill_1
XFILLER_104_512 VPWR VGND sg13g2_decap_8
XFILLER_65_1818 VPWR VGND sg13g2_fill_2
XFILLER_46_1206 VPWR VGND sg13g2_fill_2
X_20205_ _20205_/Y _20205_/A _20269_/B VPWR VGND sg13g2_nand2_1
X_21185_ _23616_/D _21587_/A1 _21188_/B _21184_/Y VPWR VGND sg13g2_o21ai_1
X_20136_ _20140_/C _13069_/B _20319_/B _19597_/X _20135_/Y VPWR VGND sg13g2_a22oi_1
XFILLER_104_589 VPWR VGND sg13g2_decap_8
XFILLER_89_278 VPWR VGND sg13g2_decap_4
XFILLER_8_1734 VPWR VGND sg13g2_decap_8
XFILLER_24_1515 VPWR VGND sg13g2_fill_2
XFILLER_63_1564 VPWR VGND sg13g2_decap_8
XFILLER_4_1609 VPWR VGND sg13g2_fill_2
X_20067_ _20067_/Y _12835_/X _20085_/B _20066_/Y VPWR VGND sg13g2_o21ai_1
XFILLER_86_974 VPWR VGND sg13g2_decap_8
XFILLER_85_440 VPWR VGND sg13g2_fill_1
XFILLER_46_805 VPWR VGND sg13g2_decap_8
XFILLER_100_773 VPWR VGND sg13g2_decap_8
XFILLER_98_1638 VPWR VGND sg13g2_decap_8
XFILLER_73_613 VPWR VGND sg13g2_decap_8
XFILLER_85_484 VPWR VGND sg13g2_decap_4
X_11840_ _11840_/Y _11843_/S _23481_/Q _11839_/Y VPWR VGND sg13g2_o21ai_1
X_23826_ _23826_/Q clkload29/A _23826_/D fanout2670/X VPWR VGND sg13g2_dfrbpq_1
XFILLER_76_1925 VPWR VGND sg13g2_fill_1
X_23757_ _23757_/Q clkload30/A _23757_/D fanout2657/X VPWR VGND sg13g2_dfrbpq_1
X_11771_ _11771_/Y _11751_/Y _11754_/Y _11761_/Y _11766_/Y _11770_/X VPWR VGND sg13g2_a221oi_1
XFILLER_2_1399 VPWR VGND sg13g2_decap_4
XFILLER_37_1909 VPWR VGND sg13g2_fill_2
XFILLER_54_66 VPWR VGND sg13g2_decap_8
XFILLER_96_1395 VPWR VGND sg13g2_decap_8
XFILLER_54_77 VPWR VGND sg13g2_fill_2
XFILLER_14_746 VPWR VGND sg13g2_fill_1
XFILLER_53_392 VPWR VGND sg13g2_decap_8
X_13510_ _14004_/B _13510_/A _13510_/B VPWR VGND sg13g2_or2_1
X_22708_ _22708_/Q clkload19/A _22708_/D fanout2862/X VPWR VGND sg13g2_dfrbpq_1
X_14490_ _14491_/D _22618_/Q _23029_/Q VPWR VGND sg13g2_xor2_1
X_23688_ _23688_/Q clkload31/A _23688_/D fanout2655/X VPWR VGND sg13g2_dfrbpq_1
XFILLER_14_779 VPWR VGND sg13g2_decap_4
XFILLER_9_205 VPWR VGND sg13g2_decap_8
XFILLER_13_267 VPWR VGND sg13g2_fill_1
XFILLER_70_1513 VPWR VGND sg13g2_fill_1
XFILLER_16_1021 VPWR VGND sg13g2_decap_8
XFILLER_35_1644 VPWR VGND sg13g2_decap_4
XFILLER_70_21 VPWR VGND sg13g2_decap_8
X_22639_ _22639_/Q clkload19/A _22639_/D fanout2863/X VPWR VGND sg13g2_dfrbpq_1
XFILLER_13_1920 VPWR VGND sg13g2_decap_8
X_13372_ _13372_/X _14030_/A _13372_/B VPWR VGND sg13g2_and2_1
XFILLER_16_1087 VPWR VGND sg13g2_decap_8
XFILLER_10_974 VPWR VGND sg13g2_decap_8
Xclkload19 clkload19/X clkload19/A VPWR VGND sg13g2_buf_8
X_15111_ _15111_/X _23154_/Q _16331_/A _15120_/S VPWR VGND sg13g2_mux2_1
XFILLER_70_98 VPWR VGND sg13g2_decap_4
XFILLER_10_996 VPWR VGND sg13g2_fill_1
X_12323_ _12324_/C _12686_/B _12323_/B _12323_/C _12323_/D VPWR VGND sg13g2_or4_1
XFILLER_79_30 VPWR VGND sg13g2_decap_4
X_15042_ _15043_/B _22535_/Q _15042_/B VPWR VGND sg13g2_and2_1
XFILLER_5_466 VPWR VGND sg13g2_decap_8
X_12254_ _12254_/Y _12820_/S _12253_/X _12294_/B1 VPWR VGND sg13g2_o21ai_1
XFILLER_107_372 VPWR VGND sg13g2_decap_8
XFILLER_68_1464 VPWR VGND sg13g2_decap_4
X_11205_ _11255_/B _11205_/A _14591_/A VPWR VGND sg13g2_nand2_1
XFILLER_9_1509 VPWR VGND sg13g2_decap_8
X_19850_ _19850_/Y _19850_/A _19850_/B VPWR VGND sg13g2_nor2_1
X_12185_ _24252_/A _14871_/A _14871_/B VPWR VGND sg13g2_and2_1
XFILLER_81_1620 VPWR VGND sg13g2_fill_1
XFILLER_81_1631 VPWR VGND sg13g2_decap_4
X_18801_ _23034_/D _18801_/A _18801_/B _18801_/C VPWR VGND sg13g2_nand3_1
XFILLER_68_407 VPWR VGND sg13g2_decap_4
XFILLER_110_515 VPWR VGND sg13g2_decap_8
X_19781_ _19781_/Y _20310_/A3 _19781_/A2 _19781_/B1 _20310_/A1 _19782_/A1 VPWR VGND
+ sg13g2_a221oi_1
X_16993_ _17008_/D _16993_/A _16993_/B _16993_/C VPWR VGND sg13g2_nor3_1
XFILLER_89_790 VPWR VGND sg13g2_decap_8
XFILLER_49_632 VPWR VGND sg13g2_decap_8
X_18732_ _18732_/Y _18732_/A VPWR VGND sg13g2_inv_1
XFILLER_49_643 VPWR VGND sg13g2_decap_8
XFILLER_62_1063 VPWR VGND sg13g2_fill_2
XFILLER_7_1255 VPWR VGND sg13g2_decap_8
X_15944_ _15949_/B _15944_/A _15944_/B VPWR VGND sg13g2_or2_1
XFILLER_23_1047 VPWR VGND sg13g2_decap_8
XFILLER_48_153 VPWR VGND sg13g2_fill_1
X_15875_ _15882_/A _22935_/Q _15897_/A2 _15874_/Y VPWR VGND sg13g2_a21oi_1
X_18663_ _23011_/D _14935_/Y _14940_/Y _18662_/Y _18651_/B VPWR VGND sg13g2_a22oi_1
XFILLER_37_838 VPWR VGND sg13g2_fill_2
XFILLER_76_473 VPWR VGND sg13g2_decap_8
XFILLER_40_1350 VPWR VGND sg13g2_fill_1
XFILLER_97_1148 VPWR VGND sg13g2_decap_8
XFILLER_97_1159 VPWR VGND sg13g2_fill_1
X_14826_ _14826_/X _17838_/B _14882_/B VPWR VGND sg13g2_xor2_1
X_17614_ _17615_/B _22554_/Q _22553_/Q _17624_/D VPWR VGND sg13g2_nand3_1
XFILLER_40_1383 VPWR VGND sg13g2_decap_8
XFILLER_52_808 VPWR VGND sg13g2_fill_2
XFILLER_17_562 VPWR VGND sg13g2_decap_8
XFILLER_75_1424 VPWR VGND sg13g2_fill_1
X_17545_ _17642_/B _15182_/X _17835_/B _16031_/Y VPWR VGND sg13g2_a21o_1
X_11969_ _11969_/X _12004_/S _23898_/Q VPWR VGND sg13g2_and2_1
XFILLER_32_532 VPWR VGND sg13g2_fill_1
XFILLER_44_392 VPWR VGND sg13g2_decap_4
X_13708_ _13708_/Y _13707_/X _13708_/B VPWR VGND sg13g2_nand2b_1
X_17476_ _22855_/D _17476_/A1 _17475_/B _17475_/Y VPWR VGND sg13g2_o21ai_1
X_14688_ _14688_/X _14685_/X _14687_/Y _14732_/S VPWR VGND sg13g2_mux2_1
X_19215_ _19215_/Y _19215_/A _19234_/S VPWR VGND sg13g2_nand2_1
X_13639_ _13639_/X _23439_/Q _23503_/Q _23599_/Q _23663_/Q _13643_/S _13639_/S1 VPWR
+ VGND sg13g2_mux4_1
X_16427_ _16427_/Y _22581_/Q _16431_/B VPWR VGND sg13g2_nand2_1
XFILLER_18_1897 VPWR VGND sg13g2_decap_8
XFILLER_105_1856 VPWR VGND sg13g2_decap_8
X_19146_ _23122_/D _23122_/Q _19006_/A _19149_/S VPWR VGND sg13g2_mux2_1
XFILLER_34_1165 VPWR VGND sg13g2_fill_1
X_16358_ _16358_/Y _22544_/Q _16425_/B _16357_/Y VPWR VGND sg13g2_a21oi_1
XFILLER_30_1018 VPWR VGND sg13g2_fill_2
XFILLER_9_783 VPWR VGND sg13g2_decap_8
XFILLER_30_1029 VPWR VGND sg13g2_fill_2
X_15309_ _15309_/Y _15309_/A _15353_/A VPWR VGND sg13g2_nor2_2
X_16289_ _16298_/C _16289_/A _16321_/C _16321_/D VPWR VGND sg13g2_nor3_2
X_19077_ _19077_/X _18856_/A _23107_/Q _19077_/S VPWR VGND sg13g2_mux2_1
XFILLER_51_1490 VPWR VGND sg13g2_fill_1
XFILLER_12_1452 VPWR VGND sg13g2_decap_4
XFILLER_105_309 VPWR VGND sg13g2_decap_8
X_18028_ _18028_/Y _24225_/Q _23046_/Q _14465_/Y VPWR VGND sg13g2_a21oi_1
Xhold4706 _17369_/A _22812_/Q VPWR VGND sg13g2_dlygate4sd3_1
XFILLER_99_510 VPWR VGND sg13g2_decap_4
Xhold4717 _20903_/A _23498_/Q VPWR VGND sg13g2_dlygate4sd3_1
Xhold4728 _21767_/A _23884_/Q VPWR VGND sg13g2_dlygate4sd3_1
Xhold4739 _22082_/A _24033_/Q VPWR VGND sg13g2_dlygate4sd3_1
XFILLER_114_865 VPWR VGND sg13g2_decap_8
XFILLER_99_565 VPWR VGND sg13g2_decap_8
XFILLER_115_28 VPWR VGND sg13g2_decap_8
X_19979_ _19979_/Y _20162_/A _19978_/A _19978_/Y VPWR VGND sg13g2_a21oi_1
XFILLER_113_386 VPWR VGND sg13g2_decap_8
XFILLER_101_537 VPWR VGND sg13g2_decap_8
XFILLER_112_1805 VPWR VGND sg13g2_decap_8
X_22990_ _22990_/Q clkload13/A _22990_/D fanout2915/X VPWR VGND sg13g2_dfrbpq_1
XFILLER_67_440 VPWR VGND sg13g2_fill_1
XFILLER_68_963 VPWR VGND sg13g2_decap_8
XFILLER_83_911 VPWR VGND sg13g2_decap_8
XFILLER_67_462 VPWR VGND sg13g2_decap_8
X_21941_ _23965_/D _21941_/A1 _21942_/B _21940_/Y VPWR VGND sg13g2_o21ai_1
XFILLER_82_410 VPWR VGND sg13g2_fill_1
XFILLER_55_635 VPWR VGND sg13g2_decap_8
XFILLER_54_134 VPWR VGND sg13g2_fill_2
X_21872_ _23932_/D _21938_/A1 _21876_/B _21871_/Y VPWR VGND sg13g2_o21ai_1
XFILLER_110_1562 VPWR VGND sg13g2_decap_8
X_23611_ _23611_/Q clkload59/A _23611_/D fanout2788/X VPWR VGND sg13g2_dfrbpq_1
X_20823_ _20823_/Y _20823_/A _20841_/B VPWR VGND sg13g2_nand2_1
XFILLER_58_1644 VPWR VGND sg13g2_decap_4
XFILLER_70_638 VPWR VGND sg13g2_fill_2
XFILLER_19_1617 VPWR VGND sg13g2_fill_1
XFILLER_63_690 VPWR VGND sg13g2_decap_4
X_23542_ _23542_/Q clkload46/A _23542_/D fanout2677/X VPWR VGND sg13g2_dfrbpq_1
X_20754_ _20754_/Y _20754_/A _20768_/B VPWR VGND sg13g2_nand2_1
XFILLER_24_36 VPWR VGND sg13g2_fill_1
XFILLER_23_565 VPWR VGND sg13g2_fill_1
XFILLER_11_716 VPWR VGND sg13g2_decap_8
XFILLER_50_362 VPWR VGND sg13g2_fill_1
XFILLER_50_373 VPWR VGND sg13g2_decap_4
X_23473_ _23473_/Q _24113_/CLK _23473_/D fanout2682/X VPWR VGND sg13g2_dfrbpq_1
XFILLER_11_738 VPWR VGND sg13g2_decap_8
X_20685_ _23395_/D _20685_/A1 _20704_/B _20684_/Y VPWR VGND sg13g2_o21ai_1
XFILLER_50_384 VPWR VGND sg13g2_decap_8
XFILLER_91_1292 VPWR VGND sg13g2_fill_1
XFILLER_13_1205 VPWR VGND sg13g2_fill_1
XFILLER_52_1254 VPWR VGND sg13g2_decap_4
X_22424_ _22424_/Y _22424_/A _22424_/B VPWR VGND sg13g2_nand2_1
XFILLER_109_615 VPWR VGND sg13g2_decap_8
XFILLER_6_219 VPWR VGND sg13g2_decap_4
XFILLER_13_1249 VPWR VGND sg13g2_decap_8
XFILLER_100_1208 VPWR VGND sg13g2_decap_4
XFILLER_104_1377 VPWR VGND sg13g2_decap_8
X_22355_ _22355_/Y _22355_/A _22374_/B VPWR VGND sg13g2_nand2_1
XFILLER_104_1388 VPWR VGND sg13g2_fill_1
XFILLER_108_147 VPWR VGND sg13g2_decap_8
XFILLER_40_68 VPWR VGND sg13g2_fill_1
XFILLER_30_1563 VPWR VGND sg13g2_decap_8
X_21306_ _21306_/Y _21306_/A _21313_/B VPWR VGND sg13g2_nand2_1
X_22286_ _24130_/D _22286_/A1 _22285_/B _22285_/Y VPWR VGND sg13g2_o21ai_1
X_24025_ _24025_/Q clkload46/A _24025_/D fanout2748/X VPWR VGND sg13g2_dfrbpq_1
X_21237_ _23641_/D _21237_/A1 _21247_/B _21236_/Y VPWR VGND sg13g2_o21ai_1
XFILLER_65_1637 VPWR VGND sg13g2_decap_8
XFILLER_78_716 VPWR VGND sg13g2_fill_2
XFILLER_78_727 VPWR VGND sg13g2_decap_8
XFILLER_105_898 VPWR VGND sg13g2_decap_8
XFILLER_78_738 VPWR VGND sg13g2_fill_1
XFILLER_104_386 VPWR VGND sg13g2_fill_2
XFILLER_78_749 VPWR VGND sg13g2_decap_8
XFILLER_8_1531 VPWR VGND sg13g2_decap_8
XFILLER_28_1470 VPWR VGND sg13g2_decap_4
XFILLER_59_930 VPWR VGND sg13g2_fill_2
Xclkbuf_leaf_9_clk_i clkload27/A clkbuf_leaf_9_clk_i/A VPWR VGND sg13g2_buf_16
XFILLER_28_1492 VPWR VGND sg13g2_decap_8
XFILLER_59_952 VPWR VGND sg13g2_fill_1
XFILLER_63_1372 VPWR VGND sg13g2_decap_8
X_20119_ _20120_/B _20113_/Y _19803_/B _19861_/B _20118_/Y VPWR VGND sg13g2_a22oi_1
X_21099_ _21099_/Y _23576_/Q _21099_/B VPWR VGND sg13g2_nand2_1
XFILLER_59_974 VPWR VGND sg13g2_decap_8
XFILLER_115_1462 VPWR VGND sg13g2_decap_8
XFILLER_98_1413 VPWR VGND sg13g2_fill_1
XFILLER_8_1597 VPWR VGND sg13g2_decap_4
XFILLER_86_782 VPWR VGND sg13g2_decap_4
X_12941_ _24261_/A _14064_/A VPWR VGND sg13g2_inv_1
XFILLER_18_315 VPWR VGND sg13g2_fill_1
XFILLER_58_484 VPWR VGND sg13g2_decap_4
XFILLER_100_581 VPWR VGND sg13g2_decap_8
XFILLER_45_112 VPWR VGND sg13g2_fill_2
XFILLER_111_1348 VPWR VGND sg13g2_decap_8
XFILLER_59_1408 VPWR VGND sg13g2_decap_4
X_15660_ _15661_/B _22466_/Q _15945_/A2 _15991_/A2 _22765_/Q VPWR VGND sg13g2_a22oi_1
XFILLER_65_65 VPWR VGND sg13g2_fill_1
X_12872_ _12873_/B _23461_/Q _23525_/Q _23621_/Q _23685_/Q _12733_/S _12982_/S1 VPWR
+ VGND sg13g2_mux4_1
XFILLER_41_1692 VPWR VGND sg13g2_fill_2
XFILLER_45_145 VPWR VGND sg13g2_fill_2
XFILLER_33_307 VPWR VGND sg13g2_decap_8
X_14611_ _24217_/D _14602_/D _14609_/Y _14610_/Y VPWR VGND sg13g2_o21ai_1
XFILLER_61_616 VPWR VGND sg13g2_fill_2
X_11823_ _11823_/X _24025_/Q _24057_/Q _12062_/A VPWR VGND sg13g2_mux2_1
X_23809_ _23809_/Q clkload43/A _23809_/D fanout2739/X VPWR VGND sg13g2_dfrbpq_1
X_15591_ _16105_/A _23010_/Q _22560_/Q _15591_/S VPWR VGND sg13g2_mux2_1
XFILLER_27_893 VPWR VGND sg13g2_fill_1
XFILLER_37_1706 VPWR VGND sg13g2_decap_8
XFILLER_42_830 VPWR VGND sg13g2_fill_1
XFILLER_42_841 VPWR VGND sg13g2_decap_8
X_17330_ _22792_/D _17866_/A _17366_/S _17329_/Y VPWR VGND sg13g2_o21ai_1
XFILLER_81_31 VPWR VGND sg13g2_decap_4
X_11754_ _11754_/Y _11379_/Y _11753_/Y _11754_/B1 VPWR VGND sg13g2_a21oi_1
XFILLER_14_554 VPWR VGND sg13g2_decap_8
XFILLER_41_351 VPWR VGND sg13g2_decap_4
XFILLER_92_1078 VPWR VGND sg13g2_decap_8
XFILLER_41_362 VPWR VGND sg13g2_decap_4
X_17261_ _22760_/D _17866_/A _17270_/B _17260_/Y VPWR VGND sg13g2_o21ai_1
XFILLER_50_1906 VPWR VGND sg13g2_decap_8
X_19000_ _19002_/B _18997_/Y _19001_/C VPWR VGND sg13g2_nand2b_1
XFILLER_70_1343 VPWR VGND sg13g2_decap_4
X_13424_ _13424_/X _24044_/Q _24076_/Q _13589_/B VPWR VGND sg13g2_mux2_1
X_17192_ _17192_/Y _17192_/A _17197_/B VPWR VGND sg13g2_nor2_1
X_16143_ _16143_/Y _22501_/Q _16187_/B _16142_/Y VPWR VGND sg13g2_a21oi_1
X_13355_ _13355_/X _13528_/A _13356_/C VPWR VGND sg13g2_and2_1
XFILLER_6_742 VPWR VGND sg13g2_decap_4
XFILLER_115_607 VPWR VGND sg13g2_decap_8
X_12306_ _12306_/X _23742_/Q _23806_/Q _23870_/Q _23966_/Q _12193_/S _12015_/S VPWR
+ VGND sg13g2_mux4_1
XFILLER_100_1731 VPWR VGND sg13g2_fill_1
X_16074_ _22489_/D _16073_/B _16072_/Y _16073_/Y VPWR VGND sg13g2_o21ai_1
XFILLER_53_7 VPWR VGND sg13g2_decap_8
X_13286_ _13286_/Y _14060_/A _13368_/A VPWR VGND sg13g2_nor2_1
X_19902_ _19903_/B _19902_/A1 _20319_/B _19956_/A VPWR VGND sg13g2_a21oi_1
X_15025_ _15028_/A _24267_/A _15025_/B VPWR VGND sg13g2_nand2_1
X_12237_ _12238_/B _23837_/Q _23869_/Q _12239_/S VPWR VGND sg13g2_mux2_1
XFILLER_100_1797 VPWR VGND sg13g2_decap_8
XFILLER_48_1857 VPWR VGND sg13g2_decap_8
XFILLER_48_1868 VPWR VGND sg13g2_fill_2
XFILLER_9_1328 VPWR VGND sg13g2_decap_4
X_19833_ _19936_/B _19987_/A _19568_/B _19541_/A VPWR VGND sg13g2_a21o_1
X_12168_ _12168_/Y _13165_/A1 _12165_/Y _12167_/Y _13675_/A1 _11921_/A VPWR VGND sg13g2_a221oi_1
XFILLER_2_981 VPWR VGND sg13g2_decap_4
XFILLER_111_835 VPWR VGND sg13g2_decap_8
XFILLER_1_480 VPWR VGND sg13g2_fill_1
XFILLER_96_557 VPWR VGND sg13g2_decap_8
X_19764_ _19764_/Y _19764_/A _19764_/B VPWR VGND sg13g2_nand2_1
XFILLER_42_1423 VPWR VGND sg13g2_decap_4
X_12099_ _19373_/A _12099_/A _12099_/B VPWR VGND sg13g2_and2_2
X_16976_ _16977_/B _17019_/A _16976_/B VPWR VGND sg13g2_nor2_1
XFILLER_110_367 VPWR VGND sg13g2_decap_8
XFILLER_65_911 VPWR VGND sg13g2_decap_8
XFILLER_77_771 VPWR VGND sg13g2_fill_1
X_18715_ _18723_/B _18719_/B VPWR VGND sg13g2_inv_1
X_15927_ _15928_/C _15926_/Y _15972_/B VPWR VGND sg13g2_nand2b_1
X_19695_ _19695_/Y _19638_/S _19553_/X _19694_/Y VPWR VGND sg13g2_a21oi_1
XFILLER_25_808 VPWR VGND sg13g2_decap_8
X_18646_ _18646_/Y _23007_/Q _18646_/B VPWR VGND sg13g2_xnor2_1
XFILLER_37_668 VPWR VGND sg13g2_fill_2
XFILLER_80_903 VPWR VGND sg13g2_fill_2
X_15858_ _15859_/B _22708_/Q _15898_/A2 _15898_/B1 _22644_/Q VPWR VGND sg13g2_a22oi_1
XFILLER_64_454 VPWR VGND sg13g2_fill_2
XFILLER_111_1871 VPWR VGND sg13g2_decap_8
XFILLER_94_1811 VPWR VGND sg13g2_decap_8
XFILLER_52_605 VPWR VGND sg13g2_decap_8
XFILLER_80_925 VPWR VGND sg13g2_decap_4
XFILLER_0_1837 VPWR VGND sg13g2_decap_4
X_14809_ _14809_/Y _14809_/A VPWR VGND sg13g2_inv_1
XFILLER_17_370 VPWR VGND sg13g2_decap_8
XFILLER_45_690 VPWR VGND sg13g2_fill_2
X_15789_ _15798_/C _22861_/Q _16005_/B _15986_/C1 VPWR VGND sg13g2_a21oi_1
XFILLER_75_1243 VPWR VGND sg13g2_decap_8
X_17528_ _17528_/Y _22877_/Q _17528_/B VPWR VGND sg13g2_nand2_1
XFILLER_51_159 VPWR VGND sg13g2_fill_1
XFILLER_18_1650 VPWR VGND sg13g2_decap_4
XFILLER_53_1541 VPWR VGND sg13g2_decap_4
Xrebuffer5503 _13883_/D rebuffer5504/X VPWR VGND sg13g2_buf_1
Xrebuffer5514 _11200_/D _11315_/D VPWR VGND sg13g2_buf_1
Xplace3801 _14296_/A2 _11938_/Y VPWR VGND sg13g2_buf_1
XFILLER_14_1525 VPWR VGND sg13g2_fill_2
Xrebuffer5525 rebuffer5525/X rebuffer5526/X VPWR VGND sg13g2_buf_1
Xrebuffer5536 rebuffer5536/X rebuffer5537/X VPWR VGND sg13g2_buf_1
X_20470_ _23296_/D _22414_/A1 _20473_/B _20469_/Y VPWR VGND sg13g2_o21ai_1
Xplace3812 _16023_/B _15633_/S VPWR VGND sg13g2_buf_1
Xplace3823 _14645_/A _13469_/Y VPWR VGND sg13g2_buf_8
Xrebuffer5547 rebuffer5547/X rebuffer5548/X VPWR VGND sg13g2_buf_1
Xrebuffer5558 _16251_/A _14890_/Y VPWR VGND sg13g2_buf_1
Xplace3834 _15905_/A _15690_/B VPWR VGND sg13g2_buf_1
Xplace3845 _13182_/B2 _12824_/B1 VPWR VGND sg13g2_buf_1
X_19129_ _23106_/D _23106_/Q _17941_/B _19134_/S VPWR VGND sg13g2_mux2_1
Xrebuffer5569 _13503_/B _12529_/Y VPWR VGND sg13g2_buf_1
XFILLER_69_1003 VPWR VGND sg13g2_decap_8
XFILLER_105_1697 VPWR VGND sg13g2_decap_8
Xplace3856 _17815_/B1 _17706_/X VPWR VGND sg13g2_buf_1
XFILLER_69_1014 VPWR VGND sg13g2_fill_2
Xhold5204 _21959_/A _23974_/Q VPWR VGND sg13g2_dlygate4sd3_1
Xplace3867 _13383_/A _12668_/A VPWR VGND sg13g2_buf_1
Xplace3878 _20100_/A1 _19913_/Y VPWR VGND sg13g2_buf_1
Xplace3889 _19134_/S _19130_/S VPWR VGND sg13g2_buf_1
X_22140_ _22140_/Y _22140_/A _22142_/B VPWR VGND sg13g2_nand2_1
XFILLER_106_629 VPWR VGND sg13g2_decap_8
XFILLER_12_1271 VPWR VGND sg13g2_decap_8
XFILLER_31_1894 VPWR VGND sg13g2_fill_2
X_22071_ _22071_/Y _22071_/A _22075_/B VPWR VGND sg13g2_nand2_1
XFILLER_114_662 VPWR VGND sg13g2_decap_8
XFILLER_87_502 VPWR VGND sg13g2_decap_8
XFILLER_102_813 VPWR VGND sg13g2_fill_1
X_21022_ _21022_/Y _21022_/A _21029_/B VPWR VGND sg13g2_nand2_1
XFILLER_113_161 VPWR VGND sg13g2_decap_8
XFILLER_43_1209 VPWR VGND sg13g2_decap_8
XFILLER_59_215 VPWR VGND sg13g2_decap_8
XFILLER_59_226 VPWR VGND sg13g2_fill_1
XFILLER_101_323 VPWR VGND sg13g2_decap_4
XFILLER_74_207 VPWR VGND sg13g2_decap_8
XFILLER_19_58 VPWR VGND sg13g2_fill_2
XFILLER_28_624 VPWR VGND sg13g2_decap_8
X_22973_ _22973_/Q clkload16/A _22973_/D fanout2920/X VPWR VGND sg13g2_dfrbpq_1
XFILLER_83_730 VPWR VGND sg13g2_decap_4
XFILLER_25_1698 VPWR VGND sg13g2_decap_4
XFILLER_67_292 VPWR VGND sg13g2_fill_2
X_21924_ _23957_/D _21924_/A1 _21965_/S _21923_/Y VPWR VGND sg13g2_o21ai_1
XFILLER_99_1799 VPWR VGND sg13g2_decap_8
XFILLER_28_679 VPWR VGND sg13g2_decap_4
XFILLER_3_1483 VPWR VGND sg13g2_decap_8
XFILLER_55_476 VPWR VGND sg13g2_fill_1
XFILLER_93_1310 VPWR VGND sg13g2_decap_8
Xinput4402 _20349_/A2 data_rdata_i[31] VPWR VGND sg13g2_buf_1
XFILLER_27_189 VPWR VGND sg13g2_fill_1
Xinput4413 _18595_/A1 instr_err_i VPWR VGND sg13g2_buf_1
Xinput4424 _18895_/B instr_rdata_i[18] VPWR VGND sg13g2_buf_1
Xinput4435 _19006_/A instr_rdata_i[28] VPWR VGND sg13g2_buf_1
XFILLER_24_841 VPWR VGND sg13g2_fill_1
X_20806_ _23452_/D _21309_/A1 _20809_/B _20805_/Y VPWR VGND sg13g2_o21ai_1
XFILLER_19_1425 VPWR VGND sg13g2_decap_8
Xinput4446 _19126_/A1 instr_rdata_i[9] VPWR VGND sg13g2_buf_1
XFILLER_70_468 VPWR VGND sg13g2_decap_8
XFILLER_19_1436 VPWR VGND sg13g2_decap_8
Xinput4457 _15742_/B2 irqs_i[3] VPWR VGND sg13g2_buf_1
XFILLER_54_1327 VPWR VGND sg13g2_decap_8
X_23525_ _23525_/Q clkload42/A _23525_/D fanout2718/X VPWR VGND sg13g2_dfrbpq_1
XFILLER_106_1428 VPWR VGND sg13g2_fill_2
X_20737_ _23419_/D _21307_/A1 _20742_/B _20736_/Y VPWR VGND sg13g2_o21ai_1
XFILLER_11_535 VPWR VGND sg13g2_decap_8
XFILLER_106_1439 VPWR VGND sg13g2_fill_2
XFILLER_11_557 VPWR VGND sg13g2_decap_8
XFILLER_32_1614 VPWR VGND sg13g2_decap_8
X_11470_ _11470_/Y _23478_/Q _11706_/S VPWR VGND sg13g2_nand2b_1
XFILLER_11_568 VPWR VGND sg13g2_fill_2
X_23456_ _23456_/Q clkload40/A _23456_/D fanout2736/X VPWR VGND sg13g2_dfrbpq_1
XFILLER_52_1051 VPWR VGND sg13g2_decap_8
X_20668_ _20668_/Y _20668_/A _20673_/B VPWR VGND sg13g2_nand2_1
XFILLER_13_1013 VPWR VGND sg13g2_fill_1
XFILLER_104_1152 VPWR VGND sg13g2_decap_4
X_22407_ _24189_/D _22407_/A1 _22408_/B _22406_/Y VPWR VGND sg13g2_o21ai_1
X_23387_ _23387_/Q clkload54/A _23387_/D fanout2771/X VPWR VGND sg13g2_dfrbpq_1
XFILLER_87_1125 VPWR VGND sg13g2_decap_8
X_20599_ _23354_/D _19817_/Y _20600_/B _20598_/Y VPWR VGND sg13g2_o21ai_1
X_13140_ _13146_/B _13632_/A _13140_/B VPWR VGND sg13g2_nor2_1
XFILLER_109_489 VPWR VGND sg13g2_decap_8
X_22338_ _24156_/D _22405_/A1 _22341_/B _22337_/Y VPWR VGND sg13g2_o21ai_1
X_13071_ _13071_/Y _13434_/A _13071_/B _20134_/A VPWR VGND sg13g2_nor3_1
X_22269_ _22269_/Y _24123_/Q _22269_/B VPWR VGND sg13g2_nand2_1
XFILLER_105_662 VPWR VGND sg13g2_decap_4
X_12022_ _12023_/B _23579_/Q _23643_/Q _12191_/S VPWR VGND sg13g2_mux2_1
X_24008_ _24008_/Q clkload32/A _24008_/D fanout2648/X VPWR VGND sg13g2_dfrbpq_1
XFILLER_104_150 VPWR VGND sg13g2_decap_8
XFILLER_61_1309 VPWR VGND sg13g2_fill_1
XFILLER_78_557 VPWR VGND sg13g2_decap_8
X_16830_ _16830_/Y _16830_/A _16830_/B VPWR VGND sg13g2_nand2_1
XFILLER_24_1120 VPWR VGND sg13g2_decap_8
XFILLER_93_516 VPWR VGND sg13g2_fill_1
XFILLER_43_1754 VPWR VGND sg13g2_decap_8
XFILLER_76_53 VPWR VGND sg13g2_decap_8
XFILLER_19_602 VPWR VGND sg13g2_fill_2
X_16761_ _22667_/D _17476_/A1 _16760_/A _16760_/Y VPWR VGND sg13g2_a21oi_1
X_13973_ _13973_/X _23924_/Q _24020_/Q _24116_/Q _24148_/Q _13974_/S _17718_/B2 VPWR
+ VGND sg13g2_mux4_1
XFILLER_101_890 VPWR VGND sg13g2_fill_1
XFILLER_20_1006 VPWR VGND sg13g2_fill_1
XFILLER_86_590 VPWR VGND sg13g2_fill_1
XFILLER_4_1247 VPWR VGND sg13g2_decap_8
X_18500_ _18500_/Y _18144_/Y _18494_/B _18499_/Y _18553_/A1 _18562_/A VPWR VGND sg13g2_a221oi_1
XFILLER_47_955 VPWR VGND sg13g2_decap_8
XFILLER_98_1254 VPWR VGND sg13g2_decap_4
X_12924_ _12924_/Y _12042_/B _12915_/X _12920_/Y _12923_/Y _13008_/B VPWR VGND sg13g2_a221oi_1
XFILLER_46_443 VPWR VGND sg13g2_fill_2
X_15712_ _20140_/A _15712_/A _15712_/B _15712_/C _15712_/D VPWR VGND sg13g2_nor4_1
X_16692_ _16692_/Y _16707_/A _16692_/B VPWR VGND sg13g2_nor2_1
X_19480_ _19483_/B _19608_/A _19480_/B _19480_/C VPWR VGND sg13g2_nand3b_1
XFILLER_59_1216 VPWR VGND sg13g2_fill_2
XFILLER_47_999 VPWR VGND sg13g2_fill_2
XFILLER_46_476 VPWR VGND sg13g2_decap_8
XFILLER_61_402 VPWR VGND sg13g2_decap_8
XFILLER_94_1129 VPWR VGND sg13g2_fill_1
X_18431_ _18431_/Y _18103_/B _18421_/B _18430_/Y VPWR VGND sg13g2_o21ai_1
X_15643_ _15643_/Y _22730_/Q _15708_/A2 _15731_/B1 _22666_/Q VPWR VGND sg13g2_a22oi_1
XFILLER_18_189 VPWR VGND sg13g2_decap_8
X_12855_ _13503_/A _12855_/A1 _12855_/A2 _12854_/Y VPWR VGND sg13g2_a21oi_2
XFILLER_73_284 VPWR VGND sg13g2_decap_8
XFILLER_33_126 VPWR VGND sg13g2_decap_8
XFILLER_15_841 VPWR VGND sg13g2_fill_1
X_11806_ _11807_/B _23737_/Q _23865_/Q _11810_/S VPWR VGND sg13g2_mux2_1
X_15574_ _15578_/B _22761_/Q _17234_/A _17303_/A _22793_/Q VPWR VGND sg13g2_a22oi_1
X_18362_ _18362_/Y _18361_/B _18379_/B _18344_/B _18361_/Y VPWR VGND sg13g2_a22oi_1
X_12786_ _12786_/Y _14189_/A _12785_/Y _12782_/A VPWR VGND sg13g2_a21oi_1
XFILLER_61_479 VPWR VGND sg13g2_decap_8
XFILLER_14_362 VPWR VGND sg13g2_decap_8
X_17313_ _17313_/Y _17313_/A _17351_/B VPWR VGND sg13g2_nand2_1
X_11737_ _11737_/X _23896_/Q _23992_/Q _11737_/S VPWR VGND sg13g2_mux2_1
XFILLER_25_90 VPWR VGND sg13g2_fill_1
X_18293_ _22975_/D _18292_/Y _22975_/Q _18565_/B VPWR VGND sg13g2_mux2_1
XFILLER_54_1861 VPWR VGND sg13g2_decap_8
XFILLER_41_192 VPWR VGND sg13g2_decap_8
XFILLER_106_1951 VPWR VGND sg13g2_decap_4
Xplace3108 _21313_/B _21308_/B VPWR VGND sg13g2_buf_1
X_14456_ _14596_/C _14571_/A _14273_/Y _14455_/Y VPWR VGND sg13g2_o21ai_1
XFILLER_50_1714 VPWR VGND sg13g2_fill_2
X_17244_ _17244_/Y _17244_/A _17266_/B VPWR VGND sg13g2_nand2_1
X_11668_ _11867_/D _14019_/B _14028_/B _19361_/A VPWR VGND sg13g2_nand3b_1
XFILLER_54_1894 VPWR VGND sg13g2_fill_2
Xplace3119 _21281_/B _21287_/B VPWR VGND sg13g2_buf_1
XFILLER_89_1913 VPWR VGND sg13g2_decap_8
X_17175_ _17175_/Y _17175_/A _17209_/B VPWR VGND sg13g2_nor2_1
XFILLER_15_1878 VPWR VGND sg13g2_decap_8
X_14387_ _14387_/Y _22748_/Q _14387_/B _19928_/B VPWR VGND sg13g2_nand3_1
XFILLER_50_1769 VPWR VGND sg13g2_fill_1
X_11599_ _11599_/Y _14117_/A _14119_/B _11599_/C VPWR VGND sg13g2_nand3_1
XFILLER_115_404 VPWR VGND sg13g2_decap_8
X_16126_ _16126_/Y _16126_/A _16199_/B VPWR VGND sg13g2_nand2_1
XFILLER_31_1179 VPWR VGND sg13g2_fill_1
XFILLER_13_1580 VPWR VGND sg13g2_decap_4
X_13338_ _13338_/X _23595_/Q _23627_/Q _23659_/Q _23691_/Q _13701_/S0 _11493_/A VPWR
+ VGND sg13g2_mux4_1
XFILLER_48_1610 VPWR VGND sg13g2_fill_1
X_16057_ _22485_/D _17386_/B _16055_/Y _16056_/Y VPWR VGND sg13g2_o21ai_1
X_13269_ _13269_/X _23306_/Q _23338_/Q _23370_/Q _23402_/Q _13555_/S0 _13270_/S1 VPWR
+ VGND sg13g2_mux4_1
XFILLER_102_109 VPWR VGND sg13g2_fill_1
XFILLER_83_1545 VPWR VGND sg13g2_decap_8
X_15008_ _15008_/Y _15068_/A _15008_/B _15008_/C VPWR VGND sg13g2_nand3_1
XFILLER_48_1665 VPWR VGND sg13g2_decap_4
XFILLER_97_844 VPWR VGND sg13g2_decap_4
XFILLER_96_321 VPWR VGND sg13g2_decap_8
XFILLER_44_1529 VPWR VGND sg13g2_fill_2
XFILLER_111_632 VPWR VGND sg13g2_decap_8
XFILLER_96_332 VPWR VGND sg13g2_fill_1
X_19816_ _19816_/Y _19814_/Y _19815_/Y _19946_/C1 VPWR VGND sg13g2_a21oi_1
Xfanout2770 fanout2770/X fanout2780/X VPWR VGND sg13g2_buf_1
Xfanout2781 fanout2781/X fanout2790/X VPWR VGND sg13g2_buf_1
XFILLER_97_888 VPWR VGND sg13g2_decap_8
Xfanout2792 fanout2792/X wire1182/X VPWR VGND sg13g2_buf_1
XFILLER_81_1280 VPWR VGND sg13g2_decap_4
XFILLER_38_922 VPWR VGND sg13g2_decap_4
XFILLER_110_175 VPWR VGND sg13g2_decap_8
X_19747_ _19747_/Y _19744_/Y _19746_/Y _20350_/A VPWR VGND sg13g2_o21ai_1
XFILLER_42_1264 VPWR VGND sg13g2_fill_1
X_16959_ _16975_/A _22701_/Q _16980_/C VPWR VGND sg13g2_and2_1
XFILLER_37_421 VPWR VGND sg13g2_decap_8
XFILLER_38_955 VPWR VGND sg13g2_decap_8
XFILLER_38_966 VPWR VGND sg13g2_fill_1
XFILLER_42_1297 VPWR VGND sg13g2_decap_4
X_19678_ _19678_/Y _19678_/A VPWR VGND sg13g2_inv_1
XFILLER_96_1939 VPWR VGND sg13g2_decap_8
XFILLER_4_1781 VPWR VGND sg13g2_decap_8
XFILLER_24_104 VPWR VGND sg13g2_fill_2
X_18629_ _18637_/B _23003_/Q _23004_/Q _18629_/C VPWR VGND sg13g2_and3_1
XFILLER_0_1645 VPWR VGND sg13g2_fill_1
XFILLER_80_744 VPWR VGND sg13g2_decap_8
XFILLER_18_690 VPWR VGND sg13g2_decap_8
XFILLER_52_446 VPWR VGND sg13g2_fill_1
XFILLER_53_969 VPWR VGND sg13g2_decap_8
XFILLER_80_766 VPWR VGND sg13g2_fill_1
X_21640_ _21640_/Y _21640_/A _21642_/B VPWR VGND sg13g2_nand2_1
XFILLER_52_468 VPWR VGND sg13g2_fill_1
X_21571_ _23801_/D _21932_/A1 _21581_/B _21570_/Y VPWR VGND sg13g2_o21ai_1
Xplace4310 _12819_/S0 _12453_/S VPWR VGND sg13g2_buf_4
Xplace4321 _12239_/S _11749_/S VPWR VGND sg13g2_buf_4
X_23310_ _23310_/Q clkload35/A _23310_/D fanout2632/X VPWR VGND sg13g2_dfrbpq_1
XFILLER_32_192 VPWR VGND sg13g2_fill_2
XFILLER_33_1923 VPWR VGND sg13g2_decap_8
Xrebuffer5300 _14427_/A _20308_/A VPWR VGND sg13g2_buf_8
X_20522_ _20522_/Y _20522_/A _20533_/B VPWR VGND sg13g2_nand2_1
XFILLER_14_1311 VPWR VGND sg13g2_decap_8
Xplace4332 _19235_/B _22978_/Q VPWR VGND sg13g2_buf_1
Xrebuffer5311 _14083_/A _11574_/B1 VPWR VGND sg13g2_buf_1
Xrebuffer5322 _18672_/B _18742_/B VPWR VGND sg13g2_buf_1
Xplace4343 _11595_/A _22969_/Q VPWR VGND sg13g2_buf_2
XFILLER_21_888 VPWR VGND sg13g2_decap_8
Xplace3620 _19714_/S _19708_/S VPWR VGND sg13g2_buf_1
Xrebuffer5333 _13520_/B _13433_/A VPWR VGND sg13g2_buf_1
Xrebuffer5344 _11754_/B1 _11418_/Y VPWR VGND sg13g2_buf_8
Xrebuffer4610 _12002_/A rebuffer5430/X VPWR VGND sg13g2_buf_1
Xplace3631 _15662_/B1 _16681_/B VPWR VGND sg13g2_buf_1
X_23241_ _23241_/Q _24205_/CLK _23241_/D fanout2671/X VPWR VGND sg13g2_dfrbpq_1
Xrebuffer5355 _18602_/B _14553_/Y VPWR VGND sg13g2_buf_1
XFILLER_105_1472 VPWR VGND sg13g2_decap_4
Xplace3642 _14710_/B _14715_/B VPWR VGND sg13g2_buf_1
Xrebuffer5366 _12453_/S _22979_/Q VPWR VGND sg13g2_buf_16
Xrebuffer4621 _20117_/A _12952_/B VPWR VGND sg13g2_buf_1
Xplace3653 _17810_/A2 _17824_/A2 VPWR VGND sg13g2_buf_1
Xrebuffer4632 _14714_/A1 _13344_/Y VPWR VGND sg13g2_buf_1
Xrebuffer5377 _19331_/C _19480_/B VPWR VGND sg13g2_buf_1
XFILLER_101_1325 VPWR VGND sg13g2_decap_8
Xplace3664 _16209_/B _17386_/B VPWR VGND sg13g2_buf_1
XFILLER_88_1445 VPWR VGND sg13g2_fill_2
Xhold5001 _21064_/A _23563_/Q VPWR VGND sg13g2_dlygate4sd3_1
Xrebuffer5388 _12855_/A2 _12623_/A VPWR VGND sg13g2_buf_1
Xplace3675 _14936_/B _14826_/X VPWR VGND sg13g2_buf_1
Xhold5012 _21850_/A _23924_/Q VPWR VGND sg13g2_dlygate4sd3_1
Xplace2941 _21924_/A1 _21295_/A1 VPWR VGND sg13g2_buf_1
X_23172_ _23172_/Q _23187_/CLK _23172_/D fanout2918/X VPWR VGND sg13g2_dfrbpq_1
Xhold5023 _21657_/A _23842_/Q VPWR VGND sg13g2_dlygate4sd3_1
Xplace3686 _15884_/A _13733_/B VPWR VGND sg13g2_buf_2
XFILLER_107_949 VPWR VGND sg13g2_fill_1
Xplace2952 _18865_/B _18580_/X VPWR VGND sg13g2_buf_1
Xhold5034 _19215_/A _23172_/Q VPWR VGND sg13g2_dlygate4sd3_1
Xplace3697 _20290_/A _20292_/A VPWR VGND sg13g2_buf_1
X_20384_ _20384_/Y _23257_/Q _20395_/B VPWR VGND sg13g2_nand2_1
Xplace2963 _16413_/S _18667_/A VPWR VGND sg13g2_buf_1
Xhold5045 _21398_/A _23718_/Q VPWR VGND sg13g2_dlygate4sd3_1
Xplace2974 _18471_/S _18221_/S VPWR VGND sg13g2_buf_2
XFILLER_66_1710 VPWR VGND sg13g2_fill_2
X_22123_ _22123_/Y _22123_/A _22129_/B VPWR VGND sg13g2_nand2_1
Xclkbuf_4_8__f_clk_i clkbuf_4_8__f_clk_i/X clkbuf_3_4_0_clk_i/X VPWR VGND sg13g2_buf_8
Xplace2985 _16417_/B _14553_/Y VPWR VGND sg13g2_buf_2
Xhold5056 _20220_/A _23243_/Q VPWR VGND sg13g2_dlygate4sd3_1
XFILLER_106_459 VPWR VGND sg13g2_fill_1
Xhold5067 _21240_/A _23643_/Q VPWR VGND sg13g2_dlygate4sd3_1
Xclkbuf_leaf_74_clk_i clkload7/A clkbuf_leaf_0_clk_i/A VPWR VGND sg13g2_buf_16
XFILLER_82_1000 VPWR VGND sg13g2_decap_4
Xplace2996 _18889_/B _18587_/C VPWR VGND sg13g2_buf_1
Xhold5078 _20673_/A _23390_/Q VPWR VGND sg13g2_dlygate4sd3_1
Xhold5089 _21294_/A _23669_/Q VPWR VGND sg13g2_dlygate4sd3_1
XFILLER_82_1011 VPWR VGND sg13g2_decap_8
XFILLER_102_610 VPWR VGND sg13g2_decap_8
XFILLER_43_1017 VPWR VGND sg13g2_decap_4
XFILLER_82_1077 VPWR VGND sg13g2_decap_4
XFILLER_87_365 VPWR VGND sg13g2_decap_8
XFILLER_29_911 VPWR VGND sg13g2_decap_8
XFILLER_47_207 VPWR VGND sg13g2_decap_8
XFILLER_102_687 VPWR VGND sg13g2_decap_8
XFILLER_5_1523 VPWR VGND sg13g2_fill_2
XFILLER_25_1451 VPWR VGND sg13g2_decap_8
XFILLER_40_1927 VPWR VGND sg13g2_fill_1
XFILLER_21_1326 VPWR VGND sg13g2_decap_4
XFILLER_90_508 VPWR VGND sg13g2_decap_8
X_22956_ _22956_/Q _23187_/CLK _22956_/D fanout2917/X VPWR VGND sg13g2_dfrbpq_1
XFILLER_56_763 VPWR VGND sg13g2_decap_8
XFILLER_55_262 VPWR VGND sg13g2_fill_2
XFILLER_55_273 VPWR VGND sg13g2_fill_2
X_21907_ _21907_/Y _21907_/A _21910_/B VPWR VGND sg13g2_nand2_1
XFILLER_83_593 VPWR VGND sg13g2_decap_4
Xclkbuf_leaf_12_clk_i clkload19/A clkbuf_leaf_6_clk_i/A VPWR VGND sg13g2_buf_16
X_22887_ _22887_/Q clkload28/A _22887_/D fanout2870/X VPWR VGND sg13g2_dfrbpq_1
XFILLER_43_446 VPWR VGND sg13g2_decap_8
X_12640_ _12640_/Y _23169_/Q _12640_/B VPWR VGND sg13g2_nand2_1
XFILLER_31_608 VPWR VGND sg13g2_decap_4
X_21838_ _23916_/D _22305_/A1 _21843_/B _21837_/Y VPWR VGND sg13g2_o21ai_1
XFILLER_93_1151 VPWR VGND sg13g2_decap_8
XFILLER_43_479 VPWR VGND sg13g2_decap_8
XFILLER_102_84 VPWR VGND sg13g2_decap_8
XFILLER_70_265 VPWR VGND sg13g2_decap_8
XFILLER_52_991 VPWR VGND sg13g2_decap_8
XFILLER_54_1135 VPWR VGND sg13g2_decap_8
XFILLER_106_1203 VPWR VGND sg13g2_decap_8
XFILLER_24_693 VPWR VGND sg13g2_decap_4
X_12571_ _12572_/B _14189_/A _12569_/X _12570_/X _13266_/A1 VPWR VGND sg13g2_a22oi_1
X_21769_ _23885_/D _23885_/Q _21972_/A0 _21781_/S VPWR VGND sg13g2_mux2_1
XFILLER_11_321 VPWR VGND sg13g2_fill_1
X_14310_ _14340_/C _14346_/B _14346_/C _15262_/A _15227_/A VPWR VGND sg13g2_nor4_1
XFILLER_62_88 VPWR VGND sg13g2_fill_2
X_11522_ _11522_/X _11518_/X _11519_/X _11520_/X _11521_/X _13193_/S0 _11517_/S VPWR
+ VGND sg13g2_mux4_1
X_23508_ _23508_/Q _24210_/CLK _23508_/D fanout2635/X VPWR VGND sg13g2_dfrbpq_1
Xclkbuf_leaf_27_clk_i clkload51/A clkload3/A VPWR VGND sg13g2_buf_16
XFILLER_7_314 VPWR VGND sg13g2_fill_1
XFILLER_36_1591 VPWR VGND sg13g2_decap_8
X_14241_ _14242_/B _22943_/Q _15268_/A _17934_/C _14241_/D VPWR VGND sg13g2_nor4_1
X_23439_ _23439_/Q clkload31/A _23439_/D fanout2658/X VPWR VGND sg13g2_dfrbpq_1
X_11453_ _11454_/B _24022_/Q _24054_/Q _24086_/Q _24118_/Q _13701_/S0 _11726_/S VPWR
+ VGND sg13g2_mux4_1
XFILLER_109_231 VPWR VGND sg13g2_decap_8
X_14172_ _14174_/D _14263_/A _14172_/B VPWR VGND sg13g2_nor2_1
X_11384_ _11384_/Y _12285_/A _11915_/S VPWR VGND sg13g2_nor2_2
X_13123_ _13373_/B _13123_/A _13179_/B _13123_/C VPWR VGND sg13g2_and3_1
XFILLER_30_1190 VPWR VGND sg13g2_fill_1
X_18980_ _18980_/Y _18999_/A _18980_/B _18980_/C VPWR VGND sg13g2_nand3b_1
XFILLER_106_960 VPWR VGND sg13g2_decap_8
XFILLER_98_619 VPWR VGND sg13g2_fill_2
XFILLER_84_1854 VPWR VGND sg13g2_fill_2
X_17931_ _22941_/D _17931_/A _17931_/B VPWR VGND sg13g2_nand2_1
X_13054_ _13055_/D _11363_/B _13050_/X _13053_/X _13245_/B2 VPWR VGND sg13g2_a22oi_1
X_12005_ _12005_/Y _23899_/Q _13798_/A2 _12004_/X _12123_/A VPWR VGND sg13g2_a22oi_1
X_17862_ _17865_/A _17862_/A1 _17855_/A _17929_/B1 _17102_/A VPWR VGND sg13g2_a22oi_1
XFILLER_38_207 VPWR VGND sg13g2_decap_8
X_19601_ _19601_/Y _19605_/A _20356_/B _19600_/Y VPWR VGND sg13g2_a21oi_1
XFILLER_78_376 VPWR VGND sg13g2_decap_8
XFILLER_94_836 VPWR VGND sg13g2_fill_1
X_16813_ _16813_/X _22674_/Q _16813_/B VPWR VGND sg13g2_xor2_1
XFILLER_78_387 VPWR VGND sg13g2_fill_2
XFILLER_93_324 VPWR VGND sg13g2_fill_1
X_17793_ _17793_/Y _23183_/Q _17822_/A2 _17815_/B1 _22991_/Q VPWR VGND sg13g2_a22oi_1
XFILLER_19_421 VPWR VGND sg13g2_decap_4
XFILLER_93_346 VPWR VGND sg13g2_fill_1
XFILLER_93_357 VPWR VGND sg13g2_decap_8
XFILLER_19_443 VPWR VGND sg13g2_decap_8
XFILLER_47_763 VPWR VGND sg13g2_fill_1
X_13956_ _13957_/A _23924_/Q _14147_/C _13955_/X _13959_/S0 VPWR VGND sg13g2_a22oi_1
XFILLER_78_1636 VPWR VGND sg13g2_decap_8
XFILLER_35_925 VPWR VGND sg13g2_decap_8
XFILLER_74_582 VPWR VGND sg13g2_decap_8
X_19463_ _19464_/B _14021_/B _20356_/A _19463_/S VPWR VGND sg13g2_mux2_1
X_12907_ _12907_/Y _23973_/Q _12909_/B VPWR VGND sg13g2_nand2b_1
X_13887_ _13887_/X _24051_/Q _24083_/Q _24115_/Q _24147_/Q _13900_/S0 _13900_/S1 VPWR
+ VGND sg13g2_mux4_1
X_16675_ _16683_/C _22649_/Q _22648_/Q _22647_/Q _22650_/Q VPWR VGND sg13g2_nand4_1
XFILLER_34_435 VPWR VGND sg13g2_fill_1
XFILLER_61_232 VPWR VGND sg13g2_fill_1
XFILLER_61_243 VPWR VGND sg13g2_decap_8
XFILLER_62_766 VPWR VGND sg13g2_decap_8
XFILLER_34_468 VPWR VGND sg13g2_fill_2
X_12838_ _20063_/A _12726_/A _12838_/B VPWR VGND sg13g2_nand2b_2
X_19394_ _19394_/X _19703_/A _19394_/B VPWR VGND sg13g2_and2_1
XFILLER_62_788 VPWR VGND sg13g2_fill_1
XFILLER_76_1371 VPWR VGND sg13g2_fill_2
X_18345_ _18345_/Y _18377_/A _18405_/A _18071_/A VPWR VGND sg13g2_a21oi_1
X_15557_ _15558_/B _22726_/Q _15662_/A2 _15662_/B1 _22662_/Q VPWR VGND sg13g2_a22oi_1
X_12769_ _12769_/Y _12769_/A _14056_/A VPWR VGND sg13g2_xnor2_1
XFILLER_30_630 VPWR VGND sg13g2_fill_1
XFILLER_30_652 VPWR VGND sg13g2_decap_8
X_14508_ _14519_/B _14508_/A _14508_/B _14508_/C _14508_/D VPWR VGND sg13g2_nand4_1
XFILLER_50_1500 VPWR VGND sg13g2_decap_4
X_15488_ _15489_/C _16852_/B _15488_/B VPWR VGND sg13g2_nor2_1
X_18276_ _18276_/Y _18366_/A _18268_/Y _18269_/Y _18530_/A _18275_/Y VPWR VGND sg13g2_a221oi_1
XFILLER_50_1533 VPWR VGND sg13g2_fill_1
X_17227_ _17229_/C _22747_/Q _17227_/B _17227_/C VPWR VGND sg13g2_nand3_1
X_14439_ _14439_/Y _14439_/A _14439_/B _14439_/C VPWR VGND sg13g2_nor3_1
XFILLER_102_1667 VPWR VGND sg13g2_decap_4
XFILLER_89_1776 VPWR VGND sg13g2_decap_8
X_17158_ _17158_/Y _17158_/A _17182_/B VPWR VGND sg13g2_nor2_1
XFILLER_66_1006 VPWR VGND sg13g2_decap_4
XFILLER_6_391 VPWR VGND sg13g2_fill_2
X_16109_ _16109_/Y _16109_/A _16203_/B VPWR VGND sg13g2_nor2_1
XFILLER_115_245 VPWR VGND sg13g2_decap_8
X_17089_ _17095_/B _22722_/Q _17089_/B VPWR VGND sg13g2_and2_1
XFILLER_63_1916 VPWR VGND sg13g2_fill_2
XFILLER_63_1927 VPWR VGND sg13g2_fill_1
XFILLER_112_941 VPWR VGND sg13g2_fill_2
XFILLER_97_630 VPWR VGND sg13g2_decap_8
XFILLER_29_207 VPWR VGND sg13g2_decap_8
XFILLER_6_1854 VPWR VGND sg13g2_decap_8
XFILLER_42_1050 VPWR VGND sg13g2_decap_8
XFILLER_61_1684 VPWR VGND sg13g2_decap_8
X_22810_ _22810_/Q clkload18/A _22810_/D fanout2821/X VPWR VGND sg13g2_dfrbpq_1
XFILLER_61_1695 VPWR VGND sg13g2_fill_2
XFILLER_2_1729 VPWR VGND sg13g2_decap_8
X_23790_ _23790_/Q clkload44/A _23790_/D fanout2744/X VPWR VGND sg13g2_dfrbpq_1
XFILLER_72_519 VPWR VGND sg13g2_decap_8
XFILLER_96_1725 VPWR VGND sg13g2_decap_8
XFILLER_37_251 VPWR VGND sg13g2_decap_8
X_22741_ _22741_/Q clkload20/A _22741_/D fanout2867/X VPWR VGND sg13g2_dfrbpq_1
XFILLER_25_435 VPWR VGND sg13g2_decap_8
XFILLER_80_541 VPWR VGND sg13g2_decap_8
XFILLER_13_608 VPWR VGND sg13g2_decap_8
X_22672_ _22672_/Q clkload20/A _22672_/D fanout2867/X VPWR VGND sg13g2_dfrbpq_1
XFILLER_80_585 VPWR VGND sg13g2_fill_2
XFILLER_12_118 VPWR VGND sg13g2_fill_1
X_21623_ _21756_/B _21918_/D _22050_/B _22050_/C VPWR VGND sg13g2_nand3_1
XFILLER_52_298 VPWR VGND sg13g2_decap_8
XFILLER_90_1346 VPWR VGND sg13g2_decap_8
XFILLER_16_1417 VPWR VGND sg13g2_decap_8
XFILLER_55_1466 VPWR VGND sg13g2_fill_1
XFILLER_32_14 VPWR VGND sg13g2_decap_8
X_21554_ _23795_/D _22249_/A0 _23795_/Q _21554_/S VPWR VGND sg13g2_mux2_1
XFILLER_55_1499 VPWR VGND sg13g2_fill_1
Xplace4140 _11699_/S _11456_/B VPWR VGND sg13g2_buf_1
Xplace4151 _13643_/S _13645_/A VPWR VGND sg13g2_buf_4
X_20505_ _23312_/D _20297_/Y _20504_/B _20504_/Y VPWR VGND sg13g2_o21ai_1
Xplace4162 _11726_/S _13398_/S VPWR VGND sg13g2_buf_1
X_24273_ _24273_/X _24273_/A VPWR VGND sg13g2_buf_1
XFILLER_20_184 VPWR VGND sg13g2_fill_2
Xplace4173 _12974_/A _13253_/S VPWR VGND sg13g2_buf_1
X_21485_ _23761_/D _23761_/Q _21617_/A0 _21488_/S VPWR VGND sg13g2_mux2_1
XFILLER_88_1220 VPWR VGND sg13g2_decap_8
XFILLER_14_1163 VPWR VGND sg13g2_fill_2
Xplace4184 _12478_/S _12884_/B VPWR VGND sg13g2_buf_4
Xplace4195 _13959_/S0 _13840_/S0 VPWR VGND sg13g2_buf_1
Xplace3450 _17512_/S _17528_/B VPWR VGND sg13g2_buf_1
Xplace3461 _17026_/B _17044_/D VPWR VGND sg13g2_buf_1
X_23224_ _23224_/Q clkload54/A _23224_/D fanout2752/X VPWR VGND sg13g2_dfrbpq_1
Xplace3472 _16591_/A _16678_/S VPWR VGND sg13g2_buf_1
XFILLER_88_1242 VPWR VGND sg13g2_fill_2
X_20436_ _23284_/D _22451_/A1 _20435_/B _20435_/Y VPWR VGND sg13g2_o21ai_1
Xplace3483 _16156_/B _16183_/B VPWR VGND sg13g2_buf_1
XFILLER_107_757 VPWR VGND sg13g2_decap_8
XFILLER_84_1106 VPWR VGND sg13g2_decap_8
Xplace3494 _24274_/A _15096_/A1 VPWR VGND sg13g2_buf_1
X_23155_ _23155_/Q clkload14/A _23155_/D fanout2843/X VPWR VGND sg13g2_dfrbpq_1
X_20367_ _20831_/C _20367_/A _20367_/B VPWR VGND sg13g2_nand2_1
X_22106_ _24044_/D _22305_/A1 _22108_/B _22105_/Y VPWR VGND sg13g2_o21ai_1
XFILLER_106_289 VPWR VGND sg13g2_fill_1
X_23086_ _23086_/Q _23215_/CLK _23086_/D fanout2924/X VPWR VGND sg13g2_dfrbpq_1
XFILLER_88_630 VPWR VGND sg13g2_fill_2
X_22037_ _24012_/D _22305_/A1 _22048_/B _22036_/Y VPWR VGND sg13g2_o21ai_1
XFILLER_7_1629 VPWR VGND sg13g2_decap_8
XFILLER_76_814 VPWR VGND sg13g2_decap_8
XFILLER_76_825 VPWR VGND sg13g2_fill_1
XFILLER_5_1320 VPWR VGND sg13g2_fill_1
XFILLER_76_858 VPWR VGND sg13g2_decap_8
XFILLER_79_1923 VPWR VGND sg13g2_fill_1
XFILLER_29_752 VPWR VGND sg13g2_decap_8
X_13810_ _20308_/A _13810_/A _13810_/B VPWR VGND sg13g2_xnor2_1
X_14790_ _17838_/B _14885_/A _14790_/B VPWR VGND sg13g2_nor2_1
X_23988_ _23988_/Q clkload49/A _23988_/D fanout2673/X VPWR VGND sg13g2_dfrbpq_1
XFILLER_21_1156 VPWR VGND sg13g2_fill_2
XFILLER_84_880 VPWR VGND sg13g2_decap_4
XFILLER_95_1224 VPWR VGND sg13g2_fill_1
XFILLER_44_722 VPWR VGND sg13g2_fill_2
X_13741_ _13755_/A _13741_/A _13932_/B _13932_/C _13741_/D VPWR VGND sg13g2_nand4_1
X_22939_ _22939_/Q _23029_/CLK _22939_/D fanout2807/X VPWR VGND sg13g2_dfrbpq_1
XFILLER_71_541 VPWR VGND sg13g2_decap_4
XFILLER_16_457 VPWR VGND sg13g2_decap_8
X_16460_ _16460_/Y _22594_/Q _16470_/B VPWR VGND sg13g2_nand2_1
X_13672_ _13672_/Y _13671_/B _23600_/Q _13671_/Y VPWR VGND sg13g2_o21ai_1
X_15411_ _16058_/A _19778_/A _15406_/X _15410_/Y VPWR VGND sg13g2_a21oi_1
X_12623_ _12623_/X _12623_/A _12623_/B VPWR VGND sg13g2_and2_1
X_16391_ _22561_/D _23011_/Q _22561_/Q _18657_/B VPWR VGND sg13g2_mux2_1
XFILLER_73_1555 VPWR VGND sg13g2_decap_4
XFILLER_40_961 VPWR VGND sg13g2_decap_8
X_18130_ _22958_/D _18471_/S _18541_/A1 _18129_/Y VPWR VGND sg13g2_o21ai_1
X_15342_ _15373_/A _22454_/Q _15270_/A _15289_/X _22913_/Q VPWR VGND sg13g2_a22oi_1
XFILLER_34_1539 VPWR VGND sg13g2_fill_2
XFILLER_73_1588 VPWR VGND sg13g2_decap_8
XFILLER_16_1940 VPWR VGND sg13g2_decap_8
XFILLER_11_140 VPWR VGND sg13g2_decap_8
XFILLER_103_1910 VPWR VGND sg13g2_decap_8
X_11505_ _11505_/X _23701_/Q _23733_/Q _23765_/Q _23797_/Q _12028_/A _12006_/S1 VPWR
+ VGND sg13g2_mux4_1
XFILLER_8_645 VPWR VGND sg13g2_decap_4
XFILLER_51_1853 VPWR VGND sg13g2_fill_1
X_18061_ _18064_/B _17978_/A _18189_/B _18464_/A VPWR VGND sg13g2_a21oi_1
X_15273_ _15273_/X _16357_/A _22452_/Q _15496_/S VPWR VGND sg13g2_mux2_1
X_12485_ _12486_/B _23808_/Q _23968_/Q _12485_/S VPWR VGND sg13g2_mux2_1
XFILLER_51_1875 VPWR VGND sg13g2_fill_1
XFILLER_103_1954 VPWR VGND sg13g2_fill_1
X_14224_ _14226_/A _14224_/A _22825_/Q VPWR VGND sg13g2_nand2_1
XFILLER_12_1848 VPWR VGND sg13g2_decap_8
X_17012_ _22711_/D _16946_/S _17010_/Y _17011_/Y VPWR VGND sg13g2_o21ai_1
X_11436_ _14274_/A _14117_/A _11634_/A _11861_/B VPWR VGND sg13g2_nor3_2
XFILLER_7_177 VPWR VGND sg13g2_decap_8
X_14155_ _14155_/Y _14290_/B _14155_/B _14290_/C VPWR VGND sg13g2_nand3_1
X_11367_ _11367_/Y _12413_/B _22550_/Q VPWR VGND sg13g2_nor2b_1
X_13106_ _13107_/B _23848_/Q _23880_/Q _23944_/Q _23976_/Q _13606_/S0 _13606_/S1 VPWR
+ VGND sg13g2_mux4_1
XFILLER_3_350 VPWR VGND sg13g2_fill_2
XFILLER_98_84 VPWR VGND sg13g2_decap_4
X_18963_ _18964_/C _19003_/A _23086_/Q VPWR VGND sg13g2_nand2_1
XFILLER_3_372 VPWR VGND sg13g2_decap_8
X_14086_ _14087_/D _14086_/A1 _14119_/B _14117_/C VPWR VGND sg13g2_o21ai_1
X_11298_ _11298_/X _23735_/Q _23799_/Q _23863_/Q _23959_/Q _12006_/S1 _11723_/S VPWR
+ VGND sg13g2_mux4_1
XFILLER_106_790 VPWR VGND sg13g2_fill_1
XFILLER_80_1504 VPWR VGND sg13g2_decap_8
XFILLER_3_394 VPWR VGND sg13g2_fill_1
XFILLER_26_1012 VPWR VGND sg13g2_decap_8
XFILLER_65_1061 VPWR VGND sg13g2_decap_8
XFILLER_112_259 VPWR VGND sg13g2_decap_8
X_17914_ _17916_/A _17914_/A1 _17929_/A2 _17929_/B1 _17197_/A VPWR VGND sg13g2_a22oi_1
X_13037_ _13037_/Y _23174_/Q _19197_/A VPWR VGND sg13g2_nand2_1
XFILLER_80_1548 VPWR VGND sg13g2_fill_2
X_18894_ _23047_/D _18888_/Y _18891_/Y _18892_/Y _18893_/Y VPWR VGND sg13g2_a22oi_1
XFILLER_6_1106 VPWR VGND sg13g2_decap_8
XFILLER_67_814 VPWR VGND sg13g2_decap_8
XFILLER_26_1056 VPWR VGND sg13g2_decap_8
XFILLER_113_1026 VPWR VGND sg13g2_decap_8
XFILLER_94_633 VPWR VGND sg13g2_decap_8
XFILLER_26_1078 VPWR VGND sg13g2_fill_1
X_17845_ _22913_/D _15375_/Y _17869_/B _17844_/Y VPWR VGND sg13g2_o21ai_1
XFILLER_23_1933 VPWR VGND sg13g2_decap_8
XFILLER_26_1089 VPWR VGND sg13g2_decap_8
XFILLER_67_869 VPWR VGND sg13g2_decap_8
X_17776_ _17784_/A _22573_/Q VPWR VGND sg13g2_inv_1
XFILLER_66_379 VPWR VGND sg13g2_decap_8
XFILLER_110_1936 VPWR VGND sg13g2_decap_8
X_14988_ _18688_/A _14983_/X _14986_/Y _14987_/Y VPWR VGND sg13g2_a21o_1
X_16727_ _16728_/B _22661_/Q _16727_/B VPWR VGND sg13g2_xnor2_1
XFILLER_78_1455 VPWR VGND sg13g2_decap_8
X_13939_ _13939_/Y _13940_/A _13937_/B _13938_/Y VPWR VGND sg13g2_o21ai_1
XFILLER_39_1417 VPWR VGND sg13g2_fill_1
XFILLER_78_1477 VPWR VGND sg13g2_decap_4
XFILLER_1_1762 VPWR VGND sg13g2_decap_8
XFILLER_39_1428 VPWR VGND sg13g2_fill_1
X_19446_ _19446_/Y _19446_/A _19463_/S VPWR VGND sg13g2_nor2_1
X_16658_ _16683_/B _22646_/Q _22645_/Q _16658_/C VPWR VGND sg13g2_nand3_1
XFILLER_16_991 VPWR VGND sg13g2_decap_8
X_15609_ _17119_/A _17517_/D VPWR VGND sg13g2_inv_1
X_16589_ _16590_/B _22632_/Q _22631_/Q _16589_/C VPWR VGND sg13g2_nand3_1
XFILLER_17_1737 VPWR VGND sg13g2_decap_8
XFILLER_31_950 VPWR VGND sg13g2_decap_8
XFILLER_52_1617 VPWR VGND sg13g2_fill_2
X_18328_ _18328_/Y _18498_/C _18245_/B _18379_/B VPWR VGND sg13g2_o21ai_1
XFILLER_108_1876 VPWR VGND sg13g2_decap_8
XFILLER_30_471 VPWR VGND sg13g2_fill_1
XFILLER_15_1461 VPWR VGND sg13g2_decap_8
X_18259_ _18260_/B _18269_/A _18259_/B _18259_/C _18259_/D VPWR VGND sg13g2_nor4_1
X_21270_ _23657_/D _21336_/A0 _23657_/Q _21286_/S VPWR VGND sg13g2_mux2_1
XFILLER_11_1336 VPWR VGND sg13g2_decap_8
X_20221_ _23243_/D _20365_/B _20700_/A1 _20220_/Y VPWR VGND sg13g2_o21ai_1
XFILLER_85_1437 VPWR VGND sg13g2_decap_8
X_20152_ _20153_/D _24263_/A _20318_/B VPWR VGND sg13g2_nand2_1
XFILLER_67_1882 VPWR VGND sg13g2_fill_2
XFILLER_103_248 VPWR VGND sg13g2_decap_8
XFILLER_8_1916 VPWR VGND sg13g2_decap_8
XFILLER_63_1735 VPWR VGND sg13g2_fill_2
X_20083_ _20121_/B _19719_/A _19482_/Y _20082_/Y VPWR VGND sg13g2_o21ai_1
XFILLER_97_471 VPWR VGND sg13g2_decap_8
XFILLER_115_1847 VPWR VGND sg13g2_decap_8
XFILLER_112_782 VPWR VGND sg13g2_decap_8
XFILLER_58_836 VPWR VGND sg13g2_decap_4
X_23911_ _23911_/Q _24170_/CLK _23911_/D fanout2708/X VPWR VGND sg13g2_dfrbpq_1
XFILLER_69_195 VPWR VGND sg13g2_decap_8
XFILLER_26_1590 VPWR VGND sg13g2_fill_1
X_23842_ _23842_/Q clkload43/A _23842_/D fanout2732/X VPWR VGND sg13g2_dfrbpq_1
XFILLER_84_154 VPWR VGND sg13g2_decap_4
XFILLER_85_699 VPWR VGND sg13g2_decap_8
XFILLER_72_316 VPWR VGND sg13g2_fill_2
XFILLER_26_722 VPWR VGND sg13g2_decap_4
XFILLER_72_327 VPWR VGND sg13g2_decap_4
X_23773_ _23773_/Q clkload59/A _23773_/D fanout2789/X VPWR VGND sg13g2_dfrbpq_1
XFILLER_92_1419 VPWR VGND sg13g2_decap_8
X_22724_ _22724_/Q clkload22/A _22724_/D fanout2885/X VPWR VGND sg13g2_dfrbpq_1
XFILLER_53_552 VPWR VGND sg13g2_fill_2
XFILLER_109_1607 VPWR VGND sg13g2_fill_2
XFILLER_81_872 VPWR VGND sg13g2_decap_8
XFILLER_53_563 VPWR VGND sg13g2_fill_1
XFILLER_80_360 VPWR VGND sg13g2_decap_4
XFILLER_53_574 VPWR VGND sg13g2_fill_2
XFILLER_74_1842 VPWR VGND sg13g2_fill_1
X_22655_ _22655_/Q clkload24/A _22655_/D fanout2889/X VPWR VGND sg13g2_dfrbpq_1
XFILLER_55_1241 VPWR VGND sg13g2_fill_2
XFILLER_9_409 VPWR VGND sg13g2_fill_2
XFILLER_43_57 VPWR VGND sg13g2_decap_8
XFILLER_90_1143 VPWR VGND sg13g2_decap_8
XFILLER_90_1154 VPWR VGND sg13g2_fill_1
X_21606_ _23818_/D _21606_/A1 _21605_/B _21605_/Y VPWR VGND sg13g2_o21ai_1
X_22586_ _22586_/Q clkload22/A _22586_/D fanout2875/X VPWR VGND sg13g2_dfrbpq_1
XFILLER_55_1296 VPWR VGND sg13g2_fill_2
X_21537_ _23784_/D _21898_/A0 _23784_/Q _21554_/S VPWR VGND sg13g2_mux2_1
XFILLER_5_604 VPWR VGND sg13g2_fill_1
X_12270_ _12270_/Y _16781_/A _15491_/A VPWR VGND sg13g2_nor2_1
X_24256_ _24256_/X _24256_/A VPWR VGND sg13g2_buf_1
X_21468_ _23751_/D _21962_/A1 _21483_/B _21467_/Y VPWR VGND sg13g2_o21ai_1
Xplace3280 _21964_/A0 _20172_/Y VPWR VGND sg13g2_buf_1
X_23207_ _23207_/Q _23215_/CLK _23207_/D fanout2926/X VPWR VGND sg13g2_dfrbpq_1
X_11221_ _11222_/B _23193_/Q _23192_/Q VPWR VGND sg13g2_nor2b_2
Xplace3291 _21956_/A1 _21261_/A1 VPWR VGND sg13g2_buf_1
X_20419_ _20419_/Y _20419_/A _20426_/B VPWR VGND sg13g2_nand2_1
XFILLER_4_158 VPWR VGND sg13g2_decap_8
X_24187_ _24187_/Q _24190_/CLK _24187_/D fanout2770/X VPWR VGND sg13g2_dfrbpq_1
XFILLER_107_576 VPWR VGND sg13g2_decap_8
XFILLER_11_1881 VPWR VGND sg13g2_decap_8
X_21399_ _23718_/D _21960_/A1 _21398_/B _21398_/Y VPWR VGND sg13g2_o21ai_1
X_23138_ _23138_/Q clkload5/A _23138_/D fanout2834/X VPWR VGND sg13g2_dfrbpq_1
XFILLER_49_1067 VPWR VGND sg13g2_fill_1
X_23069_ _23069_/Q _23114_/CLK _23069_/D fanout2905/X VPWR VGND sg13g2_dfrbpq_1
X_15960_ _15960_/Y _23027_/Q VPWR VGND sg13g2_inv_1
XFILLER_76_600 VPWR VGND sg13g2_fill_2
XFILLER_62_1245 VPWR VGND sg13g2_fill_1
XFILLER_27_1376 VPWR VGND sg13g2_fill_1
X_14911_ _14911_/X _23134_/Q _16263_/A _14933_/S VPWR VGND sg13g2_mux2_1
XFILLER_102_270 VPWR VGND sg13g2_decap_4
XFILLER_75_110 VPWR VGND sg13g2_fill_1
XFILLER_76_633 VPWR VGND sg13g2_fill_1
XFILLER_0_397 VPWR VGND sg13g2_decap_4
X_15891_ _22476_/D _15981_/S _15888_/Y _15890_/Y VPWR VGND sg13g2_a21oi_1
XFILLER_36_508 VPWR VGND sg13g2_fill_1
X_17630_ _17630_/Y _17583_/A _17628_/Y _17629_/Y VPWR VGND sg13g2_a21oi_1
X_14842_ _16241_/A _11889_/A _14825_/Y _14841_/Y VPWR VGND sg13g2_o21ai_1
XFILLER_64_828 VPWR VGND sg13g2_decap_8
XFILLER_17_711 VPWR VGND sg13g2_fill_1
XFILLER_64_839 VPWR VGND sg13g2_decap_8
XFILLER_75_187 VPWR VGND sg13g2_decap_8
X_17561_ _22879_/D _17631_/B _17558_/Y _17560_/Y VPWR VGND sg13g2_a21oi_1
XFILLER_95_1021 VPWR VGND sg13g2_fill_2
X_14773_ _14788_/B _14885_/A _14885_/B _14885_/C VPWR VGND sg13g2_nor3_1
X_19300_ _23217_/D _23217_/Q _20310_/A0 _19300_/S VPWR VGND sg13g2_mux2_1
X_16512_ _16512_/Y _22616_/Q _16512_/B VPWR VGND sg13g2_nand2_1
XFILLER_17_777 VPWR VGND sg13g2_decap_4
XFILLER_32_703 VPWR VGND sg13g2_decap_8
XFILLER_44_563 VPWR VGND sg13g2_fill_2
X_13724_ _13724_/Y _15906_/A _13724_/A2 _20258_/A VPWR VGND sg13g2_a21oi_1
X_17492_ _17492_/Y _17492_/A _17498_/B VPWR VGND sg13g2_nand2_1
XFILLER_16_276 VPWR VGND sg13g2_decap_8
XFILLER_16_287 VPWR VGND sg13g2_fill_2
X_19231_ _23185_/D _24274_/A _23185_/Q _19231_/S VPWR VGND sg13g2_mux2_1
XFILLER_71_393 VPWR VGND sg13g2_fill_2
X_12606_ _12607_/D _12606_/A _12606_/B VPWR VGND sg13g2_nor2_1
XFILLER_83_7 VPWR VGND sg13g2_fill_1
X_16374_ _16374_/Y _22549_/Q _16376_/B VPWR VGND sg13g2_nand2_1
X_13586_ _13586_/Y _13586_/A1 _23598_/Q _13585_/Y VPWR VGND sg13g2_o21ai_1
XFILLER_12_460 VPWR VGND sg13g2_fill_1
XFILLER_34_1358 VPWR VGND sg13g2_fill_1
XFILLER_40_791 VPWR VGND sg13g2_decap_8
X_15325_ _15325_/Y _17034_/A _15325_/B VPWR VGND sg13g2_nor2_1
X_19093_ _23082_/D _23082_/Q _19092_/X _19099_/S VPWR VGND sg13g2_mux2_1
X_18044_ _18494_/A _18358_/S _18008_/X _18011_/Y VPWR VGND sg13g2_a21o_1
X_15256_ _15256_/Y _16781_/A _16781_/B _16781_/C VPWR VGND sg13g2_nor3_1
XFILLER_103_1795 VPWR VGND sg13g2_decap_8
X_14207_ _14213_/B _14809_/A _14207_/B VPWR VGND sg13g2_and2_2
X_15187_ _15187_/Y _15264_/B _15187_/B _15187_/C VPWR VGND sg13g2_nor3_1
XFILLER_86_1746 VPWR VGND sg13g2_fill_2
XFILLER_47_1708 VPWR VGND sg13g2_fill_1
X_12399_ _12399_/Y _24127_/Q _12401_/B VPWR VGND sg13g2_nand2b_1
XFILLER_86_1768 VPWR VGND sg13g2_decap_8
XFILLER_86_1779 VPWR VGND sg13g2_fill_1
X_14138_ _14766_/A _14438_/B _14138_/B _14439_/B VPWR VGND sg13g2_nor3_2
X_19995_ _19995_/Y _19995_/A VPWR VGND sg13g2_inv_1
XFILLER_45_1421 VPWR VGND sg13g2_decap_8
XFILLER_113_568 VPWR VGND sg13g2_decap_8
XFILLER_86_408 VPWR VGND sg13g2_fill_1
X_18946_ _18947_/C _23052_/Q _18959_/A _18956_/B VPWR VGND sg13g2_or3_1
XFILLER_98_279 VPWR VGND sg13g2_decap_8
XFILLER_86_419 VPWR VGND sg13g2_decap_8
XFILLER_100_229 VPWR VGND sg13g2_fill_2
XFILLER_80_1378 VPWR VGND sg13g2_decap_8
XFILLER_94_441 VPWR VGND sg13g2_decap_8
XFILLER_3_1813 VPWR VGND sg13g2_decap_8
XFILLER_23_1741 VPWR VGND sg13g2_fill_2
XFILLER_55_806 VPWR VGND sg13g2_decap_4
XFILLER_66_143 VPWR VGND sg13g2_decap_8
XFILLER_82_614 VPWR VGND sg13g2_decap_8
XFILLER_48_880 VPWR VGND sg13g2_decap_8
XFILLER_66_176 VPWR VGND sg13g2_decap_4
XFILLER_78_1230 VPWR VGND sg13g2_fill_1
XFILLER_58_1804 VPWR VGND sg13g2_decap_8
XFILLER_66_198 VPWR VGND sg13g2_fill_1
X_17759_ _17759_/Y _17175_/A _17810_/A2 _17810_/B1 _17758_/Y VPWR VGND sg13g2_a22oi_1
XFILLER_47_390 VPWR VGND sg13g2_fill_2
XFILLER_93_1706 VPWR VGND sg13g2_decap_8
XFILLER_63_850 VPWR VGND sg13g2_decap_8
XFILLER_81_157 VPWR VGND sg13g2_decap_8
X_20770_ _20770_/Y _23435_/Q _20778_/B VPWR VGND sg13g2_nand2_1
XFILLER_39_1236 VPWR VGND sg13g2_decap_8
XFILLER_74_1116 VPWR VGND sg13g2_decap_8
XFILLER_35_574 VPWR VGND sg13g2_decap_8
XFILLER_50_500 VPWR VGND sg13g2_decap_8
XFILLER_50_511 VPWR VGND sg13g2_fill_1
X_19429_ _19429_/Y _20229_/B _19443_/B _19428_/Y VPWR VGND sg13g2_o21ai_1
X_22440_ _24205_/D _24205_/Q _22440_/A1 _22449_/S VPWR VGND sg13g2_mux2_1
XFILLER_17_1545 VPWR VGND sg13g2_decap_8
XFILLER_52_1436 VPWR VGND sg13g2_fill_2
XFILLER_52_1458 VPWR VGND sg13g2_fill_1
XFILLER_109_819 VPWR VGND sg13g2_decap_8
X_22371_ _22371_/Y _22371_/A _22377_/B VPWR VGND sg13g2_nand2_1
X_24110_ _24110_/Q clkload36/A _24110_/D fanout2639/X VPWR VGND sg13g2_dfrbpq_1
X_21322_ _21322_/Y _23682_/Q _21330_/B VPWR VGND sg13g2_nand2_1
XFILLER_50_1193 VPWR VGND sg13g2_decap_8
X_24041_ _24041_/Q _24205_/CLK _24041_/D fanout2650/X VPWR VGND sg13g2_dfrbpq_1
XFILLER_89_1381 VPWR VGND sg13g2_fill_2
XFILLER_30_1789 VPWR VGND sg13g2_decap_8
X_21253_ _23648_/D _21587_/A1 _21271_/B _21252_/Y VPWR VGND sg13g2_o21ai_1
XFILLER_89_202 VPWR VGND sg13g2_decap_8
XFILLER_85_1267 VPWR VGND sg13g2_fill_1
X_21184_ _21184_/Y _21184_/A _21188_/B VPWR VGND sg13g2_nand2_1
XFILLER_89_246 VPWR VGND sg13g2_decap_8
XFILLER_85_1289 VPWR VGND sg13g2_fill_2
XFILLER_89_257 VPWR VGND sg13g2_fill_1
XFILLER_104_568 VPWR VGND sg13g2_decap_8
X_20135_ _20135_/Y _15714_/A _20133_/Y _20134_/Y VPWR VGND sg13g2_o21ai_1
XFILLER_100_730 VPWR VGND sg13g2_decap_8
X_20066_ _20066_/Y _20066_/A _20066_/B VPWR VGND sg13g2_nand2_1
XFILLER_115_1655 VPWR VGND sg13g2_decap_8
XFILLER_115_1666 VPWR VGND sg13g2_fill_2
XFILLER_57_132 VPWR VGND sg13g2_fill_2
XFILLER_98_1617 VPWR VGND sg13g2_decap_8
XFILLER_58_688 VPWR VGND sg13g2_fill_1
XFILLER_72_113 VPWR VGND sg13g2_fill_2
XFILLER_79_1049 VPWR VGND sg13g2_decap_4
XFILLER_2_1334 VPWR VGND sg13g2_decap_8
XFILLER_113_1390 VPWR VGND sg13g2_fill_2
X_23825_ _23825_/Q _24113_/CLK _23825_/D fanout2685/X VPWR VGND sg13g2_dfrbpq_1
XFILLER_96_1330 VPWR VGND sg13g2_fill_2
XFILLER_2_1345 VPWR VGND sg13g2_fill_1
XFILLER_22_1273 VPWR VGND sg13g2_decap_8
XFILLER_72_135 VPWR VGND sg13g2_decap_8
XFILLER_61_809 VPWR VGND sg13g2_fill_2
X_11770_ _11770_/X _12039_/B _11770_/B VPWR VGND sg13g2_and2_1
XFILLER_14_703 VPWR VGND sg13g2_fill_2
XFILLER_57_1325 VPWR VGND sg13g2_decap_8
X_23756_ _23756_/Q clkload49/A _23756_/D fanout2674/X VPWR VGND sg13g2_dfrbpq_1
X_20968_ _23528_/D _21335_/A0 _23528_/Q _20989_/S VPWR VGND sg13g2_mux2_1
XFILLER_41_500 VPWR VGND sg13g2_fill_1
XFILLER_54_883 VPWR VGND sg13g2_decap_4
XFILLER_60_319 VPWR VGND sg13g2_decap_8
XFILLER_109_1415 VPWR VGND sg13g2_decap_8
XFILLER_109_1426 VPWR VGND sg13g2_fill_2
X_22707_ _22707_/Q clkload19/A _22707_/D fanout2863/X VPWR VGND sg13g2_dfrbpq_1
XFILLER_13_224 VPWR VGND sg13g2_fill_2
XFILLER_14_758 VPWR VGND sg13g2_decap_8
X_23687_ _23687_/Q _24170_/CLK _23687_/D fanout2698/X VPWR VGND sg13g2_dfrbpq_1
X_20899_ _23495_/D _21333_/A1 _20919_/B _20898_/Y VPWR VGND sg13g2_o21ai_1
X_13440_ _13440_/Y _13437_/B _13440_/B VPWR VGND sg13g2_nand2b_1
X_22638_ _22638_/Q clkload19/A _22638_/D fanout2863/X VPWR VGND sg13g2_dfrbpq_1
XFILLER_41_588 VPWR VGND sg13g2_decap_8
XFILLER_74_1694 VPWR VGND sg13g2_fill_1
XFILLER_110_84 VPWR VGND sg13g2_decap_8
XFILLER_107_1161 VPWR VGND sg13g2_fill_1
XFILLER_35_1678 VPWR VGND sg13g2_fill_1
X_13371_ _13372_/B _13292_/A _20179_/B _20193_/B VPWR VGND sg13g2_o21ai_1
XFILLER_107_1183 VPWR VGND sg13g2_decap_4
XFILLER_103_1014 VPWR VGND sg13g2_decap_8
XFILLER_16_1066 VPWR VGND sg13g2_decap_8
XFILLER_10_953 VPWR VGND sg13g2_decap_8
X_22569_ _22569_/Q _23029_/CLK _22569_/D fanout2825/X VPWR VGND sg13g2_dfrbpq_1
X_15110_ _16331_/A _15102_/Y _14918_/B _18753_/A VPWR VGND sg13g2_o21ai_1
X_12322_ _12323_/D _23902_/Q _13798_/A2 _12321_/X _11477_/A _12567_/A VPWR VGND sg13g2_a221oi_1
X_16090_ _17866_/A _16353_/B _15563_/Y _16090_/S VPWR VGND sg13g2_mux2_1
XFILLER_10_986 VPWR VGND sg13g2_fill_2
XFILLER_6_946 VPWR VGND sg13g2_decap_4
XFILLER_100_1946 VPWR VGND sg13g2_decap_8
XFILLER_6_979 VPWR VGND sg13g2_fill_2
X_24239_ _24239_/Q clkload27/A _24239_/D fanout2856/X VPWR VGND sg13g2_dfrbpq_1
X_12253_ _12253_/X _23901_/Q _23997_/Q _24093_/Q _24125_/Q _12293_/A _22981_/Q VPWR
+ VGND sg13g2_mux4_1
XFILLER_79_42 VPWR VGND sg13g2_fill_1
XFILLER_68_1443 VPWR VGND sg13g2_fill_1
XFILLER_83_1908 VPWR VGND sg13g2_fill_2
XFILLER_5_478 VPWR VGND sg13g2_decap_4
XFILLER_29_1416 VPWR VGND sg13g2_fill_1
XFILLER_107_395 VPWR VGND sg13g2_decap_8
XFILLER_79_97 VPWR VGND sg13g2_decap_4
X_18800_ _18801_/C _23066_/Q _18825_/B VPWR VGND sg13g2_nand2_1
XFILLER_96_717 VPWR VGND sg13g2_decap_4
X_19780_ _19780_/Y _23209_/Q _19781_/A2 _19781_/B1 _23201_/Q VPWR VGND sg13g2_a22oi_1
X_16992_ _16993_/A _22707_/Q VPWR VGND sg13g2_inv_1
XFILLER_95_216 VPWR VGND sg13g2_decap_8
XFILLER_81_1665 VPWR VGND sg13g2_decap_8
X_18731_ _23024_/D _15042_/B _18730_/Y _15071_/A VPWR VGND sg13g2_a21oi_1
XFILLER_23_1004 VPWR VGND sg13g2_decap_8
X_15943_ _15944_/B _22712_/Q _15946_/A2 _15946_/B1 _22648_/Q VPWR VGND sg13g2_a22oi_1
XFILLER_103_590 VPWR VGND sg13g2_decap_8
XFILLER_48_121 VPWR VGND sg13g2_fill_2
XFILLER_77_964 VPWR VGND sg13g2_decap_4
XFILLER_23_1037 VPWR VGND sg13g2_decap_4
XFILLER_48_132 VPWR VGND sg13g2_decap_8
XFILLER_97_1105 VPWR VGND sg13g2_decap_8
XFILLER_92_912 VPWR VGND sg13g2_decap_8
X_18662_ _18662_/Y _23011_/Q _18662_/B VPWR VGND sg13g2_xnor2_1
X_15874_ _15874_/Y _15874_/A _15874_/B _15874_/C _15874_/D VPWR VGND sg13g2_nand4_1
XFILLER_48_176 VPWR VGND sg13g2_fill_2
X_17613_ _17613_/X _22971_/Q _22955_/Q _17697_/A VPWR VGND sg13g2_mux2_1
X_14825_ _14825_/Y _14825_/A _14879_/A VPWR VGND sg13g2_nand2_1
XFILLER_36_338 VPWR VGND sg13g2_fill_2
XFILLER_20_1947 VPWR VGND sg13g2_decap_8
XFILLER_63_135 VPWR VGND sg13g2_fill_1
XFILLER_64_669 VPWR VGND sg13g2_decap_8
X_17544_ _17544_/Y _17629_/B _16356_/A _17543_/Y VPWR VGND sg13g2_o21ai_1
XFILLER_17_574 VPWR VGND sg13g2_decap_8
X_14756_ _14756_/Y _14756_/A _14755_/Y VPWR VGND sg13g2_nor2b_1
XFILLER_51_319 VPWR VGND sg13g2_fill_2
X_11968_ _11968_/X _24058_/Q _24122_/Q _12004_/S VPWR VGND sg13g2_mux2_1
XFILLER_2_1890 VPWR VGND sg13g2_decap_8
XFILLER_32_511 VPWR VGND sg13g2_decap_8
X_13707_ _13707_/X _24048_/Q _24080_/Q _24112_/Q _24144_/Q _13707_/S0 _13707_/S1 VPWR
+ VGND sg13g2_mux4_1
X_17475_ _17475_/Y _17475_/A _17475_/B VPWR VGND sg13g2_nand2_1
X_11899_ _11899_/Y _12239_/S _23578_/Q _11898_/Y VPWR VGND sg13g2_o21ai_1
X_14687_ _14687_/Y _11528_/B _14642_/B _14686_/X VPWR VGND sg13g2_a21oi_1
XFILLER_57_1870 VPWR VGND sg13g2_decap_4
X_19214_ _23171_/D _24260_/A _23171_/Q _19221_/S VPWR VGND sg13g2_mux2_1
XFILLER_60_875 VPWR VGND sg13g2_decap_8
XFILLER_53_1734 VPWR VGND sg13g2_decap_4
XFILLER_60_886 VPWR VGND sg13g2_fill_2
X_16426_ _22580_/D _16048_/X _16425_/B _16425_/Y VPWR VGND sg13g2_o21ai_1
X_13638_ _13638_/X _23471_/Q _23535_/Q _23631_/Q _23695_/Q _13643_/S _13639_/S1 VPWR
+ VGND sg13g2_mux4_1
XFILLER_105_1835 VPWR VGND sg13g2_decap_8
XFILLER_13_791 VPWR VGND sg13g2_fill_1
X_19145_ _23121_/D _23121_/Q _18995_/A _19149_/S VPWR VGND sg13g2_mux2_1
X_16357_ _16357_/Y _16357_/A _16425_/B _16357_/C VPWR VGND sg13g2_nor3_1
X_13569_ _13571_/B _13649_/A _13569_/B VPWR VGND sg13g2_nand2_1
XFILLER_8_250 VPWR VGND sg13g2_decap_8
X_15308_ _15308_/Y _15325_/B _15353_/A VPWR VGND sg13g2_nor2_1
X_19076_ _23074_/D _23074_/Q _19075_/X _19086_/S VPWR VGND sg13g2_mux2_1
X_16288_ _16321_/D _16285_/A _16288_/B VPWR VGND sg13g2_nand2b_1
XFILLER_69_1229 VPWR VGND sg13g2_decap_8
XFILLER_103_1570 VPWR VGND sg13g2_fill_1
XFILLER_86_1521 VPWR VGND sg13g2_decap_4
X_15239_ _15452_/B _15257_/B _16782_/C VPWR VGND sg13g2_and2_1
Xhold4707 _17282_/A _22770_/Q VPWR VGND sg13g2_dlygate4sd3_1
XFILLER_86_1543 VPWR VGND sg13g2_fill_1
Xhold4718 _21891_/A _23941_/Q VPWR VGND sg13g2_dlygate4sd3_1
Xhold4729 _21117_/A _23584_/Q VPWR VGND sg13g2_dlygate4sd3_1
XFILLER_47_1516 VPWR VGND sg13g2_fill_1
XFILLER_113_310 VPWR VGND sg13g2_fill_1
XFILLER_99_533 VPWR VGND sg13g2_decap_4
XFILLER_114_844 VPWR VGND sg13g2_decap_8
XFILLER_99_544 VPWR VGND sg13g2_decap_8
XFILLER_86_1587 VPWR VGND sg13g2_decap_4
X_19978_ _19978_/Y _19978_/A _19978_/B VPWR VGND sg13g2_nor2_1
XFILLER_101_516 VPWR VGND sg13g2_decap_8
XFILLER_45_1251 VPWR VGND sg13g2_decap_4
XFILLER_86_227 VPWR VGND sg13g2_fill_1
X_18929_ _18931_/B _18929_/A _18951_/A VPWR VGND sg13g2_nand2_1
XFILLER_86_249 VPWR VGND sg13g2_decap_8
XFILLER_64_1896 VPWR VGND sg13g2_decap_8
XFILLER_41_1126 VPWR VGND sg13g2_decap_8
X_21940_ _21940_/Y _23965_/Q _21942_/B VPWR VGND sg13g2_nand2_1
XFILLER_99_1937 VPWR VGND sg13g2_decap_8
XFILLER_68_986 VPWR VGND sg13g2_fill_1
XFILLER_54_113 VPWR VGND sg13g2_fill_1
XFILLER_67_496 VPWR VGND sg13g2_decap_8
X_21871_ _21871_/Y _23932_/Q _21876_/B VPWR VGND sg13g2_nand2_1
XFILLER_27_349 VPWR VGND sg13g2_decap_8
XFILLER_23_1593 VPWR VGND sg13g2_fill_2
XFILLER_58_1612 VPWR VGND sg13g2_decap_8
X_23610_ _23610_/Q clkload53/A _23610_/D fanout2781/X VPWR VGND sg13g2_dfrbpq_1
XFILLER_3_1687 VPWR VGND sg13g2_decap_8
XFILLER_58_1623 VPWR VGND sg13g2_fill_1
XFILLER_70_606 VPWR VGND sg13g2_decap_8
X_20822_ _23459_/D _21325_/A1 _20827_/B _20821_/Y VPWR VGND sg13g2_o21ai_1
XFILLER_70_617 VPWR VGND sg13g2_fill_1
XFILLER_35_360 VPWR VGND sg13g2_decap_4
XFILLER_39_1022 VPWR VGND sg13g2_decap_4
X_23541_ _23541_/Q clkload47/A _23541_/D fanout2687/X VPWR VGND sg13g2_dfrbpq_1
XFILLER_23_533 VPWR VGND sg13g2_fill_1
XFILLER_54_1509 VPWR VGND sg13g2_fill_1
XFILLER_39_1088 VPWR VGND sg13g2_fill_1
XFILLER_50_352 VPWR VGND sg13g2_fill_1
XFILLER_23_577 VPWR VGND sg13g2_fill_1
XFILLER_36_1943 VPWR VGND sg13g2_decap_8
XFILLER_39_1099 VPWR VGND sg13g2_fill_2
X_23472_ _23472_/Q clkload38/A _23472_/D fanout2638/X VPWR VGND sg13g2_dfrbpq_1
XFILLER_36_1954 VPWR VGND sg13g2_fill_1
X_20684_ _20684_/Y _23395_/Q _20690_/B VPWR VGND sg13g2_nand2_1
XFILLER_104_1301 VPWR VGND sg13g2_decap_8
XFILLER_17_1353 VPWR VGND sg13g2_decap_8
X_22423_ _24196_/D _20101_/Y _22424_/B _22422_/Y VPWR VGND sg13g2_o21ai_1
XFILLER_104_1356 VPWR VGND sg13g2_fill_1
XFILLER_13_1239 VPWR VGND sg13g2_fill_1
X_22354_ _24163_/D _20075_/Y _22359_/B _22353_/Y VPWR VGND sg13g2_o21ai_1
XFILLER_108_126 VPWR VGND sg13g2_decap_8
Xoutput4560 instr_addr_o[4] _14844_/X VPWR VGND sg13g2_buf_1
XFILLER_40_47 VPWR VGND sg13g2_decap_4
X_21305_ _23674_/D _21305_/A1 _21308_/B _21304_/Y VPWR VGND sg13g2_o21ai_1
XFILLER_69_1730 VPWR VGND sg13g2_decap_8
XFILLER_30_1575 VPWR VGND sg13g2_decap_8
X_22285_ _22285_/Y _22285_/A _22285_/B VPWR VGND sg13g2_nand2_1
X_24024_ _24024_/Q clkload46/A _24024_/D fanout2680/X VPWR VGND sg13g2_dfrbpq_1
XFILLER_105_833 VPWR VGND sg13g2_decap_8
X_21236_ _21236_/Y _23641_/Q _21247_/B VPWR VGND sg13g2_nand2_1
XFILLER_65_1616 VPWR VGND sg13g2_decap_8
XFILLER_46_1004 VPWR VGND sg13g2_fill_1
XFILLER_105_877 VPWR VGND sg13g2_decap_8
XFILLER_46_1037 VPWR VGND sg13g2_fill_2
XFILLER_104_354 VPWR VGND sg13g2_fill_1
X_21167_ _23608_/D _21301_/A1 _21215_/B _21166_/Y VPWR VGND sg13g2_o21ai_1
XFILLER_77_205 VPWR VGND sg13g2_decap_8
XFILLER_49_56 VPWR VGND sg13g2_fill_1
XFILLER_77_216 VPWR VGND sg13g2_fill_2
X_20118_ _20118_/Y _20118_/A _20118_/B VPWR VGND sg13g2_nand2_1
XFILLER_115_1441 VPWR VGND sg13g2_decap_8
X_21098_ _23575_/D _21299_/A1 _21099_/B _21097_/Y VPWR VGND sg13g2_o21ai_1
XFILLER_8_1576 VPWR VGND sg13g2_decap_8
XFILLER_4_1407 VPWR VGND sg13g2_fill_2
XFILLER_24_1357 VPWR VGND sg13g2_decap_8
X_20049_ _20049_/Y _20266_/B2 _20043_/Y _20048_/Y VPWR VGND sg13g2_a21oi_1
X_12940_ _12940_/X _13077_/B _12940_/B VPWR VGND sg13g2_xor2_1
XFILLER_100_560 VPWR VGND sg13g2_decap_8
XFILLER_98_1425 VPWR VGND sg13g2_decap_8
XFILLER_58_474 VPWR VGND sg13g2_decap_4
XFILLER_105_84 VPWR VGND sg13g2_decap_8
XFILLER_46_647 VPWR VGND sg13g2_fill_1
XFILLER_45_124 VPWR VGND sg13g2_decap_8
X_12871_ _12871_/X _24165_/Q _24197_/Q _23237_/Q _23269_/Q _12983_/A _12986_/S1 VPWR
+ VGND sg13g2_mux4_1
XFILLER_73_466 VPWR VGND sg13g2_decap_8
X_14610_ _14610_/Y _24220_/Q _14260_/A VPWR VGND sg13g2_nor2b_1
XFILLER_57_1111 VPWR VGND sg13g2_decap_4
X_23808_ _23808_/Q clkload43/A _23808_/D fanout2774/X VPWR VGND sg13g2_dfrbpq_1
X_15590_ _22462_/D _16099_/A _15589_/X _15718_/S VPWR VGND sg13g2_mux2_1
XFILLER_14_511 VPWR VGND sg13g2_fill_2
XFILLER_96_1193 VPWR VGND sg13g2_fill_2
X_11753_ _11753_/Y _11416_/B _23640_/Q _11752_/Y VPWR VGND sg13g2_o21ai_1
X_23739_ _23739_/Q _23966_/CLK _23739_/D fanout2763/X VPWR VGND sg13g2_dfrbpq_1
XFILLER_109_1256 VPWR VGND sg13g2_fill_2
X_17260_ _17260_/Y _17260_/A _17270_/B VPWR VGND sg13g2_nand2_1
X_14472_ _18803_/A _17987_/B _14472_/B VPWR VGND sg13g2_and2_1
XFILLER_35_1442 VPWR VGND sg13g2_decap_8
X_16211_ _16241_/C _16215_/A _16215_/B VPWR VGND sg13g2_and2_1
X_13423_ _13423_/Y _13589_/B _23916_/Q _13422_/Y VPWR VGND sg13g2_o21ai_1
XFILLER_35_1475 VPWR VGND sg13g2_decap_8
X_17191_ _17191_/Y _22741_/Q _17191_/B VPWR VGND sg13g2_xnor2_1
XFILLER_35_1486 VPWR VGND sg13g2_fill_2
XFILLER_35_1497 VPWR VGND sg13g2_fill_2
X_16142_ _16142_/Y _16142_/A _16187_/B VPWR VGND sg13g2_nor2_1
X_13354_ _13510_/A _13440_/B _13437_/B VPWR VGND sg13g2_xor2_1
X_12305_ _12327_/A _14342_/C _12305_/B _13846_/A VPWR VGND sg13g2_nand3b_1
XFILLER_87_1830 VPWR VGND sg13g2_fill_2
X_16073_ _16073_/Y _16073_/A _16073_/B VPWR VGND sg13g2_nand2_1
X_13285_ _13306_/B _13528_/A _13356_/C VPWR VGND sg13g2_xnor2_1
XFILLER_108_671 VPWR VGND sg13g2_decap_8
XFILLER_6_787 VPWR VGND sg13g2_decap_8
X_12236_ _12241_/B _12245_/A _12236_/B VPWR VGND sg13g2_nor2_1
X_15024_ _15024_/Y _22534_/Q VPWR VGND sg13g2_inv_1
XFILLER_83_1716 VPWR VGND sg13g2_fill_1
XFILLER_87_1896 VPWR VGND sg13g2_decap_8
X_19832_ _19832_/Y _19663_/A _19825_/Y _19831_/Y VPWR VGND sg13g2_a21oi_1
XFILLER_111_814 VPWR VGND sg13g2_decap_8
Xfanout2930 fanout2930/X fanout2931/X VPWR VGND sg13g2_buf_1
X_12167_ _12167_/Y _12166_/B _24092_/Q _12166_/Y VPWR VGND sg13g2_o21ai_1
XFILLER_96_514 VPWR VGND sg13g2_decap_4
XFILLER_96_525 VPWR VGND sg13g2_fill_2
XFILLER_68_227 VPWR VGND sg13g2_fill_1
XFILLER_96_547 VPWR VGND sg13g2_decap_4
X_19763_ _19764_/B _20005_/A _19734_/Y _19762_/Y VPWR VGND sg13g2_a21oi_1
XFILLER_42_1413 VPWR VGND sg13g2_decap_4
X_12098_ _12098_/X _12098_/A1 _12965_/B _19803_/A VPWR VGND sg13g2_a21o_1
X_16975_ _16976_/B _16975_/A _16980_/D VPWR VGND sg13g2_nand2_1
XFILLER_110_346 VPWR VGND sg13g2_fill_2
X_18714_ _18719_/B _18714_/A _18714_/B VPWR VGND sg13g2_nor2_1
XFILLER_49_452 VPWR VGND sg13g2_fill_1
X_15926_ _15926_/Y _22647_/Q _16774_/D _17056_/C _22711_/Q VPWR VGND sg13g2_a22oi_1
X_19694_ _19694_/Y _19714_/S _19694_/B VPWR VGND sg13g2_nor2_1
XFILLER_83_219 VPWR VGND sg13g2_decap_8
XFILLER_65_934 VPWR VGND sg13g2_decap_8
XFILLER_65_945 VPWR VGND sg13g2_fill_2
XFILLER_76_271 VPWR VGND sg13g2_fill_2
X_18645_ _18646_/B _18667_/A _18661_/B VPWR VGND sg13g2_nor2_1
XFILLER_37_647 VPWR VGND sg13g2_decap_4
XFILLER_111_1850 VPWR VGND sg13g2_decap_8
X_15857_ _15864_/A _22934_/Q _15897_/A2 _15856_/Y VPWR VGND sg13g2_a21oi_1
XFILLER_0_1805 VPWR VGND sg13g2_decap_4
XFILLER_65_967 VPWR VGND sg13g2_fill_2
XFILLER_65_978 VPWR VGND sg13g2_fill_2
XFILLER_92_786 VPWR VGND sg13g2_decap_8
XFILLER_18_872 VPWR VGND sg13g2_fill_1
X_14808_ _14808_/Y _14760_/C _14808_/B VPWR VGND sg13g2_nand2b_1
XFILLER_64_477 VPWR VGND sg13g2_decap_4
XFILLER_79_1380 VPWR VGND sg13g2_fill_2
X_18576_ _18576_/Y _22996_/Q _18573_/A VPWR VGND sg13g2_nor2b_1
XFILLER_94_1845 VPWR VGND sg13g2_decap_8
X_15788_ _15798_/B _15984_/A _15788_/B VPWR VGND sg13g2_or2_1
XFILLER_91_285 VPWR VGND sg13g2_decap_8
XFILLER_55_1818 VPWR VGND sg13g2_fill_2
X_17527_ _22876_/D _17527_/A _17527_/B VPWR VGND sg13g2_or2_1
X_14739_ _14739_/X _14721_/Y _14719_/Y _14739_/S VPWR VGND sg13g2_mux2_1
XFILLER_75_1266 VPWR VGND sg13g2_decap_8
X_17458_ _22847_/D _17854_/A1 _17462_/B _17457_/Y VPWR VGND sg13g2_o21ai_1
XFILLER_32_385 VPWR VGND sg13g2_decap_4
Xrebuffer5504 rebuffer5504/X rebuffer5505/X VPWR VGND sg13g2_buf_1
Xrebuffer5515 _14122_/B _11315_/D VPWR VGND sg13g2_buf_1
Xrebuffer5526 rebuffer5526/X rebuffer5527/X VPWR VGND sg13g2_buf_1
XFILLER_20_558 VPWR VGND sg13g2_decap_8
Xplace3802 _13989_/A1 _13925_/A1 VPWR VGND sg13g2_buf_2
Xplace3813 _15633_/S _15442_/S VPWR VGND sg13g2_buf_1
X_17389_ _17389_/Y _14862_/C _16364_/B _17388_/Y VPWR VGND sg13g2_o21ai_1
Xrebuffer5537 rebuffer5537/X rebuffer5538/X VPWR VGND sg13g2_buf_1
XFILLER_105_1665 VPWR VGND sg13g2_decap_4
Xrebuffer5548 rebuffer5548/X rebuffer5549/X VPWR VGND sg13g2_buf_1
Xplace3824 _13217_/B _13216_/Y VPWR VGND sg13g2_buf_4
X_19128_ _23105_/D _23105_/Q _19128_/A1 _19134_/S VPWR VGND sg13g2_mux2_1
Xrebuffer5559 _14861_/B _14229_/Y VPWR VGND sg13g2_buf_1
Xplace3835 _15690_/B _15950_/B VPWR VGND sg13g2_buf_1
XFILLER_88_1616 VPWR VGND sg13g2_fill_1
Xplace3846 _13924_/B1 _12824_/B1 VPWR VGND sg13g2_buf_1
Xplace3857 _13970_/A _12266_/A VPWR VGND sg13g2_buf_1
Xplace3868 _15497_/S _16029_/B VPWR VGND sg13g2_buf_1
Xhold5205 _22426_/A _24198_/Q VPWR VGND sg13g2_dlygate4sd3_1
XFILLER_106_608 VPWR VGND sg13g2_decap_8
Xplace3879 _19781_/A2 _19881_/A2 VPWR VGND sg13g2_buf_1
X_19059_ _23066_/D _23066_/Q _19058_/X _19061_/S VPWR VGND sg13g2_mux2_1
XFILLER_69_1048 VPWR VGND sg13g2_decap_8
XFILLER_47_1302 VPWR VGND sg13g2_decap_4
X_22070_ _24027_/D _22270_/A1 _22069_/B _22069_/Y VPWR VGND sg13g2_o21ai_1
XFILLER_114_641 VPWR VGND sg13g2_decap_8
XFILLER_86_1384 VPWR VGND sg13g2_fill_1
XFILLER_113_140 VPWR VGND sg13g2_decap_8
XFILLER_47_1357 VPWR VGND sg13g2_decap_4
XFILLER_59_205 VPWR VGND sg13g2_decap_4
XFILLER_9_1885 VPWR VGND sg13g2_decap_8
XFILLER_101_368 VPWR VGND sg13g2_decap_8
XFILLER_99_1723 VPWR VGND sg13g2_fill_2
XFILLER_28_603 VPWR VGND sg13g2_decap_8
XFILLER_101_379 VPWR VGND sg13g2_fill_1
XFILLER_5_1749 VPWR VGND sg13g2_decap_8
X_22972_ _22972_/Q clkload29/A _22972_/D fanout2921/X VPWR VGND sg13g2_dfrbpq_1
XFILLER_56_934 VPWR VGND sg13g2_decap_8
XFILLER_60_1579 VPWR VGND sg13g2_decap_8
XFILLER_67_271 VPWR VGND sg13g2_fill_1
XFILLER_99_1756 VPWR VGND sg13g2_decap_4
XFILLER_112_1658 VPWR VGND sg13g2_fill_1
XFILLER_28_647 VPWR VGND sg13g2_fill_1
X_21923_ _21923_/Y _23957_/Q _21935_/B VPWR VGND sg13g2_nand2_1
XFILLER_16_809 VPWR VGND sg13g2_decap_4
XFILLER_82_252 VPWR VGND sg13g2_decap_8
XFILLER_35_14 VPWR VGND sg13g2_decap_8
XFILLER_43_606 VPWR VGND sg13g2_fill_1
XFILLER_71_915 VPWR VGND sg13g2_fill_1
XFILLER_15_308 VPWR VGND sg13g2_decap_8
XFILLER_43_617 VPWR VGND sg13g2_fill_1
XFILLER_83_797 VPWR VGND sg13g2_decap_4
Xinput4403 _20284_/A2 data_rdata_i[3] VPWR VGND sg13g2_buf_1
XFILLER_35_36 VPWR VGND sg13g2_fill_1
Xinput4414 _19150_/A instr_gnt_i VPWR VGND sg13g2_buf_1
XFILLER_24_820 VPWR VGND sg13g2_decap_8
X_20805_ _20805_/Y _20805_/A _20809_/B VPWR VGND sg13g2_nand2_1
Xinput4425 _18907_/B instr_rdata_i[19] VPWR VGND sg13g2_buf_1
XFILLER_93_1344 VPWR VGND sg13g2_decap_4
XFILLER_19_1415 VPWR VGND sg13g2_decap_4
Xinput4436 _19017_/A instr_rdata_i[29] VPWR VGND sg13g2_buf_1
Xinput4447 _18567_/B instr_rvalid_i VPWR VGND sg13g2_buf_1
XFILLER_24_853 VPWR VGND sg13g2_fill_1
X_21785_ _21832_/S _21984_/A _22186_/A VPWR VGND sg13g2_nand2_1
XFILLER_54_1306 VPWR VGND sg13g2_decap_8
Xinput4458 _14224_/A irqs_i[4] VPWR VGND sg13g2_buf_1
XFILLER_93_1377 VPWR VGND sg13g2_decap_8
XFILLER_24_886 VPWR VGND sg13g2_fill_1
X_20736_ _20736_/Y _20736_/A _20742_/B VPWR VGND sg13g2_nand2_1
X_23524_ _23524_/Q _24196_/CLK _23524_/D fanout2702/X VPWR VGND sg13g2_dfrbpq_1
XFILLER_23_374 VPWR VGND sg13g2_decap_4
XFILLER_51_683 VPWR VGND sg13g2_decap_8
XFILLER_32_1604 VPWR VGND sg13g2_decap_4
XFILLER_52_1030 VPWR VGND sg13g2_fill_2
X_23455_ _23455_/Q clkload40/A _23455_/D fanout2736/X VPWR VGND sg13g2_dfrbpq_1
X_20667_ _23387_/D _19854_/Y _20666_/B _20666_/Y VPWR VGND sg13g2_o21ai_1
XFILLER_13_1003 VPWR VGND sg13g2_decap_4
XFILLER_109_413 VPWR VGND sg13g2_fill_1
XFILLER_104_1131 VPWR VGND sg13g2_decap_8
X_22406_ _22406_/Y _24189_/Q _22408_/B VPWR VGND sg13g2_nand2_1
X_23386_ _23386_/Q clkload54/A _23386_/D fanout2752/X VPWR VGND sg13g2_dfrbpq_1
X_20598_ _20598_/Y _20598_/A _20600_/B VPWR VGND sg13g2_nand2_1
XFILLER_109_468 VPWR VGND sg13g2_decap_8
XFILLER_100_1028 VPWR VGND sg13g2_decap_4
X_22337_ _22337_/Y _22337_/A _22341_/B VPWR VGND sg13g2_nand2_1
XFILLER_10_1935 VPWR VGND sg13g2_decap_8
XFILLER_30_1372 VPWR VGND sg13g2_fill_1
XFILLER_2_212 VPWR VGND sg13g2_decap_8
XFILLER_3_735 VPWR VGND sg13g2_decap_8
X_13070_ _20134_/A _20132_/A _13070_/B VPWR VGND sg13g2_nor2_1
XFILLER_65_1402 VPWR VGND sg13g2_fill_1
X_22268_ _24122_/D _22268_/A1 _22269_/B _22267_/Y VPWR VGND sg13g2_o21ai_1
X_12021_ _12026_/B _12473_/A _12021_/B VPWR VGND sg13g2_nor2_1
X_24007_ _24007_/Q clkload36/A _24007_/D fanout2708/X VPWR VGND sg13g2_dfrbpq_1
XFILLER_78_503 VPWR VGND sg13g2_fill_1
XFILLER_65_1446 VPWR VGND sg13g2_fill_1
X_21219_ _23634_/D _21619_/A1 _21221_/B _21218_/Y VPWR VGND sg13g2_o21ai_1
X_22199_ _22199_/Y _24089_/Q _22210_/B VPWR VGND sg13g2_nand2_1
XFILLER_43_1700 VPWR VGND sg13g2_decap_8
XFILLER_76_21 VPWR VGND sg13g2_decap_8
XFILLER_82_1793 VPWR VGND sg13g2_decap_4
XFILLER_59_750 VPWR VGND sg13g2_fill_2
XFILLER_59_761 VPWR VGND sg13g2_decap_8
XFILLER_98_1200 VPWR VGND sg13g2_fill_1
X_16760_ _16760_/Y _16760_/A _16760_/B VPWR VGND sg13g2_nor2_1
XFILLER_43_1766 VPWR VGND sg13g2_decap_8
XFILLER_59_772 VPWR VGND sg13g2_fill_1
XFILLER_19_614 VPWR VGND sg13g2_decap_8
XFILLER_93_539 VPWR VGND sg13g2_decap_8
XFILLER_76_87 VPWR VGND sg13g2_fill_2
XFILLER_24_1176 VPWR VGND sg13g2_decap_4
XFILLER_78_1807 VPWR VGND sg13g2_fill_1
X_15711_ _15712_/D _16016_/A _15711_/B _15711_/C VPWR VGND sg13g2_nand3_1
XFILLER_78_1818 VPWR VGND sg13g2_fill_1
XFILLER_20_1029 VPWR VGND sg13g2_fill_1
X_12923_ _12923_/Y _12923_/A VPWR VGND sg13g2_inv_1
XFILLER_46_433 VPWR VGND sg13g2_fill_2
XFILLER_74_742 VPWR VGND sg13g2_decap_4
X_16691_ _16692_/B _22653_/Q _16698_/C VPWR VGND sg13g2_xor2_1
XFILLER_78_1829 VPWR VGND sg13g2_decap_4
XFILLER_46_455 VPWR VGND sg13g2_decap_8
XFILLER_62_904 VPWR VGND sg13g2_fill_1
XFILLER_18_157 VPWR VGND sg13g2_decap_8
X_18430_ _18430_/Y _18419_/Y _18430_/B VPWR VGND sg13g2_nand2b_1
XFILLER_92_31 VPWR VGND sg13g2_decap_8
X_15642_ _15646_/A _15642_/A _15642_/B VPWR VGND sg13g2_nand2_1
XFILLER_73_263 VPWR VGND sg13g2_fill_1
XFILLER_92_42 VPWR VGND sg13g2_fill_2
X_12854_ _12854_/Y _13081_/A _13081_/B _13082_/A _13082_/B VPWR VGND sg13g2_a22oi_1
XFILLER_34_639 VPWR VGND sg13g2_decap_8
XFILLER_46_499 VPWR VGND sg13g2_fill_1
X_11805_ _11812_/A _13208_/A _11805_/B VPWR VGND sg13g2_nor2_1
X_18361_ _18361_/Y _18485_/A _18361_/B VPWR VGND sg13g2_nor2_1
X_15573_ _15578_/A _22598_/Q _16441_/A _16161_/A _22493_/Q _15391_/A VPWR VGND sg13g2_a221oi_1
XFILLER_15_853 VPWR VGND sg13g2_decap_8
X_12785_ _12785_/Y _12789_/S _24068_/Q _12784_/Y VPWR VGND sg13g2_o21ai_1
XFILLER_72_1406 VPWR VGND sg13g2_decap_4
X_17312_ _22784_/D _16050_/A _17324_/B _17311_/Y VPWR VGND sg13g2_o21ai_1
XFILLER_42_672 VPWR VGND sg13g2_fill_1
X_14524_ _14601_/B _14599_/C _14523_/Y _22942_/Q VPWR VGND sg13g2_a21o_1
X_18292_ _18292_/Y _18253_/B _18289_/Y _18291_/Y VPWR VGND sg13g2_a21oi_1
X_11736_ _11736_/Y _11736_/A _11441_/S VPWR VGND sg13g2_nor2b_2
XFILLER_70_992 VPWR VGND sg13g2_decap_8
XFILLER_54_1840 VPWR VGND sg13g2_decap_8
XFILLER_109_1075 VPWR VGND sg13g2_fill_1
XFILLER_41_171 VPWR VGND sg13g2_decap_8
XFILLER_106_1930 VPWR VGND sg13g2_decap_8
X_17243_ _22752_/D _16050_/A _17262_/B _17242_/Y VPWR VGND sg13g2_o21ai_1
XFILLER_30_867 VPWR VGND sg13g2_decap_4
X_14455_ _14455_/Y _16855_/B _14455_/B VPWR VGND sg13g2_nor2_1
XFILLER_54_1884 VPWR VGND sg13g2_fill_1
Xplace3109 _21308_/B _21349_/S VPWR VGND sg13g2_buf_1
X_11667_ _11867_/C _14028_/B _14034_/B _11664_/Y _19671_/A VPWR VGND sg13g2_a22oi_1
XFILLER_15_1857 VPWR VGND sg13g2_decap_8
XFILLER_50_1737 VPWR VGND sg13g2_decap_8
X_13406_ _13433_/A _13406_/A _13651_/A _13533_/B VPWR VGND sg13g2_nand3_1
X_17174_ _17174_/Y _22738_/Q _17174_/B VPWR VGND sg13g2_xnor2_1
XFILLER_70_1185 VPWR VGND sg13g2_decap_8
X_11598_ _11599_/C _11571_/B _14118_/C _11583_/S VPWR VGND sg13g2_o21ai_1
XFILLER_70_1196 VPWR VGND sg13g2_fill_1
X_14386_ _14386_/Y _22749_/Q VPWR VGND sg13g2_inv_1
XFILLER_102_1849 VPWR VGND sg13g2_decap_8
X_16125_ _16125_/Y _22498_/Q _16183_/B _16124_/Y VPWR VGND sg13g2_a21oi_1
X_13337_ _13337_/X _13330_/X _13333_/Y _13334_/X _13335_/X _13706_/S _13960_/S1 VPWR
+ VGND sg13g2_mux4_1
XFILLER_83_1502 VPWR VGND sg13g2_fill_1
X_16056_ _16056_/Y _16056_/A _17386_/B VPWR VGND sg13g2_nand2_1
X_13268_ _13268_/Y _13636_/A VPWR VGND sg13g2_inv_1
XFILLER_29_1010 VPWR VGND sg13g2_fill_1
XFILLER_100_1595 VPWR VGND sg13g2_decap_4
X_15007_ _15008_/C _22502_/Q _14998_/B _15075_/B1 _22930_/Q VPWR VGND sg13g2_a22oi_1
XFILLER_9_1104 VPWR VGND sg13g2_fill_2
XFILLER_29_1032 VPWR VGND sg13g2_decap_8
X_12219_ _12219_/Y _12219_/A _12219_/B _12219_/C _12219_/D VPWR VGND sg13g2_nor4_2
X_13199_ _13206_/A _13208_/A _13199_/B VPWR VGND sg13g2_nor2_1
XFILLER_96_300 VPWR VGND sg13g2_decap_8
XFILLER_44_1508 VPWR VGND sg13g2_fill_1
XFILLER_111_611 VPWR VGND sg13g2_decap_8
XFILLER_29_1065 VPWR VGND sg13g2_fill_1
XFILLER_61_1811 VPWR VGND sg13g2_decap_4
Xfanout2760 fanout2760/X fanout2768/X VPWR VGND sg13g2_buf_1
X_19815_ _19815_/Y _20316_/A2 _19514_/Y _19811_/Y _20222_/B VPWR VGND sg13g2_a22oi_1
XFILLER_29_1087 VPWR VGND sg13g2_fill_1
Xfanout2771 fanout2771/X fanout2772/X VPWR VGND sg13g2_buf_1
Xfanout2782 fanout2782/X fanout2790/X VPWR VGND sg13g2_buf_1
XFILLER_84_506 VPWR VGND sg13g2_decap_4
XFILLER_110_154 VPWR VGND sg13g2_decap_8
Xfanout2793 fanout2793/X fanout2794/X VPWR VGND sg13g2_buf_1
XFILLER_56_208 VPWR VGND sg13g2_fill_2
XFILLER_111_688 VPWR VGND sg13g2_decap_8
XFILLER_113_1934 VPWR VGND sg13g2_decap_8
X_19746_ _19746_/Y _19850_/A _19746_/B VPWR VGND sg13g2_nor2_1
X_16958_ _22701_/D _16946_/S _16956_/X _16957_/Y VPWR VGND sg13g2_o21ai_1
XFILLER_96_399 VPWR VGND sg13g2_decap_8
XFILLER_84_539 VPWR VGND sg13g2_decap_8
XFILLER_42_1254 VPWR VGND sg13g2_decap_4
X_15909_ _15909_/Y _22477_/Q _15980_/S VPWR VGND sg13g2_nand2b_1
XFILLER_49_293 VPWR VGND sg13g2_decap_8
XFILLER_96_1918 VPWR VGND sg13g2_decap_8
X_19677_ _19678_/A _20062_/B _19659_/Y _19665_/Y _19325_/X _19676_/Y VPWR VGND sg13g2_a221oi_1
X_16889_ _16889_/Y _22688_/Q _16889_/B VPWR VGND sg13g2_xnor2_1
XFILLER_4_1760 VPWR VGND sg13g2_decap_8
XFILLER_38_978 VPWR VGND sg13g2_fill_2
XFILLER_65_764 VPWR VGND sg13g2_decap_4
XFILLER_20_1530 VPWR VGND sg13g2_fill_1
XFILLER_64_252 VPWR VGND sg13g2_fill_2
XFILLER_0_1624 VPWR VGND sg13g2_fill_2
X_18628_ _18632_/A _18757_/A _18627_/X _23004_/Q VPWR VGND sg13g2_a21oi_1
XFILLER_111_1680 VPWR VGND sg13g2_decap_4
XFILLER_52_414 VPWR VGND sg13g2_decap_8
XFILLER_20_1585 VPWR VGND sg13g2_decap_8
XFILLER_20_1596 VPWR VGND sg13g2_decap_8
X_18559_ _18866_/B _17982_/B _23077_/Q _18890_/B VPWR VGND sg13g2_mux2_1
XFILLER_52_458 VPWR VGND sg13g2_decap_4
XFILLER_40_609 VPWR VGND sg13g2_fill_1
XFILLER_59_1784 VPWR VGND sg13g2_decap_4
XFILLER_75_1052 VPWR VGND sg13g2_decap_8
XFILLER_36_1014 VPWR VGND sg13g2_decap_8
XFILLER_90_1528 VPWR VGND sg13g2_decap_4
XFILLER_36_1025 VPWR VGND sg13g2_fill_1
XFILLER_55_1648 VPWR VGND sg13g2_fill_2
X_21570_ _21570_/Y _21570_/A _21581_/B VPWR VGND sg13g2_nand2_1
XFILLER_55_1659 VPWR VGND sg13g2_decap_4
Xplace4300 _13004_/S0 _13243_/S0 VPWR VGND sg13g2_buf_1
XFILLER_20_322 VPWR VGND sg13g2_fill_1
XFILLER_33_1902 VPWR VGND sg13g2_decap_8
Xplace4311 _12721_/S _13232_/S VPWR VGND sg13g2_buf_1
Xplace4322 _11749_/S _11752_/B VPWR VGND sg13g2_buf_4
X_20521_ _23317_/D _22390_/A1 _20578_/B _20520_/Y VPWR VGND sg13g2_o21ai_1
Xrebuffer5301 _12516_/B _12535_/B VPWR VGND sg13g2_buf_1
XFILLER_20_333 VPWR VGND sg13g2_decap_8
XFILLER_21_856 VPWR VGND sg13g2_decap_8
XFILLER_18_1470 VPWR VGND sg13g2_fill_1
XFILLER_21_867 VPWR VGND sg13g2_decap_8
Xclkbuf_leaf_8_clk_i clkload15/A clkload0/A VPWR VGND sg13g2_buf_16
XFILLER_53_1350 VPWR VGND sg13g2_fill_1
Xplace4333 _11861_/B _22978_/Q VPWR VGND sg13g2_buf_1
Xrebuffer5312 _13637_/A1 _12575_/Y VPWR VGND sg13g2_buf_1
Xrebuffer5323 _18742_/B _14533_/Y VPWR VGND sg13g2_buf_8
Xplace4344 _11250_/A _11311_/B VPWR VGND sg13g2_buf_1
Xplace3610 _18692_/B _14990_/B VPWR VGND sg13g2_buf_1
Xrebuffer5334 _20228_/A _13433_/A VPWR VGND sg13g2_buf_1
Xplace3621 _19703_/A _19874_/A VPWR VGND sg13g2_buf_1
Xrebuffer5345 place3794/A _11372_/Y VPWR VGND sg13g2_buf_2
Xrebuffer4600 _12694_/B _12692_/Y VPWR VGND sg13g2_buf_2
XFILLER_53_1383 VPWR VGND sg13g2_fill_2
X_23240_ _23240_/Q clkload32/A _23240_/D fanout2647/X VPWR VGND sg13g2_dfrbpq_1
Xrebuffer4611 _12963_/A _12098_/A1 VPWR VGND sg13g2_buf_1
X_20452_ _23288_/D _19750_/Y _20451_/B _20451_/Y VPWR VGND sg13g2_o21ai_1
Xplace3632 _14998_/B _15067_/B VPWR VGND sg13g2_buf_1
XFILLER_21_16 VPWR VGND sg13g2_fill_1
Xrebuffer5356 _18661_/A _14553_/Y VPWR VGND sg13g2_buf_1
Xplace3643 _14715_/B _14720_/B VPWR VGND sg13g2_buf_1
Xrebuffer5367 _14116_/C _11623_/D VPWR VGND sg13g2_buf_1
Xrebuffer4622 _12952_/B _12949_/A VPWR VGND sg13g2_buf_1
XFILLER_88_1424 VPWR VGND sg13g2_decap_8
Xplace3654 _17824_/A2 _17670_/A2 VPWR VGND sg13g2_buf_1
Xrebuffer4633 _14853_/A1 _14229_/A VPWR VGND sg13g2_buf_1
Xrebuffer5378 _19480_/B _11590_/Y VPWR VGND sg13g2_buf_8
Xrebuffer5389 _12529_/B _12623_/A VPWR VGND sg13g2_buf_1
Xhold5002 _22413_/A _24192_/Q VPWR VGND sg13g2_dlygate4sd3_1
Xplace3665 _17386_/B _16060_/B VPWR VGND sg13g2_buf_1
Xplace3676 _14966_/B _14826_/X VPWR VGND sg13g2_buf_1
X_23171_ _23171_/Q clkload17/A _23171_/D fanout2858/X VPWR VGND sg13g2_dfrbpq_1
Xplace2942 _20927_/A1 _22390_/A1 VPWR VGND sg13g2_buf_1
X_20383_ _23256_/D _21301_/A1 _20380_/B _20382_/Y VPWR VGND sg13g2_o21ai_1
Xhold5013 _22087_/A _24035_/Q VPWR VGND sg13g2_dlygate4sd3_1
Xplace3687 _15839_/A _20229_/B VPWR VGND sg13g2_buf_1
Xplace2953 _19048_/B1 _18960_/B1 VPWR VGND sg13g2_buf_1
Xhold5024 _22160_/A _24070_/Q VPWR VGND sg13g2_dlygate4sd3_1
XFILLER_106_427 VPWR VGND sg13g2_fill_1
Xhold5035 _21783_/A _23892_/Q VPWR VGND sg13g2_dlygate4sd3_1
Xplace3698 _20034_/A _12843_/A VPWR VGND sg13g2_buf_1
XFILLER_106_438 VPWR VGND sg13g2_decap_8
Xhold5046 _22123_/A _24053_/Q VPWR VGND sg13g2_dlygate4sd3_1
Xplace2964 _16421_/S _18667_/A VPWR VGND sg13g2_buf_1
Xplace2975 _18221_/S _18140_/B VPWR VGND sg13g2_buf_1
Xhold5057 _22158_/A _24069_/Q VPWR VGND sg13g2_dlygate4sd3_1
Xplace2986 _18824_/S _18780_/S VPWR VGND sg13g2_buf_1
Xplace2997 _18587_/C _18780_/S VPWR VGND sg13g2_buf_1
Xhold5068 _21532_/A _23782_/Q VPWR VGND sg13g2_dlygate4sd3_1
XFILLER_66_1733 VPWR VGND sg13g2_decap_4
Xhold5079 _21370_/A _23705_/Q VPWR VGND sg13g2_dlygate4sd3_1
XFILLER_86_1192 VPWR VGND sg13g2_decap_4
XFILLER_47_1143 VPWR VGND sg13g2_decap_4
XFILLER_99_182 VPWR VGND sg13g2_decap_8
X_21004_ _23543_/D _22262_/A1 _21013_/B _21003_/Y VPWR VGND sg13g2_o21ai_1
XFILLER_47_1176 VPWR VGND sg13g2_decap_8
XFILLER_101_110 VPWR VGND sg13g2_decap_8
XFILLER_47_1187 VPWR VGND sg13g2_fill_1
XFILLER_88_878 VPWR VGND sg13g2_decap_8
XFILLER_29_934 VPWR VGND sg13g2_decap_8
XFILLER_56_731 VPWR VGND sg13g2_decap_8
XFILLER_99_1553 VPWR VGND sg13g2_decap_4
XFILLER_5_1568 VPWR VGND sg13g2_decap_8
XFILLER_29_956 VPWR VGND sg13g2_fill_1
XFILLER_56_753 VPWR VGND sg13g2_decap_4
X_22955_ _22955_/Q _23187_/CLK _22955_/D fanout2919/X VPWR VGND sg13g2_dfrbpq_1
XFILLER_28_455 VPWR VGND sg13g2_decap_4
XFILLER_29_989 VPWR VGND sg13g2_decap_8
XFILLER_95_1417 VPWR VGND sg13g2_decap_4
XFILLER_112_1499 VPWR VGND sg13g2_fill_1
X_21906_ _23949_/D _21972_/A0 _23949_/Q _21915_/S VPWR VGND sg13g2_mux2_1
XFILLER_95_1439 VPWR VGND sg13g2_fill_1
XFILLER_15_105 VPWR VGND sg13g2_fill_1
XFILLER_3_1270 VPWR VGND sg13g2_decap_8
XFILLER_43_414 VPWR VGND sg13g2_decap_8
XFILLER_44_937 VPWR VGND sg13g2_decap_4
XFILLER_43_425 VPWR VGND sg13g2_fill_1
X_22886_ _22886_/Q _22917_/CLK _22886_/D fanout2893/X VPWR VGND sg13g2_dfrbpq_1
XFILLER_43_436 VPWR VGND sg13g2_decap_4
XFILLER_93_1130 VPWR VGND sg13g2_decap_8
XFILLER_15_149 VPWR VGND sg13g2_fill_1
XFILLER_73_1704 VPWR VGND sg13g2_decap_8
XFILLER_102_63 VPWR VGND sg13g2_decap_8
X_21837_ _21837_/Y _23916_/Q _21843_/B VPWR VGND sg13g2_nand2_1
XFILLER_54_1114 VPWR VGND sg13g2_decap_8
XFILLER_58_1283 VPWR VGND sg13g2_fill_2
XFILLER_73_1737 VPWR VGND sg13g2_decap_8
XFILLER_24_672 VPWR VGND sg13g2_decap_8
X_12570_ _12570_/X _24033_/Q _24097_/Q _12570_/S VPWR VGND sg13g2_mux2_1
XFILLER_58_1294 VPWR VGND sg13g2_fill_1
XFILLER_73_1748 VPWR VGND sg13g2_fill_1
XFILLER_11_300 VPWR VGND sg13g2_fill_1
X_21768_ _23884_/D _21971_/A1 _21771_/B _21767_/Y VPWR VGND sg13g2_o21ai_1
XFILLER_12_834 VPWR VGND sg13g2_fill_1
XFILLER_19_1278 VPWR VGND sg13g2_decap_8
XFILLER_12_856 VPWR VGND sg13g2_fill_2
X_23507_ _23507_/Q clkload51/A _23507_/D fanout2665/X VPWR VGND sg13g2_dfrbpq_1
X_11521_ _11521_/X _23541_/Q _23989_/Q _13797_/S VPWR VGND sg13g2_mux2_1
X_20719_ _20784_/B _20719_/A _20921_/B VPWR VGND sg13g2_nand2_1
XFILLER_109_210 VPWR VGND sg13g2_decap_8
X_11452_ _11452_/Y _12123_/A _23894_/Q _12119_/A VPWR VGND sg13g2_o21ai_1
X_14240_ _14241_/D _14240_/A _14342_/B VPWR VGND sg13g2_nor2_1
X_23438_ _23438_/Q clkload38/A _23438_/D fanout2631/X VPWR VGND sg13g2_dfrbpq_1
XFILLER_32_1478 VPWR VGND sg13g2_decap_8
X_14171_ _14172_/B _22945_/Q VPWR VGND sg13g2_inv_1
X_11383_ _11383_/X _23894_/Q _23990_/Q _11919_/S VPWR VGND sg13g2_mux2_1
X_23369_ _23369_/Q _24205_/CLK _23369_/D fanout2671/X VPWR VGND sg13g2_dfrbpq_1
XFILLER_109_276 VPWR VGND sg13g2_decap_8
XFILLER_84_1800 VPWR VGND sg13g2_fill_1
X_13122_ _13123_/C _13108_/Y _13112_/Y _13116_/Y _13121_/X _11355_/A _12712_/A VPWR
+ VGND sg13g2_mux4_1
XFILLER_3_532 VPWR VGND sg13g2_decap_4
XFILLER_112_408 VPWR VGND sg13g2_decap_8
XFILLER_2_0 VPWR VGND sg13g2_decap_8
XFILLER_97_108 VPWR VGND sg13g2_fill_1
X_17930_ _17931_/B _22941_/Q _17930_/B VPWR VGND sg13g2_nand2_1
X_13053_ _13053_/X _13051_/X _13052_/X _13244_/S VPWR VGND sg13g2_mux2_1
XFILLER_3_576 VPWR VGND sg13g2_fill_1
XFILLER_84_1877 VPWR VGND sg13g2_decap_8
X_12004_ _12004_/X _23547_/Q _23995_/Q _12004_/S VPWR VGND sg13g2_mux2_1
XFILLER_87_64 VPWR VGND sg13g2_decap_8
XFILLER_79_856 VPWR VGND sg13g2_fill_2
XFILLER_78_333 VPWR VGND sg13g2_fill_2
Xhold4890 _20860_/A _23477_/Q VPWR VGND sg13g2_dlygate4sd3_1
XFILLER_39_709 VPWR VGND sg13g2_decap_8
X_19600_ _19600_/Y _19605_/A _19978_/B VPWR VGND sg13g2_nor2_1
X_16812_ _16813_/B _16812_/A _16833_/A _16812_/C VPWR VGND sg13g2_nor3_1
XFILLER_94_848 VPWR VGND sg13g2_decap_8
X_17792_ _17792_/X _22575_/Q _17792_/B VPWR VGND sg13g2_xor2_1
XFILLER_19_411 VPWR VGND sg13g2_fill_2
XFILLER_43_1574 VPWR VGND sg13g2_fill_1
XFILLER_59_580 VPWR VGND sg13g2_fill_1
X_19531_ _23221_/D _20190_/S _20927_/A1 _19530_/Y VPWR VGND sg13g2_o21ai_1
X_16743_ _16796_/B _22663_/Q _22662_/Q _16748_/C VPWR VGND sg13g2_nand3_1
X_13955_ _13955_/X _23572_/Q _24020_/Q _13955_/S VPWR VGND sg13g2_mux2_1
XFILLER_81_509 VPWR VGND sg13g2_decap_8
XFILLER_35_904 VPWR VGND sg13g2_decap_8
XFILLER_59_1014 VPWR VGND sg13g2_decap_4
XFILLER_74_561 VPWR VGND sg13g2_fill_2
X_19462_ _19462_/Y _19587_/A _19462_/B VPWR VGND sg13g2_nand2_1
X_12906_ _12906_/X _12906_/A _12906_/B VPWR VGND sg13g2_or2_1
X_16674_ _22650_/D _16203_/A _16673_/A _16673_/Y VPWR VGND sg13g2_a21oi_1
XFILLER_1_1944 VPWR VGND sg13g2_decap_8
XFILLER_62_723 VPWR VGND sg13g2_fill_1
XFILLER_19_499 VPWR VGND sg13g2_fill_2
X_13886_ _13886_/Y _13886_/A _13886_/B _13886_/C _13886_/D VPWR VGND sg13g2_nor4_2
X_18413_ _18421_/B _17947_/B _18803_/B _18549_/S VPWR VGND sg13g2_mux2_1
X_15625_ _15667_/B _15972_/B _15625_/B VPWR VGND sg13g2_and2_1
XFILLER_59_1069 VPWR VGND sg13g2_decap_8
X_19393_ _19394_/B _19563_/B _19389_/Y _19392_/X VPWR VGND sg13g2_a21oi_1
XFILLER_34_458 VPWR VGND sg13g2_fill_1
X_12837_ _12837_/Y _12837_/A _20035_/B VPWR VGND sg13g2_nor2_1
XFILLER_91_1815 VPWR VGND sg13g2_decap_4
XFILLER_15_650 VPWR VGND sg13g2_decap_8
XFILLER_72_1203 VPWR VGND sg13g2_fill_2
X_18344_ _18405_/A _18403_/A _18344_/B VPWR VGND sg13g2_nand2_1
XFILLER_15_694 VPWR VGND sg13g2_fill_1
XFILLER_37_1356 VPWR VGND sg13g2_decap_4
X_12768_ _12769_/A _14056_/B _14054_/B _12768_/S VPWR VGND sg13g2_mux2_2
XFILLER_33_1209 VPWR VGND sg13g2_fill_1
X_14507_ _14508_/D _14507_/A _14507_/B _14507_/C _14507_/D VPWR VGND sg13g2_nor4_1
X_11719_ _11720_/B _23768_/Q _23928_/Q _11723_/S VPWR VGND sg13g2_mux2_1
X_18275_ _18275_/Y _18279_/A _18275_/B _18275_/C VPWR VGND sg13g2_nor3_1
XFILLER_37_1389 VPWR VGND sg13g2_decap_4
X_15487_ _15488_/B _22691_/Q _15487_/A2 _15487_/B1 _22627_/Q VPWR VGND sg13g2_a22oi_1
XFILLER_15_1621 VPWR VGND sg13g2_decap_8
XFILLER_15_1632 VPWR VGND sg13g2_fill_2
XFILLER_54_1681 VPWR VGND sg13g2_decap_4
X_12699_ _14935_/B _12853_/B _12699_/B _12699_/C VPWR VGND sg13g2_or3_1
XFILLER_89_1700 VPWR VGND sg13g2_fill_2
X_17226_ _17229_/B _17226_/A _17226_/B _17226_/C VPWR VGND sg13g2_nand3_1
X_14438_ _14439_/C _14341_/B _14438_/B _14438_/C VPWR VGND sg13g2_nand3b_1
XFILLER_50_1578 VPWR VGND sg13g2_fill_2
X_17157_ _17157_/Y _22735_/Q _17157_/B VPWR VGND sg13g2_xnor2_1
X_14369_ _15172_/A _19980_/B _15257_/B _16782_/C _14369_/D VPWR VGND sg13g2_and4_1
XFILLER_115_224 VPWR VGND sg13g2_decap_8
X_17088_ _22722_/D _17092_/B _17085_/Y _17087_/Y VPWR VGND sg13g2_a21oi_1
XFILLER_88_108 VPWR VGND sg13g2_decap_8
XFILLER_83_1343 VPWR VGND sg13g2_fill_2
XFILLER_83_1365 VPWR VGND sg13g2_decap_8
XFILLER_35_0 VPWR VGND sg13g2_decap_8
XFILLER_111_441 VPWR VGND sg13g2_decap_8
XFILLER_6_1833 VPWR VGND sg13g2_decap_8
XFILLER_85_837 VPWR VGND sg13g2_decap_8
XFILLER_111_485 VPWR VGND sg13g2_decap_8
XFILLER_85_848 VPWR VGND sg13g2_fill_1
XFILLER_26_1783 VPWR VGND sg13g2_fill_1
XFILLER_22_1625 VPWR VGND sg13g2_fill_2
XFILLER_2_1708 VPWR VGND sg13g2_decap_8
XFILLER_38_742 VPWR VGND sg13g2_decap_4
XFILLER_96_1704 VPWR VGND sg13g2_decap_8
X_19729_ _19729_/Y _19728_/A _19727_/X _19728_/Y VPWR VGND sg13g2_o21ai_1
XFILLER_38_753 VPWR VGND sg13g2_fill_1
XFILLER_65_550 VPWR VGND sg13g2_fill_2
XFILLER_93_881 VPWR VGND sg13g2_decap_8
XFILLER_38_797 VPWR VGND sg13g2_decap_8
X_22740_ _22740_/Q clkload20/A _22740_/D fanout2869/X VPWR VGND sg13g2_dfrbpq_1
XFILLER_0_1421 VPWR VGND sg13g2_decap_4
XFILLER_26_959 VPWR VGND sg13g2_fill_2
XFILLER_16_49 VPWR VGND sg13g2_fill_2
XFILLER_25_447 VPWR VGND sg13g2_fill_2
XFILLER_25_458 VPWR VGND sg13g2_decap_8
X_22671_ _22671_/Q clkload20/A _22671_/D fanout2867/X VPWR VGND sg13g2_dfrbpq_1
XFILLER_59_1570 VPWR VGND sg13g2_fill_1
XFILLER_94_1461 VPWR VGND sg13g2_decap_4
X_21622_ _23828_/D _21622_/A1 _21621_/B _21621_/Y VPWR VGND sg13g2_o21ai_1
XFILLER_94_1494 VPWR VGND sg13g2_fill_2
X_21553_ _23794_/D _21619_/A1 _21555_/B _21552_/Y VPWR VGND sg13g2_o21ai_1
Xplace4130 _12377_/S _12502_/S VPWR VGND sg13g2_buf_4
XFILLER_32_37 VPWR VGND sg13g2_fill_2
Xplace4141 _12485_/S _12487_/S VPWR VGND sg13g2_buf_2
XFILLER_20_163 VPWR VGND sg13g2_decap_4
XFILLER_21_686 VPWR VGND sg13g2_decap_4
X_20504_ _20504_/Y _23312_/Q _20504_/B VPWR VGND sg13g2_nand2_1
X_24272_ _24272_/X _24272_/A VPWR VGND sg13g2_buf_1
Xplace4152 _13645_/A _11493_/A VPWR VGND sg13g2_buf_2
Xplace4163 _13398_/S _11815_/S1 VPWR VGND sg13g2_buf_4
XFILLER_53_1191 VPWR VGND sg13g2_decap_8
X_21484_ _23760_/D _21616_/A1 _21483_/B _21483_/Y VPWR VGND sg13g2_o21ai_1
XFILLER_14_1153 VPWR VGND sg13g2_fill_1
Xplace4174 _12986_/S1 _13259_/B VPWR VGND sg13g2_buf_1
Xplace3440 _17929_/B1 _17855_/B VPWR VGND sg13g2_buf_1
Xplace4185 _12884_/B _12877_/B VPWR VGND sg13g2_buf_1
X_23223_ _23223_/Q clkload57/A _23223_/D fanout2747/X VPWR VGND sg13g2_dfrbpq_1
Xplace3451 _17220_/B _17226_/A VPWR VGND sg13g2_buf_1
Xplace4196 _13840_/S0 _13962_/S0 VPWR VGND sg13g2_buf_2
Xplace3462 _16830_/A _16846_/A VPWR VGND sg13g2_buf_1
X_20435_ _20435_/Y _23284_/Q _20435_/B VPWR VGND sg13g2_nand2_1
XFILLER_113_7 VPWR VGND sg13g2_decap_8
XFILLER_101_1145 VPWR VGND sg13g2_decap_8
Xplace3473 _16678_/S _16666_/S VPWR VGND sg13g2_buf_1
XFILLER_4_318 VPWR VGND sg13g2_fill_2
XFILLER_88_1254 VPWR VGND sg13g2_fill_1
Xplace3484 _16183_/B _16203_/B VPWR VGND sg13g2_buf_1
Xplace3495 _17007_/A1 _16972_/B VPWR VGND sg13g2_buf_1
X_23154_ _23154_/Q clkload14/A _23154_/D fanout2843/X VPWR VGND sg13g2_dfrbpq_1
XFILLER_84_1118 VPWR VGND sg13g2_fill_2
X_20366_ _23252_/D _20365_/B _22451_/A1 _20365_/Y VPWR VGND sg13g2_o21ai_1
XFILLER_106_268 VPWR VGND sg13g2_decap_8
X_22105_ _22105_/Y _22105_/A _22108_/B VPWR VGND sg13g2_nand2_1
X_23085_ _23085_/Q clkload12/A _23085_/D fanout2911/X VPWR VGND sg13g2_dfrbpq_1
X_20297_ _20297_/Y _20362_/A1 _20285_/Y _20296_/Y _20201_/B VPWR VGND sg13g2_a22oi_1
X_22036_ _22036_/Y _22036_/A _22048_/B VPWR VGND sg13g2_nand2_1
XFILLER_88_686 VPWR VGND sg13g2_decap_4
XFILLER_9_1490 VPWR VGND sg13g2_fill_2
XFILLER_57_56 VPWR VGND sg13g2_decap_8
XFILLER_29_731 VPWR VGND sg13g2_decap_8
XFILLER_40_1725 VPWR VGND sg13g2_decap_8
X_23987_ _23987_/Q clkload51/A _23987_/D fanout2667/X VPWR VGND sg13g2_dfrbpq_1
XFILLER_28_241 VPWR VGND sg13g2_decap_8
XFILLER_17_926 VPWR VGND sg13g2_decap_8
XFILLER_56_572 VPWR VGND sg13g2_fill_1
XFILLER_90_328 VPWR VGND sg13g2_fill_2
X_13740_ _13741_/D _14060_/A _13436_/Y _13740_/B1 _13440_/Y _13739_/Y VPWR VGND sg13g2_a221oi_1
X_22938_ _22938_/Q _22941_/CLK _22938_/D fanout2802/X VPWR VGND sg13g2_dfrbpq_1
XFILLER_73_22 VPWR VGND sg13g2_fill_1
XFILLER_113_84 VPWR VGND sg13g2_decap_8
XFILLER_28_285 VPWR VGND sg13g2_fill_2
XFILLER_43_211 VPWR VGND sg13g2_decap_4
XFILLER_71_520 VPWR VGND sg13g2_decap_8
XFILLER_73_44 VPWR VGND sg13g2_fill_2
XFILLER_95_1269 VPWR VGND sg13g2_fill_1
XFILLER_43_244 VPWR VGND sg13g2_fill_2
X_13671_ _13671_/Y _23632_/Q _13671_/B VPWR VGND sg13g2_nand2b_1
X_22869_ _22869_/Q _22869_/CLK _22869_/D fanout2797/X VPWR VGND sg13g2_dfrbpq_1
XFILLER_71_575 VPWR VGND sg13g2_fill_2
X_15410_ _15410_/Y _15410_/A _16353_/B VPWR VGND sg13g2_nor2_1
XFILLER_31_417 VPWR VGND sg13g2_fill_1
X_12622_ _12622_/Y _12829_/B _12632_/D VPWR VGND sg13g2_nor2_1
XFILLER_73_1534 VPWR VGND sg13g2_decap_4
X_16390_ _22560_/D _23010_/Q _22560_/Q _18657_/B VPWR VGND sg13g2_mux2_1
XFILLER_19_1064 VPWR VGND sg13g2_decap_8
XFILLER_8_602 VPWR VGND sg13g2_fill_1
X_12553_ _12553_/Y _12550_/Y _11681_/A _12551_/X VPWR VGND sg13g2_o21ai_1
XFILLER_12_664 VPWR VGND sg13g2_decap_8
X_11504_ _11504_/X _23829_/Q _23861_/Q _23925_/Q _23957_/Q _12028_/A _12006_/S1 VPWR
+ VGND sg13g2_mux4_1
XFILLER_90_1892 VPWR VGND sg13g2_fill_2
XFILLER_89_1018 VPWR VGND sg13g2_decap_8
XFILLER_11_185 VPWR VGND sg13g2_decap_8
X_12484_ _12489_/B _12499_/A _12484_/B VPWR VGND sg13g2_nor2_1
XFILLER_12_1827 VPWR VGND sg13g2_decap_8
XFILLER_11_196 VPWR VGND sg13g2_fill_2
X_17011_ _17011_/Y _17202_/A _17021_/B VPWR VGND sg13g2_nand2_1
XFILLER_7_156 VPWR VGND sg13g2_decap_8
X_14223_ _14831_/A _15826_/B2 _22828_/Q _14222_/X VPWR VGND sg13g2_a21oi_2
X_11435_ _11435_/Y _13624_/A _11392_/Y _11434_/Y VPWR VGND sg13g2_o21ai_1
XFILLER_22_81 VPWR VGND sg13g2_decap_4
XFILLER_99_907 VPWR VGND sg13g2_decap_8
X_14154_ _14155_/B _15216_/B _14154_/B VPWR VGND sg13g2_or2_1
XFILLER_98_63 VPWR VGND sg13g2_decap_8
X_13105_ _13105_/X _23720_/Q _23752_/Q _23784_/Q _23816_/Q _13606_/S0 _13606_/S1 VPWR
+ VGND sg13g2_mux4_1
X_11297_ _11297_/X _23703_/Q _23767_/Q _23831_/Q _23927_/Q _12006_/S1 _11723_/S VPWR
+ VGND sg13g2_mux4_1
X_18962_ _18964_/B _18962_/A _19039_/B VPWR VGND sg13g2_nand2_1
X_14085_ _14096_/A _14107_/A _19320_/C _14084_/Y VPWR VGND sg13g2_o21ai_1
XFILLER_84_1663 VPWR VGND sg13g2_fill_1
XFILLER_112_238 VPWR VGND sg13g2_decap_8
XFILLER_26_1002 VPWR VGND sg13g2_fill_1
XFILLER_49_1794 VPWR VGND sg13g2_decap_8
X_17913_ _22935_/D _17913_/A _17913_/B VPWR VGND sg13g2_nand2_1
X_18893_ _18893_/Y _23047_/Q _18886_/A _18580_/X VPWR VGND sg13g2_o21ai_1
XFILLER_80_1538 VPWR VGND sg13g2_fill_1
XFILLER_26_1035 VPWR VGND sg13g2_fill_1
XFILLER_45_1658 VPWR VGND sg13g2_fill_2
XFILLER_78_152 VPWR VGND sg13g2_fill_2
XFILLER_39_528 VPWR VGND sg13g2_decap_8
X_17844_ _17844_/Y _22913_/Q _17853_/B _17869_/B VPWR VGND sg13g2_nand3_1
XFILLER_66_325 VPWR VGND sg13g2_fill_2
XFILLER_94_645 VPWR VGND sg13g2_decap_8
XFILLER_94_667 VPWR VGND sg13g2_decap_4
X_17775_ _22902_/D _17789_/B _17773_/Y _17774_/Y VPWR VGND sg13g2_a21oi_1
XFILLER_110_1915 VPWR VGND sg13g2_decap_8
XFILLER_93_155 VPWR VGND sg13g2_decap_8
XFILLER_19_241 VPWR VGND sg13g2_fill_1
X_14987_ _14987_/Y _17890_/A1 _14801_/B _15068_/A VPWR VGND sg13g2_o21ai_1
XFILLER_81_317 VPWR VGND sg13g2_fill_1
X_16726_ _16727_/B _22660_/Q _22659_/Q _16726_/C VPWR VGND sg13g2_nand3_1
XFILLER_78_1434 VPWR VGND sg13g2_decap_8
X_19514_ _19514_/Y _19514_/A _23196_/Q VPWR VGND sg13g2_nor2_1
X_13938_ _13938_/Y _20322_/A _13938_/B VPWR VGND sg13g2_nand2_1
XFILLER_1_1741 VPWR VGND sg13g2_decap_8
XFILLER_90_840 VPWR VGND sg13g2_fill_1
X_19445_ _19644_/B _19582_/B _19587_/B _19587_/A VPWR VGND sg13g2_mux2_1
XFILLER_62_542 VPWR VGND sg13g2_fill_1
XFILLER_56_1710 VPWR VGND sg13g2_decap_8
X_16657_ _22646_/D _16504_/Y _16656_/A _16656_/Y VPWR VGND sg13g2_a21oi_1
XFILLER_91_1601 VPWR VGND sg13g2_decap_8
X_13869_ _13869_/Y _13876_/A _13876_/B VPWR VGND sg13g2_nand2_1
XFILLER_35_789 VPWR VGND sg13g2_fill_1
XFILLER_91_1612 VPWR VGND sg13g2_fill_2
XFILLER_16_970 VPWR VGND sg13g2_decap_8
Xclkbuf_leaf_73_clk_i _22941_/CLK clkbuf_leaf_0_clk_i/A VPWR VGND sg13g2_buf_16
XFILLER_62_586 VPWR VGND sg13g2_fill_1
X_15608_ _17517_/D _20013_/B _15785_/B _15607_/X VPWR VGND sg13g2_a21oi_1
X_19376_ _19376_/Y _19589_/A _19372_/Y _19375_/Y VPWR VGND sg13g2_a21oi_1
X_16588_ _22632_/D _17517_/D _16591_/A _16587_/Y VPWR VGND sg13g2_a21oi_1
XFILLER_37_1153 VPWR VGND sg13g2_decap_8
XFILLER_108_1855 VPWR VGND sg13g2_decap_8
XFILLER_91_1667 VPWR VGND sg13g2_fill_1
X_18327_ _18327_/X _18451_/C _18326_/Y _18421_/A VPWR VGND sg13g2_a21o_1
XFILLER_37_1164 VPWR VGND sg13g2_decap_8
X_15539_ _19941_/A _15539_/A _15539_/B _15539_/C _15562_/A VPWR VGND sg13g2_nor4_1
XFILLER_31_973 VPWR VGND sg13g2_decap_8
XFILLER_104_1719 VPWR VGND sg13g2_decap_8
XFILLER_15_1440 VPWR VGND sg13g2_decap_8
X_18258_ _18259_/D _18425_/A _18377_/A VPWR VGND sg13g2_nor2_1
XFILLER_30_483 VPWR VGND sg13g2_decap_8
XFILLER_50_1331 VPWR VGND sg13g2_decap_8
XFILLER_30_1927 VPWR VGND sg13g2_fill_1
X_17209_ _17209_/Y _17209_/A _17209_/B VPWR VGND sg13g2_nor2_1
X_18189_ _18216_/B _18485_/B _18189_/B VPWR VGND sg13g2_nand2_1
X_20220_ _20220_/Y _20220_/A _20300_/B VPWR VGND sg13g2_nand2_1
XFILLER_102_1498 VPWR VGND sg13g2_decap_8
XFILLER_89_406 VPWR VGND sg13g2_fill_2
XFILLER_89_417 VPWR VGND sg13g2_decap_8
Xclkbuf_leaf_11_clk_i clkload28/A clkbuf_leaf_9_clk_i/A VPWR VGND sg13g2_buf_16
X_20151_ _20153_/C _19325_/X _20032_/Y _20150_/Y VPWR VGND sg13g2_a21oi_1
XFILLER_89_439 VPWR VGND sg13g2_decap_8
XFILLER_83_1140 VPWR VGND sg13g2_decap_8
X_20082_ _20082_/Y _20082_/A _20082_/B VPWR VGND sg13g2_nand2_1
XFILLER_69_130 VPWR VGND sg13g2_decap_8
XFILLER_97_450 VPWR VGND sg13g2_decap_8
XFILLER_115_1826 VPWR VGND sg13g2_decap_8
XFILLER_112_761 VPWR VGND sg13g2_decap_8
X_23910_ _23910_/Q clkload37/A _23910_/D fanout2713/X VPWR VGND sg13g2_dfrbpq_1
XFILLER_111_271 VPWR VGND sg13g2_decap_8
XFILLER_84_111 VPWR VGND sg13g2_fill_1
Xclkbuf_leaf_26_clk_i clkload50/A clkload3/A VPWR VGND sg13g2_buf_16
XFILLER_6_1652 VPWR VGND sg13g2_decap_8
XFILLER_84_133 VPWR VGND sg13g2_decap_8
X_23841_ _23841_/Q clkload43/A _23841_/D fanout2738/X VPWR VGND sg13g2_dfrbpq_1
XFILLER_61_1482 VPWR VGND sg13g2_fill_2
XFILLER_85_678 VPWR VGND sg13g2_decap_8
XFILLER_84_166 VPWR VGND sg13g2_fill_2
XFILLER_27_48 VPWR VGND sg13g2_decap_8
XFILLER_66_881 VPWR VGND sg13g2_decap_8
XFILLER_38_583 VPWR VGND sg13g2_decap_4
X_23772_ _23772_/Q _23966_/CLK _23772_/D fanout2764/X VPWR VGND sg13g2_dfrbpq_1
XFILLER_22_1488 VPWR VGND sg13g2_decap_8
X_20984_ _23536_/D _22445_/A1 _20990_/B _20983_/Y VPWR VGND sg13g2_o21ai_1
XFILLER_26_745 VPWR VGND sg13g2_decap_8
XFILLER_53_531 VPWR VGND sg13g2_decap_8
XFILLER_57_1507 VPWR VGND sg13g2_decap_8
XFILLER_65_391 VPWR VGND sg13g2_decap_8
XFILLER_81_851 VPWR VGND sg13g2_decap_8
X_22723_ _22723_/Q clkload25/A _22723_/D fanout2885/X VPWR VGND sg13g2_dfrbpq_1
XFILLER_25_255 VPWR VGND sg13g2_decap_8
XFILLER_74_1821 VPWR VGND sg13g2_fill_1
XFILLER_43_14 VPWR VGND sg13g2_decap_8
X_22654_ _22654_/Q clkload24/A _22654_/D fanout2889/X VPWR VGND sg13g2_dfrbpq_1
XFILLER_13_439 VPWR VGND sg13g2_fill_2
XFILLER_43_36 VPWR VGND sg13g2_decap_8
XFILLER_90_1122 VPWR VGND sg13g2_decap_8
XFILLER_70_1707 VPWR VGND sg13g2_fill_2
X_21605_ _21605_/Y _21605_/A _21605_/B VPWR VGND sg13g2_nand2_1
X_22585_ _22585_/Q clkload22/A _22585_/D fanout2885/X VPWR VGND sg13g2_dfrbpq_1
XFILLER_74_1898 VPWR VGND sg13g2_fill_1
XFILLER_33_1540 VPWR VGND sg13g2_fill_1
X_24255_ _24255_/X _24255_/A VPWR VGND sg13g2_buf_1
X_21467_ _21467_/Y _21467_/A _21467_/B VPWR VGND sg13g2_nand2_1
Xplace3270 _21342_/A1 _20237_/Y VPWR VGND sg13g2_buf_1
X_11220_ _11222_/A _23190_/Q _23191_/Q VPWR VGND sg13g2_nand2b_1
Xplace3281 _22429_/A1 _22296_/A1 VPWR VGND sg13g2_buf_1
X_20418_ _23273_/D _22233_/A0 _23273_/Q _20434_/S VPWR VGND sg13g2_mux2_1
X_23206_ _23206_/Q clkload33/A _23206_/D fanout2930/X VPWR VGND sg13g2_dfrbpq_1
XFILLER_11_1860 VPWR VGND sg13g2_decap_8
XFILLER_4_137 VPWR VGND sg13g2_decap_8
Xplace3292 _21261_/A1 _20101_/Y VPWR VGND sg13g2_buf_1
XFILLER_107_555 VPWR VGND sg13g2_decap_8
XFILLER_88_1073 VPWR VGND sg13g2_fill_1
X_21398_ _21398_/Y _21398_/A _21398_/B VPWR VGND sg13g2_nand2_1
X_24186_ _24186_/Q clkload44/A _24186_/D fanout2753/X VPWR VGND sg13g2_dfrbpq_1
XFILLER_29_1609 VPWR VGND sg13g2_decap_8
XFILLER_68_1658 VPWR VGND sg13g2_decap_4
XFILLER_88_1095 VPWR VGND sg13g2_fill_1
XFILLER_85_1950 VPWR VGND sg13g2_decap_4
X_20349_ _20350_/B _20222_/B _20349_/A2 _20222_/Y VPWR VGND sg13g2_o21ai_1
X_23137_ _23137_/Q clkload5/A _23137_/D fanout2841/X VPWR VGND sg13g2_dfrbpq_1
XFILLER_108_84 VPWR VGND sg13g2_decap_8
X_23068_ _23068_/Q _23114_/CLK _23068_/D fanout2905/X VPWR VGND sg13g2_dfrbpq_1
XFILLER_95_409 VPWR VGND sg13g2_fill_1
XFILLER_49_815 VPWR VGND sg13g2_decap_8
X_22019_ _22019_/Y _22019_/A _22039_/B VPWR VGND sg13g2_nand2_1
XFILLER_88_483 VPWR VGND sg13g2_decap_4
XFILLER_68_99 VPWR VGND sg13g2_decap_8
X_15890_ _15890_/Y _15981_/S _16181_/A VPWR VGND sg13g2_nor2_1
XFILLER_48_336 VPWR VGND sg13g2_decap_8
XFILLER_114_1358 VPWR VGND sg13g2_fill_1
XFILLER_44_1680 VPWR VGND sg13g2_fill_2
XFILLER_48_347 VPWR VGND sg13g2_fill_1
X_14841_ _14841_/Y _22516_/Q _16233_/B _16231_/B _14840_/Y VPWR VGND sg13g2_a22oi_1
XFILLER_40_1522 VPWR VGND sg13g2_decap_4
XFILLER_44_1691 VPWR VGND sg13g2_fill_2
XFILLER_64_807 VPWR VGND sg13g2_decap_8
XFILLER_79_1721 VPWR VGND sg13g2_fill_1
XFILLER_29_561 VPWR VGND sg13g2_decap_4
XFILLER_40_1555 VPWR VGND sg13g2_decap_4
XFILLER_57_870 VPWR VGND sg13g2_decap_8
XFILLER_90_103 VPWR VGND sg13g2_decap_8
XFILLER_29_572 VPWR VGND sg13g2_decap_4
X_17560_ _17560_/Y _22879_/Q _17631_/B VPWR VGND sg13g2_nor2_1
X_14772_ _14885_/C _14772_/A _14792_/B VPWR VGND sg13g2_nor2_1
X_11984_ _14346_/B _22975_/Q _12471_/B _11984_/C VPWR VGND sg13g2_and3_1
XFILLER_40_1588 VPWR VGND sg13g2_decap_4
XFILLER_91_659 VPWR VGND sg13g2_decap_8
XFILLER_16_222 VPWR VGND sg13g2_decap_8
XFILLER_72_840 VPWR VGND sg13g2_fill_2
XFILLER_75_1607 VPWR VGND sg13g2_fill_1
X_16511_ _22615_/D _17920_/B2 _22615_/Q _16514_/B VPWR VGND sg13g2_mux2_1
X_13723_ _13723_/X _13723_/A _20258_/A VPWR VGND sg13g2_and2_1
X_17491_ _22862_/D _17902_/B2 _22862_/Q _17498_/B VPWR VGND sg13g2_mux2_1
XFILLER_56_1017 VPWR VGND sg13g2_decap_4
X_19230_ _23184_/D _24273_/A _23184_/Q _19232_/B VPWR VGND sg13g2_mux2_1
XFILLER_71_372 VPWR VGND sg13g2_decap_8
XFILLER_90_9 VPWR VGND sg13g2_fill_1
XFILLER_34_1304 VPWR VGND sg13g2_fill_1
X_19161_ _23134_/D _23134_/Q _14911_/X _19171_/S VPWR VGND sg13g2_mux2_1
X_12605_ _12606_/B _12603_/X _12604_/X _12707_/S VPWR VGND sg13g2_mux2_1
XFILLER_9_911 VPWR VGND sg13g2_decap_8
X_13585_ _13585_/Y _23630_/Q _13676_/B VPWR VGND sg13g2_nand2b_1
XFILLER_13_984 VPWR VGND sg13g2_fill_1
XFILLER_73_1386 VPWR VGND sg13g2_decap_8
XFILLER_8_410 VPWR VGND sg13g2_decap_8
X_18112_ _22950_/D _17977_/A _22950_/Q _18119_/S VPWR VGND sg13g2_mux2_1
XFILLER_40_770 VPWR VGND sg13g2_decap_8
XFILLER_73_1397 VPWR VGND sg13g2_fill_2
X_12536_ _12536_/Y _12532_/Y _12535_/X _12343_/Y VPWR VGND sg13g2_o21ai_1
XFILLER_12_483 VPWR VGND sg13g2_decap_8
X_19092_ _19092_/X _18918_/B _23114_/Q _19098_/S VPWR VGND sg13g2_mux2_1
XFILLER_16_1760 VPWR VGND sg13g2_decap_8
XFILLER_76_7 VPWR VGND sg13g2_decap_8
XFILLER_12_1602 VPWR VGND sg13g2_fill_2
XFILLER_16_1782 VPWR VGND sg13g2_decap_8
X_18043_ _18071_/A _18254_/A VPWR VGND sg13g2_inv_1
X_15255_ _16781_/C _15227_/A _15255_/B VPWR VGND sg13g2_nand2b_1
XFILLER_32_1072 VPWR VGND sg13g2_decap_8
X_12467_ _12899_/S _13186_/B _12551_/B _12551_/C _13968_/B VPWR VGND sg13g2_nor4_2
XFILLER_86_1714 VPWR VGND sg13g2_fill_2
X_14206_ _14207_/B _14206_/A _14206_/B VPWR VGND sg13g2_and2_1
X_11418_ _11418_/Y _11418_/A _11418_/B VPWR VGND sg13g2_nand2_2
X_15186_ _15187_/B _15186_/A _15257_/A VPWR VGND sg13g2_xnor2_1
X_12398_ _12412_/B _12445_/A _12395_/X _12397_/X VPWR VGND sg13g2_o21ai_1
XFILLER_4_671 VPWR VGND sg13g2_decap_8
X_14137_ _14439_/B _14144_/C _14143_/C _22995_/Q VPWR VGND sg13g2_or3_1
X_11349_ _11350_/B _24023_/Q _24055_/Q _24087_/Q _24119_/Q _11919_/S _11920_/C1 VPWR
+ VGND sg13g2_mux4_1
XFILLER_99_759 VPWR VGND sg13g2_decap_8
X_19994_ _19995_/A _20284_/A1 _23208_/Q _23216_/Q _20284_/A2 _20019_/S0 _20072_/S1
+ VPWR VGND sg13g2_mux4_1
XFILLER_113_547 VPWR VGND sg13g2_decap_8
XFILLER_3_181 VPWR VGND sg13g2_fill_1
XFILLER_84_1471 VPWR VGND sg13g2_decap_4
XFILLER_84_1482 VPWR VGND sg13g2_fill_2
X_18945_ _18947_/B _18942_/Y _18956_/B VPWR VGND sg13g2_nand2b_1
X_14068_ _14068_/X _24276_/A _14068_/B _17041_/B VPWR VGND sg13g2_or3_1
XFILLER_100_208 VPWR VGND sg13g2_decap_8
XFILLER_60_1909 VPWR VGND sg13g2_decap_8
XFILLER_80_1346 VPWR VGND sg13g2_decap_8
X_13019_ _13019_/Y _13019_/A _13019_/B VPWR VGND sg13g2_nand2_1
XFILLER_95_932 VPWR VGND sg13g2_decap_8
X_18876_ _18879_/B _18873_/Y _18924_/C VPWR VGND sg13g2_nand2b_1
XFILLER_62_1780 VPWR VGND sg13g2_fill_1
XFILLER_67_667 VPWR VGND sg13g2_decap_8
X_17827_ _17855_/B _17835_/A _17835_/B VPWR VGND sg13g2_and2_1
XFILLER_114_1881 VPWR VGND sg13g2_decap_8
XFILLER_94_475 VPWR VGND sg13g2_decap_4
XFILLER_94_486 VPWR VGND sg13g2_decap_8
XFILLER_54_328 VPWR VGND sg13g2_fill_1
XFILLER_110_1745 VPWR VGND sg13g2_decap_4
XFILLER_3_1869 VPWR VGND sg13g2_decap_8
X_17758_ _17758_/Y _17823_/A1 _17755_/Y _17757_/Y VPWR VGND sg13g2_o21ai_1
XFILLER_97_1876 VPWR VGND sg13g2_fill_2
X_16709_ _16717_/C _16709_/A _16709_/B _16709_/C VPWR VGND sg13g2_nor3_1
XFILLER_58_1838 VPWR VGND sg13g2_decap_8
XFILLER_93_1729 VPWR VGND sg13g2_fill_1
X_17689_ _17689_/Y _23170_/Q _17815_/A2 _17689_/B1 _17688_/Y VPWR VGND sg13g2_a22oi_1
XFILLER_78_1286 VPWR VGND sg13g2_fill_2
XFILLER_63_884 VPWR VGND sg13g2_decap_8
X_19428_ _19428_/Y _19428_/A _19443_/B VPWR VGND sg13g2_nand2_1
XFILLER_22_214 VPWR VGND sg13g2_decap_8
XFILLER_108_1630 VPWR VGND sg13g2_decap_8
XFILLER_17_1524 VPWR VGND sg13g2_decap_8
XFILLER_17_1535 VPWR VGND sg13g2_fill_1
XFILLER_50_567 VPWR VGND sg13g2_decap_4
X_19359_ _19760_/B _19639_/B _19358_/X _19712_/B VPWR VGND sg13g2_mux2_1
XFILLER_104_1516 VPWR VGND sg13g2_fill_2
XFILLER_104_1527 VPWR VGND sg13g2_fill_2
X_22370_ _24171_/D _22437_/A1 _22377_/B _22369_/Y VPWR VGND sg13g2_o21ai_1
XFILLER_30_291 VPWR VGND sg13g2_decap_8
X_21321_ _23681_/D _21321_/A1 _21330_/B _21320_/Y VPWR VGND sg13g2_o21ai_1
XFILLER_34_1893 VPWR VGND sg13g2_decap_8
XFILLER_30_1746 VPWR VGND sg13g2_decap_8
XFILLER_50_1172 VPWR VGND sg13g2_decap_8
XFILLER_69_1912 VPWR VGND sg13g2_fill_1
X_21252_ _21252_/Y _23648_/Q _21271_/B VPWR VGND sg13g2_nand2_1
X_24040_ _24040_/Q _24205_/CLK _24040_/D fanout2649/X VPWR VGND sg13g2_dfrbpq_1
XFILLER_11_1189 VPWR VGND sg13g2_fill_2
X_21183_ _23615_/D _21317_/A1 _21188_/B _21182_/Y VPWR VGND sg13g2_o21ai_1
XFILLER_89_236 VPWR VGND sg13g2_decap_4
XFILLER_104_547 VPWR VGND sg13g2_decap_8
X_20134_ _20134_/Y _20134_/A _20292_/B VPWR VGND sg13g2_nand2_1
XFILLER_115_1634 VPWR VGND sg13g2_decap_8
X_20065_ _20066_/B _20064_/B _20233_/A2 _20064_/Y VPWR VGND sg13g2_a21oi_1
XFILLER_8_1769 VPWR VGND sg13g2_decap_8
XFILLER_58_667 VPWR VGND sg13g2_decap_8
XFILLER_79_1006 VPWR VGND sg13g2_decap_8
XFILLER_18_509 VPWR VGND sg13g2_decap_8
XFILLER_6_1471 VPWR VGND sg13g2_decap_8
XFILLER_41_1853 VPWR VGND sg13g2_decap_4
XFILLER_46_829 VPWR VGND sg13g2_fill_2
XFILLER_22_1252 VPWR VGND sg13g2_decap_8
X_23824_ _23824_/Q clkload56/A _23824_/D fanout2675/X VPWR VGND sg13g2_dfrbpq_1
XFILLER_73_637 VPWR VGND sg13g2_decap_8
XFILLER_57_199 VPWR VGND sg13g2_decap_8
XFILLER_73_659 VPWR VGND sg13g2_fill_2
X_23755_ _23755_/Q clkload49/A _23755_/D fanout2675/X VPWR VGND sg13g2_dfrbpq_1
XFILLER_81_681 VPWR VGND sg13g2_fill_2
XFILLER_14_737 VPWR VGND sg13g2_decap_8
X_22706_ _22706_/Q clkload20/A _22706_/D fanout2863/X VPWR VGND sg13g2_dfrbpq_1
XFILLER_109_1438 VPWR VGND sg13g2_decap_8
X_23686_ _23686_/Q clkload42/A _23686_/D fanout2720/X VPWR VGND sg13g2_dfrbpq_1
XFILLER_109_1449 VPWR VGND sg13g2_fill_2
X_20898_ _20898_/Y _20898_/A _20903_/B VPWR VGND sg13g2_nand2_1
XFILLER_39_1782 VPWR VGND sg13g2_fill_2
XFILLER_35_1624 VPWR VGND sg13g2_fill_2
XFILLER_70_1504 VPWR VGND sg13g2_decap_8
XFILLER_110_63 VPWR VGND sg13g2_decap_8
X_22637_ _22637_/Q _22733_/CLK _22637_/D fanout2879/X VPWR VGND sg13g2_dfrbpq_1
XFILLER_10_932 VPWR VGND sg13g2_decap_8
XFILLER_70_56 VPWR VGND sg13g2_decap_8
X_13370_ _13370_/Y _20166_/A _13370_/B _13370_/C VPWR VGND sg13g2_nand3_1
X_22568_ _22568_/Q _23029_/CLK _22568_/D fanout2836/X VPWR VGND sg13g2_dfrbpq_1
XFILLER_6_925 VPWR VGND sg13g2_decap_8
X_12321_ _12321_/X _23550_/Q _23998_/Q _12321_/S VPWR VGND sg13g2_mux2_1
XFILLER_33_1370 VPWR VGND sg13g2_decap_8
X_21519_ _23775_/D _21946_/A1 _21530_/B _21518_/Y VPWR VGND sg13g2_o21ai_1
XFILLER_103_1059 VPWR VGND sg13g2_decap_8
X_22499_ _22499_/Q clkload9/A _22499_/D fanout2823/X VPWR VGND sg13g2_dfrbpq_1
XFILLER_68_1400 VPWR VGND sg13g2_fill_2
XFILLER_100_1925 VPWR VGND sg13g2_decap_8
X_15040_ _18712_/A _15040_/A _15040_/B VPWR VGND sg13g2_or2_1
X_24238_ _24238_/Q clkload15/A _24238_/D fanout2859/X VPWR VGND sg13g2_dfrbpq_1
X_12252_ _12252_/Y _23549_/Q _12922_/A2 _12251_/X _12285_/A VPWR VGND sg13g2_a22oi_1
XFILLER_102_0 VPWR VGND sg13g2_decap_8
X_11203_ _14591_/A _22977_/Q _22976_/Q VPWR VGND sg13g2_nor2b_1
X_12183_ _14871_/B _12439_/A _12531_/B _12435_/A VPWR VGND sg13g2_or3_1
X_24169_ _24169_/Q _24205_/CLK _24169_/D fanout2672/X VPWR VGND sg13g2_dfrbpq_1
XFILLER_64_1308 VPWR VGND sg13g2_fill_1
XFILLER_68_1499 VPWR VGND sg13g2_fill_2
XFILLER_46_1742 VPWR VGND sg13g2_decap_8
X_16991_ _22707_/D _17007_/A1 _16989_/Y _16990_/Y VPWR VGND sg13g2_o21ai_1
XFILLER_46_1764 VPWR VGND sg13g2_decap_4
X_18730_ _18730_/Y _23024_/Q _18730_/B VPWR VGND sg13g2_xnor2_1
XFILLER_7_1224 VPWR VGND sg13g2_decap_8
X_15942_ _15949_/A _22938_/Q _15924_/B _15941_/Y VPWR VGND sg13g2_a21oi_1
XFILLER_0_173 VPWR VGND sg13g2_decap_4
XFILLER_76_431 VPWR VGND sg13g2_decap_8
X_18661_ _18662_/B _18661_/A _18661_/B _18666_/B VPWR VGND sg13g2_nor3_1
X_15873_ _15874_/D _22612_/Q _15873_/B VPWR VGND sg13g2_nand2_1
XFILLER_37_829 VPWR VGND sg13g2_decap_4
XFILLER_40_1341 VPWR VGND sg13g2_fill_2
X_14824_ _14824_/X _14953_/A _23127_/Q _14823_/Y VPWR VGND sg13g2_a21o_1
XFILLER_20_1926 VPWR VGND sg13g2_decap_8
X_17612_ _17617_/A _23163_/Q _17621_/B VPWR VGND sg13g2_nand2_1
X_18592_ _19130_/S _18592_/A _24227_/Q _18766_/A VPWR VGND sg13g2_nor3_1
XFILLER_45_840 VPWR VGND sg13g2_fill_1
X_17543_ _17543_/Y _17537_/Y _17583_/A VPWR VGND sg13g2_nand2b_1
X_14755_ _14755_/Y _14596_/A _14402_/Y _24238_/Q VPWR VGND sg13g2_a21oi_1
X_11967_ _11967_/X _24026_/Q _24090_/Q _12004_/S VPWR VGND sg13g2_mux2_1
XFILLER_44_361 VPWR VGND sg13g2_fill_1
XFILLER_60_810 VPWR VGND sg13g2_fill_2
X_13706_ _13706_/X _13704_/X _13705_/X _13706_/S VPWR VGND sg13g2_mux2_1
X_17474_ _22854_/D _17878_/A _17489_/B _17473_/Y VPWR VGND sg13g2_o21ai_1
X_14686_ _14686_/X _14686_/A _14686_/B VPWR VGND sg13g2_and2_1
X_11898_ _11898_/Y _23610_/Q _12239_/S VPWR VGND sg13g2_nand2b_1
XFILLER_32_545 VPWR VGND sg13g2_decap_8
XFILLER_60_854 VPWR VGND sg13g2_decap_8
XFILLER_32_556 VPWR VGND sg13g2_fill_2
XFILLER_71_191 VPWR VGND sg13g2_decap_8
X_19213_ _23170_/D _24259_/A _23170_/Q _19221_/S VPWR VGND sg13g2_mux2_1
X_16425_ _16425_/Y _22580_/Q _16425_/B VPWR VGND sg13g2_nand2_1
XFILLER_18_1844 VPWR VGND sg13g2_decap_8
XFILLER_44_90 VPWR VGND sg13g2_decap_4
XFILLER_73_1150 VPWR VGND sg13g2_decap_4
X_13637_ _13648_/B _13637_/A1 _13634_/X _13636_/X VPWR VGND sg13g2_o21ai_1
XFILLER_18_1855 VPWR VGND sg13g2_fill_1
XFILLER_32_578 VPWR VGND sg13g2_decap_8
XFILLER_32_589 VPWR VGND sg13g2_fill_2
XFILLER_73_1172 VPWR VGND sg13g2_decap_4
X_19144_ _23120_/D _23120_/Q _18984_/A _19149_/S VPWR VGND sg13g2_mux2_1
X_16356_ _16357_/C _16356_/A VPWR VGND sg13g2_inv_1
X_13568_ _13568_/Y _13568_/A _13568_/B _13568_/C _13568_/D VPWR VGND sg13g2_nor4_2
X_15307_ _15325_/B _15307_/A _15307_/B VPWR VGND sg13g2_nand2_1
X_19075_ _19075_/X _17941_/B _23106_/Q _19085_/S VPWR VGND sg13g2_mux2_1
X_16287_ _16290_/A _18688_/A _16287_/B VPWR VGND sg13g2_and2_1
X_13499_ _13528_/C _20243_/A _13499_/B VPWR VGND sg13g2_xnor2_1
XFILLER_86_1500 VPWR VGND sg13g2_decap_4
X_18026_ _18351_/A _18358_/S _18022_/X _18025_/Y VPWR VGND sg13g2_a21oi_1
X_15238_ _15452_/A _15300_/A _15238_/B VPWR VGND sg13g2_nand2_1
XFILLER_103_1582 VPWR VGND sg13g2_decap_4
Xhold4708 _17255_/A _22758_/Q VPWR VGND sg13g2_dlygate4sd3_1
Xhold4719 _21690_/A _23860_/Q VPWR VGND sg13g2_dlygate4sd3_1
XFILLER_114_823 VPWR VGND sg13g2_decap_8
XFILLER_86_1566 VPWR VGND sg13g2_decap_8
XFILLER_113_322 VPWR VGND sg13g2_decap_8
X_19977_ _19991_/A _24256_/A _19977_/B VPWR VGND sg13g2_nand2_1
XFILLER_86_206 VPWR VGND sg13g2_decap_8
XFILLER_80_1121 VPWR VGND sg13g2_fill_2
XFILLER_86_239 VPWR VGND sg13g2_decap_4
X_18928_ _23050_/D _18922_/Y _18925_/Y _18926_/Y _18927_/Y VPWR VGND sg13g2_a22oi_1
XFILLER_60_1717 VPWR VGND sg13g2_decap_8
XFILLER_80_1165 VPWR VGND sg13g2_fill_1
XFILLER_68_954 VPWR VGND sg13g2_decap_4
XFILLER_99_1916 VPWR VGND sg13g2_decap_8
XFILLER_95_751 VPWR VGND sg13g2_decap_8
XFILLER_39_133 VPWR VGND sg13g2_fill_1
X_18859_ _18864_/A _23044_/Q _18865_/B _18865_/C VPWR VGND sg13g2_nand3_1
XFILLER_3_1611 VPWR VGND sg13g2_decap_8
XFILLER_27_306 VPWR VGND sg13g2_decap_8
XFILLER_95_795 VPWR VGND sg13g2_decap_8
XFILLER_3_1644 VPWR VGND sg13g2_decap_8
XFILLER_23_1572 VPWR VGND sg13g2_decap_8
X_21870_ _23931_/D _21936_/A1 _21869_/B _21869_/Y VPWR VGND sg13g2_o21ai_1
XFILLER_83_957 VPWR VGND sg13g2_decap_8
XFILLER_3_1655 VPWR VGND sg13g2_fill_2
XFILLER_82_445 VPWR VGND sg13g2_fill_2
XFILLER_54_136 VPWR VGND sg13g2_fill_1
XFILLER_93_1504 VPWR VGND sg13g2_fill_2
X_20821_ _20821_/Y _23459_/Q _20827_/B VPWR VGND sg13g2_nand2_1
XFILLER_39_1001 VPWR VGND sg13g2_decap_8
XFILLER_58_1635 VPWR VGND sg13g2_fill_1
XFILLER_97_1695 VPWR VGND sg13g2_decap_4
XFILLER_36_884 VPWR VGND sg13g2_decap_4
XFILLER_58_1657 VPWR VGND sg13g2_fill_1
XFILLER_78_1094 VPWR VGND sg13g2_decap_8
X_23540_ _23540_/Q _24210_/CLK _23540_/D fanout2636/X VPWR VGND sg13g2_dfrbpq_1
X_20752_ _23426_/D _21323_/A1 _20751_/B _20751_/Y VPWR VGND sg13g2_o21ai_1
XFILLER_35_394 VPWR VGND sg13g2_fill_1
XFILLER_50_320 VPWR VGND sg13g2_decap_8
XFILLER_23_545 VPWR VGND sg13g2_fill_2
XFILLER_39_1067 VPWR VGND sg13g2_decap_8
X_23471_ _23471_/Q clkload30/A _23471_/D fanout2658/X VPWR VGND sg13g2_dfrbpq_1
X_20683_ _23394_/D _22418_/A1 _20682_/B _20682_/Y VPWR VGND sg13g2_o21ai_1
XFILLER_17_1332 VPWR VGND sg13g2_decap_8
XFILLER_71_1835 VPWR VGND sg13g2_fill_1
XFILLER_56_1392 VPWR VGND sg13g2_decap_8
XFILLER_32_1808 VPWR VGND sg13g2_fill_2
X_22422_ _22422_/Y _22422_/A _22424_/B VPWR VGND sg13g2_nand2_1
XFILLER_108_1482 VPWR VGND sg13g2_decap_4
XFILLER_13_1218 VPWR VGND sg13g2_decap_8
XFILLER_108_105 VPWR VGND sg13g2_decap_8
X_22353_ _22353_/Y _22353_/A _22359_/B VPWR VGND sg13g2_nand2_1
Xoutput4550 instr_addr_o[24] _15053_/X VPWR VGND sg13g2_buf_1
Xoutput4561 instr_addr_o[5] _14860_/X VPWR VGND sg13g2_buf_1
X_21304_ _21304_/Y _23674_/Q _21308_/B VPWR VGND sg13g2_nand2_1
X_22284_ _24129_/D _22284_/A1 _22285_/B _22283_/Y VPWR VGND sg13g2_o21ai_1
X_24023_ _24023_/Q clkload48/A _24023_/D fanout2687/X VPWR VGND sg13g2_dfrbpq_1
X_21235_ _23640_/D _21301_/A1 _21234_/B _21234_/Y VPWR VGND sg13g2_o21ai_1
XFILLER_3_939 VPWR VGND sg13g2_decap_4
XFILLER_6_7 VPWR VGND sg13g2_decap_8
XFILLER_105_856 VPWR VGND sg13g2_fill_2
XFILLER_104_344 VPWR VGND sg13g2_decap_4
X_21166_ _21166_/Y _23608_/Q _21175_/B VPWR VGND sg13g2_nand2_1
XFILLER_49_35 VPWR VGND sg13g2_decap_8
XFILLER_8_1522 VPWR VGND sg13g2_decap_4
X_20117_ _20118_/B _20117_/A _20117_/B _20117_/C VPWR VGND sg13g2_nand3_1
XFILLER_59_932 VPWR VGND sg13g2_fill_1
X_21097_ _21097_/Y _21097_/A _21099_/B VPWR VGND sg13g2_nand2_1
XFILLER_43_1948 VPWR VGND sg13g2_decap_8
X_20048_ _20048_/Y _20100_/A1 _20045_/Y _20047_/Y _20130_/B _20100_/C1 VPWR VGND sg13g2_a221oi_1
XFILLER_105_63 VPWR VGND sg13g2_decap_8
XFILLER_85_250 VPWR VGND sg13g2_fill_2
XFILLER_18_306 VPWR VGND sg13g2_decap_8
XFILLER_46_626 VPWR VGND sg13g2_decap_8
XFILLER_115_1497 VPWR VGND sg13g2_decap_8
XFILLER_65_34 VPWR VGND sg13g2_decap_4
XFILLER_45_114 VPWR VGND sg13g2_fill_1
XFILLER_2_1121 VPWR VGND sg13g2_fill_2
X_12870_ _12870_/Y _13120_/A _12870_/B VPWR VGND sg13g2_nor2_1
XFILLER_27_840 VPWR VGND sg13g2_fill_2
XFILLER_45_147 VPWR VGND sg13g2_fill_1
XFILLER_73_456 VPWR VGND sg13g2_fill_1
X_11821_ _11865_/A _11821_/A _11981_/B VPWR VGND sg13g2_nand2_2
X_23807_ _23807_/Q clkload43/A _23807_/D fanout2774/X VPWR VGND sg13g2_dfrbpq_1
XFILLER_76_1735 VPWR VGND sg13g2_decap_4
X_21999_ _21999_/Y _21999_/A _22001_/B VPWR VGND sg13g2_nand2_1
XFILLER_14_501 VPWR VGND sg13g2_fill_1
XFILLER_96_1183 VPWR VGND sg13g2_fill_2
XFILLER_92_1014 VPWR VGND sg13g2_decap_8
XFILLER_14_523 VPWR VGND sg13g2_decap_8
XFILLER_109_1213 VPWR VGND sg13g2_fill_2
X_23738_ _23738_/Q clkload58/A _23738_/D fanout2761/X VPWR VGND sg13g2_dfrbpq_1
X_11752_ _11752_/Y _23672_/Q _11752_/B VPWR VGND sg13g2_nand2b_1
XFILLER_60_139 VPWR VGND sg13g2_decap_8
XFILLER_76_1768 VPWR VGND sg13g2_decap_8
X_14471_ _14475_/B _14471_/A _14471_/B VPWR VGND sg13g2_nor2_1
XFILLER_42_887 VPWR VGND sg13g2_decap_8
X_23669_ _23669_/Q clkload52/A _23669_/D fanout2756/X VPWR VGND sg13g2_dfrbpq_1
XFILLER_35_1421 VPWR VGND sg13g2_decap_8
X_11683_ _12499_/A _12203_/S _11688_/A VPWR VGND sg13g2_nand2b_1
XFILLER_41_375 VPWR VGND sg13g2_decap_8
X_16210_ _22513_/D _16209_/B _16208_/Y _16209_/Y VPWR VGND sg13g2_o21ai_1
X_13422_ _13422_/Y _24012_/Q _13589_/B VPWR VGND sg13g2_nand2b_1
X_17190_ _17191_/B _17195_/A _17218_/B _17190_/C VPWR VGND sg13g2_nor3_1
XFILLER_31_1307 VPWR VGND sg13g2_fill_2
X_13353_ _13353_/Y _20208_/B _13736_/A VPWR VGND sg13g2_xnor2_1
XFILLER_70_1389 VPWR VGND sg13g2_fill_2
XFILLER_104_1880 VPWR VGND sg13g2_decap_8
X_16072_ _16072_/Y _22489_/Q _16071_/B _16071_/Y VPWR VGND sg13g2_a21oi_1
XFILLER_108_650 VPWR VGND sg13g2_decap_8
X_13284_ _13356_/C _20197_/A _20197_/B VPWR VGND sg13g2_xnor2_1
XFILLER_114_119 VPWR VGND sg13g2_decap_8
X_19900_ _19903_/A _12278_/A _19835_/Y _19837_/Y _12535_/C VPWR VGND sg13g2_a22oi_1
X_15023_ _15023_/X _23145_/Q _16296_/A _15082_/A VPWR VGND sg13g2_mux2_1
XFILLER_30_70 VPWR VGND sg13g2_fill_1
X_12235_ _12236_/B _23773_/Q _23805_/Q _12235_/S VPWR VGND sg13g2_mux2_1
XFILLER_29_1203 VPWR VGND sg13g2_decap_8
XFILLER_107_182 VPWR VGND sg13g2_decap_8
XFILLER_30_92 VPWR VGND sg13g2_decap_8
X_19831_ _19831_/Y _20060_/A _19831_/B _19831_/C VPWR VGND sg13g2_nor3_1
Xfanout2920 fanout2920/X fanout2921/X VPWR VGND sg13g2_buf_1
X_12166_ _12166_/Y _24124_/Q _12166_/B VPWR VGND sg13g2_nand2b_1
Xfanout2931 fanout2931/X fanout2932/X VPWR VGND sg13g2_buf_1
XFILLER_68_217 VPWR VGND sg13g2_fill_2
X_19762_ _19762_/Y _19762_/A _20004_/B VPWR VGND sg13g2_nor2_1
XFILLER_81_1452 VPWR VGND sg13g2_decap_8
X_12097_ _12097_/X _12098_/A1 _12957_/B _19446_/A VPWR VGND sg13g2_a21o_1
X_16974_ _16980_/D _22704_/Q _22703_/Q _22702_/Q VPWR VGND sg13g2_and3_1
XFILLER_49_442 VPWR VGND sg13g2_fill_1
X_18713_ _18713_/Y _18713_/A _18713_/B VPWR VGND sg13g2_nand2_1
XFILLER_7_1054 VPWR VGND sg13g2_decap_8
XFILLER_7_1065 VPWR VGND sg13g2_fill_2
X_15925_ _15928_/B _22478_/Q _15970_/A2 _15992_/B1 _22809_/Q VPWR VGND sg13g2_a22oi_1
XFILLER_37_604 VPWR VGND sg13g2_decap_8
XFILLER_37_615 VPWR VGND sg13g2_fill_1
XFILLER_49_486 VPWR VGND sg13g2_decap_8
XFILLER_4_1942 VPWR VGND sg13g2_decap_8
XFILLER_24_1881 VPWR VGND sg13g2_decap_8
X_15856_ _15856_/Y _15856_/A _15856_/B _15856_/C _15856_/D VPWR VGND sg13g2_nand4_1
XFILLER_4_1953 VPWR VGND sg13g2_fill_2
X_18644_ _23006_/D _18642_/B _18641_/Y _18643_/Y VPWR VGND sg13g2_a21oi_1
XFILLER_92_765 VPWR VGND sg13g2_fill_2
XFILLER_18_851 VPWR VGND sg13g2_decap_4
XFILLER_64_456 VPWR VGND sg13g2_fill_1
X_14807_ _14808_/B _24236_/Q _24238_/Q _14806_/Y VPWR VGND sg13g2_o21ai_1
XFILLER_20_1767 VPWR VGND sg13g2_fill_1
X_18575_ _18575_/Y _22996_/Q _18854_/A VPWR VGND sg13g2_nor2_1
XFILLER_75_1201 VPWR VGND sg13g2_decap_8
X_15787_ _15788_/B _22737_/Q _15946_/A2 _15946_/B1 _22673_/Q VPWR VGND sg13g2_a22oi_1
XFILLER_18_884 VPWR VGND sg13g2_decap_8
X_12999_ _12999_/Y _12999_/A VPWR VGND sg13g2_inv_1
XFILLER_33_832 VPWR VGND sg13g2_decap_4
X_14738_ _14738_/X _14716_/Y _14714_/Y _14739_/S VPWR VGND sg13g2_mux2_1
X_17526_ _17527_/B _17540_/B _17524_/Y _17525_/Y VPWR VGND sg13g2_a21oi_1
XFILLER_107_1909 VPWR VGND sg13g2_decap_8
XFILLER_32_342 VPWR VGND sg13g2_decap_4
XFILLER_33_876 VPWR VGND sg13g2_decap_8
XFILLER_53_1510 VPWR VGND sg13g2_fill_2
X_17457_ _17457_/Y _17457_/A _17462_/B VPWR VGND sg13g2_nand2_1
XFILLER_75_1289 VPWR VGND sg13g2_fill_2
X_14669_ _14669_/X _14666_/Y _14668_/Y _14728_/S VPWR VGND sg13g2_mux2_1
XFILLER_18_1641 VPWR VGND sg13g2_fill_1
XFILLER_92_1581 VPWR VGND sg13g2_fill_2
XFILLER_92_1592 VPWR VGND sg13g2_decap_4
X_16408_ _22571_/D _18714_/A _16413_/S _16407_/Y VPWR VGND sg13g2_o21ai_1
Xrebuffer5505 rebuffer5505/X rebuffer5506/X VPWR VGND sg13g2_buf_1
XFILLER_105_1633 VPWR VGND sg13g2_decap_4
Xrebuffer5516 _19180_/A1 rebuffer5517/X VPWR VGND sg13g2_buf_1
X_17388_ _17388_/Y _16058_/A _17388_/B VPWR VGND sg13g2_nand2b_1
XFILLER_14_1527 VPWR VGND sg13g2_fill_1
Xrebuffer5527 rebuffer5527/X rebuffer5528/X VPWR VGND sg13g2_buf_1
Xplace3803 _13925_/A1 _12628_/A1 VPWR VGND sg13g2_buf_2
Xplace3814 _15335_/B _15785_/B VPWR VGND sg13g2_buf_1
Xrebuffer5538 rebuffer5538/X rebuffer5539/X VPWR VGND sg13g2_buf_1
Xrebuffer5549 rebuffer5549/X rebuffer5550/X VPWR VGND sg13g2_buf_1
Xplace3825 _14660_/A _12506_/B VPWR VGND sg13g2_buf_1
X_16339_ _16351_/B _22584_/Q _15391_/A _17439_/A _22840_/Q VPWR VGND sg13g2_a22oi_1
Xplace3836 _15996_/A _16352_/B VPWR VGND sg13g2_buf_1
X_19127_ _23104_/D _23104_/Q _18010_/B _19134_/S VPWR VGND sg13g2_mux2_1
Xplace3847 _13988_/B1 _12824_/B1 VPWR VGND sg13g2_buf_1
XFILLER_9_593 VPWR VGND sg13g2_fill_1
Xplace3858 _12266_/A _13280_/B VPWR VGND sg13g2_buf_1
XFILLER_88_1639 VPWR VGND sg13g2_fill_2
Xhold5206 _21313_/A _23678_/Q VPWR VGND sg13g2_dlygate4sd3_1
Xplace3869 _15695_/S _16029_/B VPWR VGND sg13g2_buf_1
XFILLER_65_0 VPWR VGND sg13g2_decap_8
X_19058_ _19058_/X _19120_/A1 _23098_/Q _19077_/S VPWR VGND sg13g2_mux2_1
XFILLER_103_1390 VPWR VGND sg13g2_decap_8
XFILLER_105_119 VPWR VGND sg13g2_decap_8
X_18009_ _18009_/Y _18009_/A _23040_/Q VPWR VGND sg13g2_nand2_1
XFILLER_114_620 VPWR VGND sg13g2_decap_8
XFILLER_47_1314 VPWR VGND sg13g2_fill_2
X_21020_ _23548_/D _22272_/A1 _21019_/B _21019_/Y VPWR VGND sg13g2_o21ai_1
XFILLER_0_909 VPWR VGND sg13g2_fill_1
XFILLER_101_303 VPWR VGND sg13g2_fill_2
XFILLER_114_697 VPWR VGND sg13g2_decap_8
XFILLER_87_537 VPWR VGND sg13g2_fill_2
XFILLER_9_1864 VPWR VGND sg13g2_decap_8
XFILLER_113_196 VPWR VGND sg13g2_decap_8
XFILLER_99_1702 VPWR VGND sg13g2_decap_8
XFILLER_5_1728 VPWR VGND sg13g2_decap_8
X_22971_ _22971_/Q _24212_/CLK _22971_/D fanout2921/X VPWR VGND sg13g2_dfrbpq_1
XFILLER_55_401 VPWR VGND sg13g2_decap_8
XFILLER_68_784 VPWR VGND sg13g2_fill_1
XFILLER_25_1689 VPWR VGND sg13g2_decap_4
XFILLER_55_412 VPWR VGND sg13g2_fill_1
XFILLER_82_231 VPWR VGND sg13g2_decap_8
XFILLER_56_968 VPWR VGND sg13g2_decap_8
XFILLER_83_765 VPWR VGND sg13g2_decap_8
XFILLER_3_1463 VPWR VGND sg13g2_decap_8
XFILLER_27_158 VPWR VGND sg13g2_decap_8
XFILLER_55_467 VPWR VGND sg13g2_decap_8
XFILLER_71_927 VPWR VGND sg13g2_decap_8
XFILLER_42_106 VPWR VGND sg13g2_decap_8
XFILLER_71_938 VPWR VGND sg13g2_fill_1
Xinput4404 _20310_/A2 data_rdata_i[4] VPWR VGND sg13g2_buf_1
Xinput4415 _19116_/A1 instr_rdata_i[0] VPWR VGND sg13g2_buf_1
X_20804_ _23451_/D _21307_/A1 _20809_/B _20803_/Y VPWR VGND sg13g2_o21ai_1
Xinput4426 _18024_/B instr_rdata_i[1] VPWR VGND sg13g2_buf_1
XFILLER_58_1454 VPWR VGND sg13g2_decap_8
XFILLER_70_437 VPWR VGND sg13g2_decap_8
Xinput4437 _19118_/A1 instr_rdata_i[2] VPWR VGND sg13g2_buf_1
XFILLER_23_320 VPWR VGND sg13g2_decap_8
X_21784_ _23892_/D _21983_/A1 _21779_/B _21783_/Y VPWR VGND sg13g2_o21ai_1
Xinput4448 _14217_/A irqs_i[0] VPWR VGND sg13g2_buf_1
Xinput4459 _14225_/A irqs_i[5] VPWR VGND sg13g2_buf_1
X_23523_ _23523_/Q clkload42/A _23523_/D fanout2701/X VPWR VGND sg13g2_dfrbpq_1
X_20735_ _23418_/D _21305_/A1 _20738_/B _20734_/Y VPWR VGND sg13g2_o21ai_1
XFILLER_106_1419 VPWR VGND sg13g2_fill_1
XFILLER_75_1790 VPWR VGND sg13g2_fill_1
X_23454_ _23454_/Q clkload55/A _23454_/D fanout2777/X VPWR VGND sg13g2_dfrbpq_1
XFILLER_50_194 VPWR VGND sg13g2_decap_4
XFILLER_104_1110 VPWR VGND sg13g2_decap_8
X_20666_ _20666_/Y _23387_/Q _20666_/B VPWR VGND sg13g2_nand2_1
XFILLER_71_1665 VPWR VGND sg13g2_fill_1
XFILLER_108_1290 VPWR VGND sg13g2_decap_8
XFILLER_7_519 VPWR VGND sg13g2_decap_8
X_22405_ _24188_/D _22405_/A1 _22408_/B _22404_/Y VPWR VGND sg13g2_o21ai_1
XFILLER_109_436 VPWR VGND sg13g2_decap_8
X_20597_ _23353_/D _21237_/A1 _20607_/B _20596_/Y VPWR VGND sg13g2_o21ai_1
X_23385_ _23385_/Q _24190_/CLK _23385_/D fanout2770/X VPWR VGND sg13g2_dfrbpq_1
XFILLER_10_1914 VPWR VGND sg13g2_decap_8
XFILLER_104_1187 VPWR VGND sg13g2_decap_8
X_22336_ _24155_/D _22403_/A1 _22335_/B _22335_/Y VPWR VGND sg13g2_o21ai_1
X_22267_ _22267_/Y _24122_/Q _22269_/B VPWR VGND sg13g2_nand2_1
XFILLER_69_1572 VPWR VGND sg13g2_fill_1
XFILLER_2_224 VPWR VGND sg13g2_decap_8
XFILLER_105_642 VPWR VGND sg13g2_decap_8
X_12020_ _12021_/B _23419_/Q _23483_/Q _12134_/S VPWR VGND sg13g2_mux2_1
XFILLER_2_246 VPWR VGND sg13g2_decap_8
X_24006_ _24006_/Q clkload37/A _24006_/D fanout2713/X VPWR VGND sg13g2_dfrbpq_1
XFILLER_65_1436 VPWR VGND sg13g2_fill_2
XFILLER_104_130 VPWR VGND sg13g2_fill_2
X_21218_ _21218_/Y _23634_/Q _21221_/B VPWR VGND sg13g2_nand2_1
X_22198_ _24088_/D _22264_/A1 _22249_/S _22197_/Y VPWR VGND sg13g2_o21ai_1
XFILLER_105_697 VPWR VGND sg13g2_decap_8
XFILLER_78_537 VPWR VGND sg13g2_fill_2
XFILLER_8_1330 VPWR VGND sg13g2_decap_8
X_21149_ _23600_/D _21616_/A1 _21154_/B _21148_/Y VPWR VGND sg13g2_o21ai_1
XFILLER_8_1352 VPWR VGND sg13g2_decap_8
XFILLER_63_1171 VPWR VGND sg13g2_decap_8
XFILLER_19_604 VPWR VGND sg13g2_fill_1
X_13971_ _20355_/B _13970_/A _13967_/Y _13970_/Y VPWR VGND sg13g2_o21ai_1
XFILLER_101_881 VPWR VGND sg13g2_decap_8
XFILLER_115_1283 VPWR VGND sg13g2_decap_8
X_15710_ _15711_/C _22895_/Q _15684_/B _15709_/Y VPWR VGND sg13g2_a21oi_1
X_12922_ _12923_/A _23557_/Q _12922_/A2 _12921_/X _12906_/A _12816_/A VPWR VGND sg13g2_a221oi_1
X_16690_ _16698_/C _16735_/A _16735_/B VPWR VGND sg13g2_nor2_1
XFILLER_59_1218 VPWR VGND sg13g2_fill_1
XFILLER_98_1278 VPWR VGND sg13g2_decap_8
X_15641_ _15642_/B _22601_/Q _15992_/A2 _15309_/Y _22496_/Q VPWR VGND sg13g2_a22oi_1
X_12853_ _13082_/B _12853_/A _12853_/B _14056_/A VPWR VGND sg13g2_nor3_1
XFILLER_74_787 VPWR VGND sg13g2_fill_1
X_11804_ _11805_/B _23705_/Q _23833_/Q _11810_/S VPWR VGND sg13g2_mux2_1
X_18360_ _18360_/Y _18332_/B _18358_/X _18359_/Y VPWR VGND sg13g2_a21oi_1
X_15572_ _15572_/Y _22874_/Q VPWR VGND sg13g2_inv_1
X_12784_ _12784_/Y _24132_/Q _12789_/S VPWR VGND sg13g2_nand2b_1
XFILLER_42_640 VPWR VGND sg13g2_decap_8
X_17311_ _17311_/Y _17311_/A _17324_/B VPWR VGND sg13g2_nand2_1
XFILLER_70_960 VPWR VGND sg13g2_decap_4
XFILLER_14_353 VPWR VGND sg13g2_decap_4
X_14523_ _14523_/Y _22877_/Q _14742_/B VPWR VGND sg13g2_nand2_1
XFILLER_15_887 VPWR VGND sg13g2_fill_2
X_18291_ _18291_/Y _18332_/B _18290_/Y _18385_/B VPWR VGND sg13g2_o21ai_1
XFILLER_41_150 VPWR VGND sg13g2_decap_8
XFILLER_93_1890 VPWR VGND sg13g2_fill_1
XFILLER_42_684 VPWR VGND sg13g2_decap_8
X_17242_ _17242_/Y _17242_/A _17262_/B VPWR VGND sg13g2_nand2_1
XFILLER_14_397 VPWR VGND sg13g2_decap_8
XFILLER_30_846 VPWR VGND sg13g2_decap_8
X_14454_ _14455_/B _14151_/B _14772_/A _14782_/B VPWR VGND sg13g2_a21oi_1
XFILLER_15_1836 VPWR VGND sg13g2_decap_8
X_13405_ _13533_/B _14441_/A _13970_/A _13904_/B VPWR VGND sg13g2_nand3_1
X_17173_ _17174_/B _17195_/A _17173_/B _17173_/C VPWR VGND sg13g2_nor3_1
X_14385_ _14385_/Y _15300_/A _15264_/B _15478_/B VPWR VGND sg13g2_a21oi_1
X_11597_ _11597_/Y _14117_/B _11596_/Y _14086_/A1 VPWR VGND sg13g2_a21oi_1
XFILLER_89_1948 VPWR VGND sg13g2_decap_8
X_16124_ _16124_/Y _17884_/A _16156_/B VPWR VGND sg13g2_nor2_1
XFILLER_115_439 VPWR VGND sg13g2_decap_8
X_16055_ _16055_/Y _22485_/Q _16207_/B _16054_/Y VPWR VGND sg13g2_a21oi_1
X_13267_ _13278_/B _13267_/A _13267_/B _13267_/C VPWR VGND sg13g2_nand3_1
X_15006_ _15008_/B _22471_/Q _15006_/B VPWR VGND sg13g2_nand2_1
XFILLER_48_1645 VPWR VGND sg13g2_decap_8
X_12218_ _12219_/D _12218_/A _12218_/B _12218_/C _12218_/D VPWR VGND sg13g2_nor4_1
XFILLER_68_1082 VPWR VGND sg13g2_decap_8
X_13198_ _13199_/B _23721_/Q _23849_/Q _13796_/B VPWR VGND sg13g2_mux2_1
XFILLER_48_1689 VPWR VGND sg13g2_decap_4
X_19814_ _19814_/Y _19811_/Y _19813_/Y _19884_/A VPWR VGND sg13g2_o21ai_1
Xfanout2750 fanout2750/X fanout2753/X VPWR VGND sg13g2_buf_1
X_12149_ _12149_/Y _12129_/Y _12124_/Y _12136_/Y _12139_/Y _12148_/Y VPWR VGND sg13g2_a221oi_1
Xfanout2761 fanout2761/X fanout2762/X VPWR VGND sg13g2_buf_1
XFILLER_42_1200 VPWR VGND sg13g2_decap_8
Xfanout2772 fanout2772/X fanout2780/X VPWR VGND sg13g2_buf_1
XFILLER_81_1260 VPWR VGND sg13g2_decap_8
Xfanout2783 fanout2783/X fanout2786/X VPWR VGND sg13g2_buf_1
XFILLER_111_667 VPWR VGND sg13g2_decap_8
XFILLER_110_133 VPWR VGND sg13g2_decap_8
XFILLER_46_1380 VPWR VGND sg13g2_fill_1
XFILLER_113_1913 VPWR VGND sg13g2_decap_8
Xfanout2794 fanout2794/X fanout2796/X VPWR VGND sg13g2_buf_1
X_19745_ _19746_/B _19886_/A1 _20284_/A0 _19509_/Y _23216_/Q VPWR VGND sg13g2_a22oi_1
XFILLER_22_1807 VPWR VGND sg13g2_decap_8
X_16957_ _16957_/Y _17147_/A _17026_/B VPWR VGND sg13g2_nand2_1
XFILLER_38_935 VPWR VGND sg13g2_decap_8
XFILLER_49_272 VPWR VGND sg13g2_fill_2
X_19676_ _19676_/Y _15333_/B _19676_/B VPWR VGND sg13g2_nand2b_1
X_16888_ _16889_/B _16893_/A _16888_/B VPWR VGND sg13g2_nor2_1
XFILLER_77_1307 VPWR VGND sg13g2_fill_2
XFILLER_64_231 VPWR VGND sg13g2_decap_8
XFILLER_25_607 VPWR VGND sg13g2_fill_2
X_18627_ _18627_/X _23003_/Q _18629_/C _16243_/A VPWR VGND sg13g2_a21o_1
XFILLER_111_1670 VPWR VGND sg13g2_fill_1
XFILLER_53_938 VPWR VGND sg13g2_decap_8
X_15839_ _15839_/Y _15839_/A _15963_/B VPWR VGND sg13g2_nor2_1
XFILLER_64_264 VPWR VGND sg13g2_decap_8
XFILLER_80_724 VPWR VGND sg13g2_decap_8
XFILLER_24_106 VPWR VGND sg13g2_fill_1
XFILLER_65_798 VPWR VGND sg13g2_decap_8
XFILLER_94_1654 VPWR VGND sg13g2_fill_1
X_18558_ _22994_/D _18557_/B _18556_/Y _18557_/Y VPWR VGND sg13g2_o21ai_1
XFILLER_75_1031 VPWR VGND sg13g2_decap_8
XFILLER_90_1507 VPWR VGND sg13g2_decap_8
XFILLER_36_1004 VPWR VGND sg13g2_fill_2
XFILLER_61_960 VPWR VGND sg13g2_decap_8
XFILLER_33_662 VPWR VGND sg13g2_decap_8
XFILLER_20_301 VPWR VGND sg13g2_decap_8
X_18489_ _22989_/D _18557_/B _18487_/Y _18488_/Y VPWR VGND sg13g2_o21ai_1
XFILLER_75_1086 VPWR VGND sg13g2_fill_2
XFILLER_33_695 VPWR VGND sg13g2_fill_2
XFILLER_36_1059 VPWR VGND sg13g2_fill_2
Xplace4301 _12813_/S _12997_/S VPWR VGND sg13g2_buf_1
X_20520_ _20520_/Y _20520_/A _20578_/B VPWR VGND sg13g2_nand2_1
Xplace4312 _13232_/S _12453_/S VPWR VGND sg13g2_buf_1
Xplace4323 _11416_/B _11752_/B VPWR VGND sg13g2_buf_1
Xrebuffer5302 _12515_/B _12535_/B VPWR VGND sg13g2_buf_1
XFILLER_32_194 VPWR VGND sg13g2_fill_1
Xrebuffer5313 _12744_/A1 _12575_/Y VPWR VGND sg13g2_buf_1
Xplace4334 _14629_/A _22977_/Q VPWR VGND sg13g2_buf_1
Xplace3600 _17580_/B _17583_/A VPWR VGND sg13g2_buf_1
Xplace4345 _11311_/B _22968_/Q VPWR VGND sg13g2_buf_2
XFILLER_18_1493 VPWR VGND sg13g2_decap_4
Xrebuffer5324 _13304_/B1 _13083_/Y VPWR VGND sg13g2_buf_1
X_20451_ _20451_/Y _23288_/Q _20451_/B VPWR VGND sg13g2_nand2_1
Xplace3611 _14990_/B _15042_/B VPWR VGND sg13g2_buf_2
Xrebuffer5335 _13540_/C1 _13433_/A VPWR VGND sg13g2_buf_1
Xplace3622 _19874_/A _19634_/B VPWR VGND sg13g2_buf_1
XFILLER_20_378 VPWR VGND sg13g2_decap_8
Xrebuffer5346 _17709_/B2 _22980_/Q VPWR VGND sg13g2_buf_1
Xrebuffer4601 _12766_/A _12831_/B VPWR VGND sg13g2_buf_1
Xrebuffer4612 _11998_/A _12098_/A1 VPWR VGND sg13g2_buf_1
Xplace3633 _15067_/B _15113_/B VPWR VGND sg13g2_buf_1
Xrebuffer5357 place2967/A _14553_/Y VPWR VGND sg13g2_buf_1
Xrebuffer5368 _19955_/A _12521_/Y VPWR VGND sg13g2_buf_1
Xplace3644 _14720_/B _14718_/B VPWR VGND sg13g2_buf_1
Xrebuffer4623 _12949_/A _12900_/Y VPWR VGND sg13g2_buf_2
Xrebuffer4634 _14229_/A _14213_/Y VPWR VGND sg13g2_buf_2
Xplace3655 _17670_/A2 _17540_/B VPWR VGND sg13g2_buf_1
XFILLER_105_1496 VPWR VGND sg13g2_decap_4
Xrebuffer5379 _12531_/D _12529_/Y VPWR VGND sg13g2_buf_1
XFILLER_101_1338 VPWR VGND sg13g2_decap_4
X_20382_ _20382_/Y _23256_/Q _20388_/B VPWR VGND sg13g2_nand2_1
X_23170_ _23170_/Q clkload15/A _23170_/D fanout2857/X VPWR VGND sg13g2_dfrbpq_1
Xhold5003 _21666_/A _23846_/Q VPWR VGND sg13g2_dlygate4sd3_1
Xplace3666 _16060_/B _16031_/Y VPWR VGND sg13g2_buf_1
Xplace3677 _15107_/A2 _14801_/B VPWR VGND sg13g2_buf_1
Xhold5014 _21461_/A _23748_/Q VPWR VGND sg13g2_dlygate4sd3_1
Xplace2943 _22390_/A1 _21295_/A1 VPWR VGND sg13g2_buf_1
Xplace3688 _20229_/B _13433_/B VPWR VGND sg13g2_buf_2
Xhold5025 _21154_/A _23604_/Q VPWR VGND sg13g2_dlygate4sd3_1
Xplace2954 _18960_/B1 _18580_/X VPWR VGND sg13g2_buf_1
Xplace3699 _12843_/A _12697_/A VPWR VGND sg13g2_buf_1
Xhold5036 _20144_/A _23238_/Q VPWR VGND sg13g2_dlygate4sd3_1
Xplace2965 _18667_/A _14553_/Y VPWR VGND sg13g2_buf_1
XFILLER_66_1701 VPWR VGND sg13g2_decap_4
Xhold5047 _22361_/A _24167_/Q VPWR VGND sg13g2_dlygate4sd3_1
Xplace2976 _18443_/A _18140_/B VPWR VGND sg13g2_buf_1
Xhold5058 _20572_/A _23342_/Q VPWR VGND sg13g2_dlygate4sd3_1
XFILLER_47_1100 VPWR VGND sg13g2_decap_8
Xhold5069 _21361_/A _23701_/Q VPWR VGND sg13g2_dlygate4sd3_1
Xplace2987 _18857_/S _18889_/B VPWR VGND sg13g2_buf_1
Xplace2998 _17122_/B _17090_/A VPWR VGND sg13g2_buf_1
X_22052_ _22095_/B _22318_/B _22252_/B VPWR VGND sg13g2_nand2_1
XFILLER_115_995 VPWR VGND sg13g2_decap_8
XFILLER_88_824 VPWR VGND sg13g2_fill_2
XFILLER_87_301 VPWR VGND sg13g2_fill_2
X_21003_ _21003_/Y _21003_/A _21013_/B VPWR VGND sg13g2_nand2_1
XFILLER_88_846 VPWR VGND sg13g2_decap_8
XFILLER_114_494 VPWR VGND sg13g2_decap_8
XFILLER_102_645 VPWR VGND sg13g2_decap_8
XFILLER_47_1199 VPWR VGND sg13g2_decap_8
XFILLER_102_656 VPWR VGND sg13g2_fill_2
XFILLER_9_1672 VPWR VGND sg13g2_fill_2
XFILLER_87_378 VPWR VGND sg13g2_decap_8
XFILLER_5_1525 VPWR VGND sg13g2_fill_1
XFILLER_112_1412 VPWR VGND sg13g2_decap_8
XFILLER_56_710 VPWR VGND sg13g2_decap_8
XFILLER_112_1423 VPWR VGND sg13g2_fill_1
XFILLER_60_1355 VPWR VGND sg13g2_decap_8
XFILLER_5_1547 VPWR VGND sg13g2_decap_8
XFILLER_28_434 VPWR VGND sg13g2_fill_2
X_22954_ _22954_/Q clkload13/A _22954_/D fanout2915/X VPWR VGND sg13g2_dfrbpq_1
XFILLER_46_36 VPWR VGND sg13g2_fill_2
XFILLER_29_968 VPWR VGND sg13g2_decap_8
XFILLER_44_905 VPWR VGND sg13g2_decap_8
XFILLER_44_916 VPWR VGND sg13g2_decap_8
X_21905_ _23948_/D _21971_/A1 _21910_/B _21904_/Y VPWR VGND sg13g2_o21ai_1
XFILLER_56_787 VPWR VGND sg13g2_decap_8
XFILLER_28_489 VPWR VGND sg13g2_fill_1
X_22885_ _22885_/Q _22917_/CLK _22885_/D fanout2893/X VPWR VGND sg13g2_dfrbpq_1
XFILLER_44_949 VPWR VGND sg13g2_decap_8
XFILLER_15_128 VPWR VGND sg13g2_fill_2
XFILLER_71_746 VPWR VGND sg13g2_fill_1
XFILLER_102_42 VPWR VGND sg13g2_decap_8
X_21836_ _23915_/D _20217_/Y _21850_/B _21835_/Y VPWR VGND sg13g2_o21ai_1
XFILLER_19_1202 VPWR VGND sg13g2_decap_8
XFILLER_71_768 VPWR VGND sg13g2_decap_8
XFILLER_24_662 VPWR VGND sg13g2_decap_4
XFILLER_12_813 VPWR VGND sg13g2_fill_2
XFILLER_12_824 VPWR VGND sg13g2_fill_2
X_21767_ _21767_/Y _21767_/A _21771_/B VPWR VGND sg13g2_nand2_1
XFILLER_19_1257 VPWR VGND sg13g2_fill_1
XFILLER_51_470 VPWR VGND sg13g2_decap_4
X_11520_ _11520_/X _23893_/Q _13797_/S VPWR VGND sg13g2_and2_1
X_23506_ _23506_/Q _24210_/CLK _23506_/D fanout2635/X VPWR VGND sg13g2_dfrbpq_1
XFILLER_11_334 VPWR VGND sg13g2_decap_8
XFILLER_36_1560 VPWR VGND sg13g2_decap_8
X_21698_ _23861_/D _21924_/A1 _21713_/B _21697_/Y VPWR VGND sg13g2_o21ai_1
XFILLER_106_1249 VPWR VGND sg13g2_decap_8
XFILLER_36_1571 VPWR VGND sg13g2_fill_1
XFILLER_7_305 VPWR VGND sg13g2_decap_8
X_23437_ _23437_/Q clkload30/A _23437_/D fanout2658/X VPWR VGND sg13g2_dfrbpq_1
X_11451_ _11451_/Y _23990_/Q _13889_/B VPWR VGND sg13g2_nor2_1
X_20649_ _20710_/B _22252_/A _20649_/B VPWR VGND sg13g2_nand2_1
XFILLER_32_1468 VPWR VGND sg13g2_decap_4
XFILLER_109_255 VPWR VGND sg13g2_decap_8
X_14170_ _14770_/B _14263_/A _16856_/B VPWR VGND sg13g2_nor2_1
XFILLER_109_266 VPWR VGND sg13g2_fill_2
X_11382_ _11382_/X _24086_/Q _24118_/Q _11737_/S VPWR VGND sg13g2_mux2_1
X_23368_ _23368_/Q clkload32/A _23368_/D fanout2647/X VPWR VGND sg13g2_dfrbpq_1
XFILLER_10_1722 VPWR VGND sg13g2_decap_8
XFILLER_49_1910 VPWR VGND sg13g2_fill_2
X_13121_ _13121_/X _13120_/A _13118_/Y _13120_/Y VPWR VGND sg13g2_a21o_1
X_23299_ _23299_/Q clkload34/A _23299_/D fanout2694/X VPWR VGND sg13g2_dfrbpq_1
XFILLER_11_72 VPWR VGND sg13g2_fill_2
XFILLER_101_1894 VPWR VGND sg13g2_decap_8
XFILLER_10_1788 VPWR VGND sg13g2_decap_8
X_13052_ _13052_/X _23431_/Q _23463_/Q _23495_/Q _23527_/Q _13243_/S0 _13042_/A VPWR
+ VGND sg13g2_mux4_1
XFILLER_105_472 VPWR VGND sg13g2_fill_2
XFILLER_45_1829 VPWR VGND sg13g2_fill_2
X_12003_ _14049_/A _12003_/A _12003_/B _12003_/C _12003_/D VPWR VGND sg13g2_nor4_2
Xhold4880 _21228_/A _23637_/Q VPWR VGND sg13g2_dlygate4sd3_1
X_17860_ _22918_/D _17860_/A VPWR VGND sg13g2_inv_1
Xhold4891 _21729_/A _23871_/Q VPWR VGND sg13g2_dlygate4sd3_1
XFILLER_79_868 VPWR VGND sg13g2_decap_8
XFILLER_61_1119 VPWR VGND sg13g2_decap_8
XFILLER_78_356 VPWR VGND sg13g2_decap_8
X_16811_ _22673_/D _16154_/X _16830_/A _16810_/Y VPWR VGND sg13g2_o21ai_1
XFILLER_94_827 VPWR VGND sg13g2_decap_8
XFILLER_93_315 VPWR VGND sg13g2_decap_8
X_17791_ _17792_/B _22574_/Q _17799_/C VPWR VGND sg13g2_nand2_1
XFILLER_66_529 VPWR VGND sg13g2_decap_8
X_19530_ _19530_/Y _23221_/Q _20190_/S VPWR VGND sg13g2_nand2_1
X_16742_ _22663_/D _17869_/A _16760_/A _16741_/Y VPWR VGND sg13g2_a21oi_1
X_13954_ _13954_/X _24052_/Q _24084_/Q _24116_/Q _24148_/Q _13959_/S0 _13955_/S VPWR
+ VGND sg13g2_mux4_1
XFILLER_1_1923 VPWR VGND sg13g2_decap_8
XFILLER_21_1851 VPWR VGND sg13g2_fill_2
X_12905_ _12906_/B _23717_/Q _23749_/Q _23781_/Q _23813_/Q _12909_/B _13006_/S1 VPWR
+ VGND sg13g2_mux4_1
X_19461_ _19462_/B _15218_/A _19460_/B _19460_/Y VPWR VGND sg13g2_o21ai_1
X_16673_ _16673_/Y _16673_/A _16673_/B VPWR VGND sg13g2_nor2_1
XFILLER_19_478 VPWR VGND sg13g2_decap_8
XFILLER_34_415 VPWR VGND sg13g2_decap_8
X_13885_ _13886_/C _13946_/A _13885_/B VPWR VGND sg13g2_nor2_1
X_18412_ _18803_/B _19121_/A1 _23067_/Q _18462_/S VPWR VGND sg13g2_mux2_1
XFILLER_46_297 VPWR VGND sg13g2_fill_2
XFILLER_61_223 VPWR VGND sg13g2_decap_8
X_15624_ _15624_/Y _22697_/Q _15708_/A2 _15731_/B1 _22633_/Q VPWR VGND sg13g2_a22oi_1
X_12836_ _12836_/X _12951_/A _12836_/B VPWR VGND sg13g2_and2_1
XFILLER_76_1340 VPWR VGND sg13g2_decap_4
X_19392_ _19392_/X _19584_/S _19561_/B VPWR VGND sg13g2_and2_1
XFILLER_50_908 VPWR VGND sg13g2_fill_1
XFILLER_62_779 VPWR VGND sg13g2_decap_8
XFILLER_15_662 VPWR VGND sg13g2_decap_8
XFILLER_76_1373 VPWR VGND sg13g2_fill_1
X_18343_ _18343_/Y _18363_/B _18341_/Y _18342_/Y VPWR VGND sg13g2_o21ai_1
X_15555_ _15560_/A _22760_/Q _15991_/A2 _15964_/A2 _22597_/Q VPWR VGND sg13g2_a22oi_1
X_12767_ _14054_/B _12761_/A _12764_/X _12766_/Y VPWR VGND sg13g2_a21oi_1
XFILLER_42_470 VPWR VGND sg13g2_fill_1
X_14506_ _14507_/D _22590_/Q _23001_/Q VPWR VGND sg13g2_xor2_1
X_11718_ _11725_/A _13210_/A _11718_/B VPWR VGND sg13g2_nor2_1
X_18274_ _18275_/C _18288_/A _18274_/B _18274_/C VPWR VGND sg13g2_nor3_1
X_15486_ _15489_/B _15486_/A _15486_/B _15486_/C VPWR VGND sg13g2_nand3_1
X_12698_ _14935_/A _12699_/B _12699_/C _12853_/B VPWR VGND sg13g2_o21ai_1
X_17225_ _17226_/C _22747_/Q _17227_/C VPWR VGND sg13g2_nor2_1
XFILLER_35_1070 VPWR VGND sg13g2_decap_4
X_14437_ _14437_/Y _14852_/A _18432_/A VPWR VGND sg13g2_nor2_1
XFILLER_89_1712 VPWR VGND sg13g2_decap_8
XFILLER_89_1723 VPWR VGND sg13g2_fill_2
XFILLER_102_1636 VPWR VGND sg13g2_decap_8
XFILLER_89_1745 VPWR VGND sg13g2_decap_4
X_17156_ _17157_/B _17156_/A _17195_/A _17173_/B _17156_/D VPWR VGND sg13g2_nor4_1
X_14368_ _16782_/C _15262_/A _15255_/B VPWR VGND sg13g2_nand2_1
XFILLER_115_203 VPWR VGND sg13g2_decap_8
X_16107_ _16109_/A _16107_/A _16107_/B VPWR VGND sg13g2_and2_1
X_17087_ _17087_/Y _17087_/A _17092_/B VPWR VGND sg13g2_nor2_1
X_16038_ _16207_/B _16161_/A _17399_/A VPWR VGND sg13g2_nand2_1
XFILLER_69_312 VPWR VGND sg13g2_fill_2
XFILLER_112_954 VPWR VGND sg13g2_decap_8
XFILLER_97_665 VPWR VGND sg13g2_decap_8
XFILLER_85_805 VPWR VGND sg13g2_decap_8
XFILLER_6_1812 VPWR VGND sg13g2_decap_8
XFILLER_96_153 VPWR VGND sg13g2_decap_4
XFILLER_28_0 VPWR VGND sg13g2_decap_8
XFILLER_57_507 VPWR VGND sg13g2_decap_4
XFILLER_26_1762 VPWR VGND sg13g2_decap_8
XFILLER_112_998 VPWR VGND sg13g2_fill_2
X_17989_ _17989_/Y _17987_/Y _17988_/Y _18030_/A VPWR VGND sg13g2_a21oi_1
XFILLER_96_186 VPWR VGND sg13g2_fill_1
XFILLER_84_326 VPWR VGND sg13g2_decap_4
XFILLER_26_1795 VPWR VGND sg13g2_decap_8
X_19728_ _19728_/Y _19728_/A _19728_/B _19978_/B VPWR VGND sg13g2_nand3_1
XFILLER_6_1889 VPWR VGND sg13g2_decap_8
XFILLER_42_1085 VPWR VGND sg13g2_decap_4
XFILLER_113_1787 VPWR VGND sg13g2_decap_8
X_19659_ _19659_/Y _20033_/A1 _19643_/Y _19658_/Y VPWR VGND sg13g2_o21ai_1
XFILLER_20_1350 VPWR VGND sg13g2_decap_8
XFILLER_65_584 VPWR VGND sg13g2_decap_8
XFILLER_77_1137 VPWR VGND sg13g2_decap_8
X_22670_ _22670_/Q _22733_/CLK _22670_/D fanout2879/X VPWR VGND sg13g2_dfrbpq_1
XFILLER_53_779 VPWR VGND sg13g2_fill_2
XFILLER_80_576 VPWR VGND sg13g2_decap_4
XFILLER_12_109 VPWR VGND sg13g2_decap_8
X_21621_ _21621_/Y _23828_/Q _21621_/B VPWR VGND sg13g2_nand2_1
XFILLER_80_587 VPWR VGND sg13g2_fill_1
XFILLER_21_610 VPWR VGND sg13g2_decap_8
XFILLER_40_429 VPWR VGND sg13g2_decap_8
XFILLER_55_1457 VPWR VGND sg13g2_decap_8
XFILLER_61_790 VPWR VGND sg13g2_fill_2
XFILLER_33_1700 VPWR VGND sg13g2_decap_8
X_21552_ _21552_/Y _21552_/A _21555_/B VPWR VGND sg13g2_nand2_1
XFILLER_33_1711 VPWR VGND sg13g2_fill_2
XFILLER_37_1880 VPWR VGND sg13g2_fill_2
XFILLER_21_665 VPWR VGND sg13g2_decap_8
Xplace4120 _13960_/S1 _22987_/Q VPWR VGND sg13g2_buf_2
Xplace4131 _12502_/S _13019_/A VPWR VGND sg13g2_buf_1
X_20503_ _23311_/D _23311_/Q _22177_/A1 _20511_/S VPWR VGND sg13g2_mux2_1
Xplace4142 _12487_/S _11792_/S VPWR VGND sg13g2_buf_1
X_24271_ _24271_/X _24271_/A VPWR VGND sg13g2_buf_1
Xplace4153 _11493_/A _13398_/S VPWR VGND sg13g2_buf_4
Xplace4164 _12006_/S1 _12004_/S VPWR VGND sg13g2_buf_1
XFILLER_14_1132 VPWR VGND sg13g2_decap_8
X_21483_ _21483_/Y _23760_/Q _21483_/B VPWR VGND sg13g2_nand2_1
Xplace3430 _17098_/A _17858_/A VPWR VGND sg13g2_buf_1
XFILLER_20_186 VPWR VGND sg13g2_fill_1
Xplace4175 _13259_/B _13253_/S VPWR VGND sg13g2_buf_1
XFILLER_101_1113 VPWR VGND sg13g2_decap_4
X_23222_ _23222_/Q clkload54/A _23222_/D fanout2751/X VPWR VGND sg13g2_dfrbpq_1
XFILLER_20_197 VPWR VGND sg13g2_decap_8
Xplace4186 _12877_/B _22985_/Q VPWR VGND sg13g2_buf_2
Xplace3441 _17631_/B _17661_/B VPWR VGND sg13g2_buf_1
X_20434_ _23283_/D _22449_/A1 _23283_/Q _20434_/S VPWR VGND sg13g2_mux2_1
Xplace3452 _17141_/B _17182_/B VPWR VGND sg13g2_buf_1
Xplace4197 _13555_/S0 _13962_/S0 VPWR VGND sg13g2_buf_1
Xplace3463 _16846_/A _16851_/S VPWR VGND sg13g2_buf_1
XFILLER_68_1807 VPWR VGND sg13g2_decap_8
XFILLER_88_1244 VPWR VGND sg13g2_fill_1
XFILLER_14_1187 VPWR VGND sg13g2_decap_4
Xplace3474 _16656_/A _16637_/S VPWR VGND sg13g2_buf_1
XFILLER_10_1029 VPWR VGND sg13g2_decap_8
Xplace3485 _16203_/B _16119_/B VPWR VGND sg13g2_buf_1
XFILLER_107_748 VPWR VGND sg13g2_decap_4
X_23153_ _23153_/Q clkload14/A _23153_/D fanout2842/X VPWR VGND sg13g2_dfrbpq_1
Xplace3496 _16972_/B _16946_/S VPWR VGND sg13g2_buf_1
XFILLER_106_7 VPWR VGND sg13g2_decap_8
X_20365_ _20365_/Y _23252_/Q _20365_/B VPWR VGND sg13g2_nand2_1
X_22104_ _24043_/D _20217_/Y _22117_/B _22103_/Y VPWR VGND sg13g2_o21ai_1
X_23084_ _23084_/Q _23215_/CLK _23084_/D fanout2911/X VPWR VGND sg13g2_dfrbpq_1
X_20296_ _20296_/Y _20296_/A _20296_/B _20296_/C _20296_/D VPWR VGND sg13g2_nand4_1
XFILLER_66_1553 VPWR VGND sg13g2_fill_2
XFILLER_88_632 VPWR VGND sg13g2_fill_1
XFILLER_66_1575 VPWR VGND sg13g2_decap_8
X_22035_ _24011_/D _20217_/Y _22045_/B _22034_/Y VPWR VGND sg13g2_o21ai_1
XFILLER_103_965 VPWR VGND sg13g2_decap_8
XFILLER_87_142 VPWR VGND sg13g2_decap_8
XFILLER_48_507 VPWR VGND sg13g2_decap_8
XFILLER_57_35 VPWR VGND sg13g2_decap_8
XFILLER_75_315 VPWR VGND sg13g2_fill_2
XFILLER_75_337 VPWR VGND sg13g2_decap_8
XFILLER_87_197 VPWR VGND sg13g2_fill_2
XFILLER_5_1355 VPWR VGND sg13g2_decap_8
XFILLER_28_220 VPWR VGND sg13g2_decap_8
XFILLER_75_348 VPWR VGND sg13g2_fill_1
XFILLER_56_540 VPWR VGND sg13g2_fill_1
X_23986_ _23986_/Q clkload29/A _23986_/D fanout2669/X VPWR VGND sg13g2_dfrbpq_1
XFILLER_112_1253 VPWR VGND sg13g2_decap_8
XFILLER_91_819 VPWR VGND sg13g2_decap_8
XFILLER_5_1366 VPWR VGND sg13g2_fill_2
XFILLER_84_860 VPWR VGND sg13g2_fill_1
XFILLER_56_551 VPWR VGND sg13g2_decap_8
XFILLER_113_63 VPWR VGND sg13g2_decap_8
X_22937_ _22937_/Q _22941_/CLK _22937_/D fanout2801/X VPWR VGND sg13g2_dfrbpq_1
XFILLER_28_264 VPWR VGND sg13g2_decap_8
XFILLER_44_724 VPWR VGND sg13g2_fill_1
XFILLER_83_370 VPWR VGND sg13g2_decap_4
XFILLER_17_949 VPWR VGND sg13g2_decap_8
XFILLER_83_392 VPWR VGND sg13g2_decap_8
XFILLER_28_297 VPWR VGND sg13g2_decap_8
XFILLER_3_1090 VPWR VGND sg13g2_decap_4
X_13670_ _13670_/Y _13671_/B _23664_/Q _13669_/Y VPWR VGND sg13g2_o21ai_1
X_22868_ _22868_/Q _22869_/CLK _22868_/D fanout2799/X VPWR VGND sg13g2_dfrbpq_1
XFILLER_32_908 VPWR VGND sg13g2_decap_8
XFILLER_44_768 VPWR VGND sg13g2_decap_4
XFILLER_32_919 VPWR VGND sg13g2_fill_1
XFILLER_43_256 VPWR VGND sg13g2_decap_4
X_12621_ _12632_/D _20013_/A _12762_/B VPWR VGND sg13g2_nor2_1
XFILLER_38_1644 VPWR VGND sg13g2_decap_4
X_21819_ _23906_/D _22286_/A1 _21833_/B _21818_/Y VPWR VGND sg13g2_o21ai_1
XFILLER_19_1043 VPWR VGND sg13g2_decap_8
X_22799_ _22799_/Q _22893_/CLK _22799_/D fanout2817/X VPWR VGND sg13g2_dfrbpq_1
XFILLER_38_1677 VPWR VGND sg13g2_decap_4
XFILLER_40_941 VPWR VGND sg13g2_decap_4
XFILLER_11_120 VPWR VGND sg13g2_decap_4
XFILLER_38_1699 VPWR VGND sg13g2_decap_8
XFILLER_51_1811 VPWR VGND sg13g2_fill_1
XFILLER_106_1046 VPWR VGND sg13g2_decap_8
XFILLER_7_102 VPWR VGND sg13g2_fill_1
XFILLER_11_164 VPWR VGND sg13g2_decap_8
XFILLER_12_698 VPWR VGND sg13g2_decap_8
X_12483_ _12484_/B _23744_/Q _23872_/Q _12487_/S VPWR VGND sg13g2_mux2_1
XFILLER_12_1806 VPWR VGND sg13g2_decap_8
X_17010_ _17010_/Y _22711_/Q _17010_/B VPWR VGND sg13g2_xnor2_1
XFILLER_103_1945 VPWR VGND sg13g2_decap_8
X_14222_ _14222_/X _14222_/A _22827_/Q VPWR VGND sg13g2_and2_1
X_11434_ _11434_/Y _11408_/Y _11403_/Y _11415_/Y _11420_/Y _11433_/Y VPWR VGND sg13g2_a221oi_1
X_14153_ _14290_/C _14132_/Y _14151_/X _14152_/X VPWR VGND sg13g2_o21ai_1
X_11365_ _11365_/Y _11337_/X _12048_/A _11342_/X _11365_/B2 _11364_/Y VPWR VGND sg13g2_a221oi_1
XFILLER_98_42 VPWR VGND sg13g2_decap_8
X_13104_ _13104_/Y _23175_/Q _13924_/A2 _13103_/X _13924_/B1 VPWR VGND sg13g2_a22oi_1
XFILLER_101_1691 VPWR VGND sg13g2_decap_4
XFILLER_113_729 VPWR VGND sg13g2_decap_8
X_18961_ _23053_/D _18955_/Y _18958_/Y _18959_/Y _18960_/Y VPWR VGND sg13g2_a22oi_1
XFILLER_3_352 VPWR VGND sg13g2_fill_1
X_14084_ _14084_/Y _19331_/A _19320_/B VPWR VGND sg13g2_nor2_1
X_11296_ _11296_/Y _11517_/S _11293_/X _11295_/X VPWR VGND sg13g2_a21oi_1
XFILLER_112_217 VPWR VGND sg13g2_decap_8
XFILLER_49_1773 VPWR VGND sg13g2_fill_2
X_17912_ _17913_/B _22935_/Q _17930_/B VPWR VGND sg13g2_nand2_1
XFILLER_45_1626 VPWR VGND sg13g2_decap_8
X_13035_ _13035_/Y _11774_/A _13035_/A2 _13649_/A _13034_/Y _12584_/Y VPWR VGND sg13g2_a221oi_1
X_18892_ _18892_/Y _18926_/A _23079_/Q _18959_/C VPWR VGND sg13g2_nand3_1
XFILLER_39_507 VPWR VGND sg13g2_decap_8
X_17843_ _22912_/D _16050_/A _17849_/C _17842_/Y VPWR VGND sg13g2_o21ai_1
XFILLER_21_7 VPWR VGND sg13g2_fill_2
XFILLER_66_304 VPWR VGND sg13g2_decap_8
XFILLER_26_1069 VPWR VGND sg13g2_decap_8
XFILLER_43_1350 VPWR VGND sg13g2_decap_4
Xclkbuf_leaf_7_clk_i clkload26/A clkbuf_leaf_9_clk_i/A VPWR VGND sg13g2_buf_16
X_17774_ _17774_/Y _17774_/A _17789_/B VPWR VGND sg13g2_nor2_1
X_14986_ _14986_/Y _22469_/Q _14874_/B _15066_/B1 _22928_/Q _14985_/X VPWR VGND sg13g2_a221oi_1
XFILLER_47_551 VPWR VGND sg13g2_decap_8
XFILLER_78_1413 VPWR VGND sg13g2_decap_8
X_19513_ _19513_/Y _19508_/Y _19512_/Y _19514_/A VPWR VGND sg13g2_o21ai_1
X_16725_ _22660_/D _17098_/A _16728_/A _16724_/Y VPWR VGND sg13g2_a21oi_1
XFILLER_93_189 VPWR VGND sg13g2_fill_2
XFILLER_81_329 VPWR VGND sg13g2_decap_8
XFILLER_1_1720 VPWR VGND sg13g2_decap_8
X_13937_ _13937_/Y _13940_/A _13937_/B VPWR VGND sg13g2_nand2_1
XFILLER_47_584 VPWR VGND sg13g2_decap_8
XFILLER_74_392 VPWR VGND sg13g2_decap_4
X_19444_ _19587_/B _13734_/A _19443_/B _19443_/Y VPWR VGND sg13g2_o21ai_1
X_16656_ _16656_/Y _16656_/A _16656_/B VPWR VGND sg13g2_nor2_1
X_13868_ _13876_/B _13866_/Y _13867_/Y _20304_/C VPWR VGND sg13g2_o21ai_1
XFILLER_95_1771 VPWR VGND sg13g2_decap_8
XFILLER_1_1797 VPWR VGND sg13g2_decap_8
XFILLER_50_716 VPWR VGND sg13g2_fill_2
X_12819_ _12819_/X _23716_/Q _23748_/Q _23844_/Q _23876_/Q _12819_/S0 _12906_/A VPWR
+ VGND sg13g2_mux4_1
XFILLER_50_727 VPWR VGND sg13g2_decap_8
X_15607_ _15607_/X _20009_/B _16352_/B _20015_/A VPWR VGND sg13g2_and3_1
X_19375_ _19375_/Y _19589_/A _19375_/B VPWR VGND sg13g2_nor2_1
XFILLER_62_598 VPWR VGND sg13g2_decap_4
X_16587_ _16587_/Y _16591_/A _16587_/B VPWR VGND sg13g2_nor2_1
X_13799_ _13799_/Y _13794_/S _13798_/Y _13141_/B VPWR VGND sg13g2_a21oi_1
XFILLER_108_1834 VPWR VGND sg13g2_decap_8
XFILLER_91_1646 VPWR VGND sg13g2_decap_8
XFILLER_72_1023 VPWR VGND sg13g2_decap_8
XFILLER_15_492 VPWR VGND sg13g2_decap_8
XFILLER_72_1034 VPWR VGND sg13g2_fill_2
X_18326_ _18326_/Y _18325_/Y _18427_/A VPWR VGND sg13g2_nand2b_1
X_15538_ _15562_/A _15538_/A _16016_/A VPWR VGND sg13g2_nand2_1
XFILLER_33_1029 VPWR VGND sg13g2_decap_8
XFILLER_8_40 VPWR VGND sg13g2_decap_4
X_18257_ _18259_/C _18072_/Y _18181_/Y _18254_/A VPWR VGND sg13g2_a21oi_1
XFILLER_8_62 VPWR VGND sg13g2_fill_2
XFILLER_89_1520 VPWR VGND sg13g2_decap_4
X_17208_ _17208_/Y _22744_/Q _17208_/B VPWR VGND sg13g2_xnor2_1
X_18188_ _18395_/A _18562_/C _18322_/C VPWR VGND sg13g2_nor2_1
X_17139_ _17140_/B _17144_/B _17173_/B _17149_/B VPWR VGND sg13g2_nor3_1
XFILLER_85_1417 VPWR VGND sg13g2_fill_2
XFILLER_89_1597 VPWR VGND sg13g2_decap_8
X_20150_ _20150_/Y _20307_/A _20150_/B VPWR VGND sg13g2_nor2_1
XFILLER_104_729 VPWR VGND sg13g2_decap_8
XFILLER_28_1824 VPWR VGND sg13g2_decap_8
XFILLER_28_1835 VPWR VGND sg13g2_fill_2
X_20081_ _20082_/B _20080_/A _19873_/Y _20080_/Y VPWR VGND sg13g2_o21ai_1
XFILLER_44_1103 VPWR VGND sg13g2_fill_1
XFILLER_115_1805 VPWR VGND sg13g2_decap_8
XFILLER_112_740 VPWR VGND sg13g2_decap_8
XFILLER_98_963 VPWR VGND sg13g2_fill_2
XFILLER_44_1114 VPWR VGND sg13g2_decap_4
XFILLER_48_1294 VPWR VGND sg13g2_decap_8
XFILLER_44_1136 VPWR VGND sg13g2_fill_2
XFILLER_69_164 VPWR VGND sg13g2_fill_2
XFILLER_111_261 VPWR VGND sg13g2_fill_2
XFILLER_44_1158 VPWR VGND sg13g2_decap_8
XFILLER_69_175 VPWR VGND sg13g2_fill_1
XFILLER_85_646 VPWR VGND sg13g2_decap_8
XFILLER_6_1642 VPWR VGND sg13g2_fill_2
X_23840_ _23840_/Q clkload43/A _23840_/D fanout2732/X VPWR VGND sg13g2_dfrbpq_1
XFILLER_96_1502 VPWR VGND sg13g2_fill_2
XFILLER_6_1686 VPWR VGND sg13g2_decap_8
XFILLER_26_702 VPWR VGND sg13g2_fill_2
X_23771_ _23771_/Q _23966_/CLK _23771_/D fanout2763/X VPWR VGND sg13g2_dfrbpq_1
XFILLER_2_1539 VPWR VGND sg13g2_decap_8
X_20983_ _20983_/Y _20983_/A _20983_/B VPWR VGND sg13g2_nand2_1
X_22722_ _22722_/Q clkload25/A _22722_/D fanout2885/X VPWR VGND sg13g2_dfrbpq_1
XFILLER_14_908 VPWR VGND sg13g2_decap_8
XFILLER_25_234 VPWR VGND sg13g2_decap_8
XFILLER_96_1579 VPWR VGND sg13g2_fill_2
XFILLER_20_1180 VPWR VGND sg13g2_decap_8
XFILLER_39_1931 VPWR VGND sg13g2_decap_8
XFILLER_74_1833 VPWR VGND sg13g2_decap_8
X_22653_ _22653_/Q clkload24/A _22653_/D fanout2889/X VPWR VGND sg13g2_dfrbpq_1
XFILLER_22_930 VPWR VGND sg13g2_decap_8
XFILLER_41_749 VPWR VGND sg13g2_decap_8
XFILLER_74_1855 VPWR VGND sg13g2_decap_8
X_21604_ _23817_/D _21965_/A0 _23817_/Q _21620_/S VPWR VGND sg13g2_mux2_1
XFILLER_22_941 VPWR VGND sg13g2_fill_1
XFILLER_35_1839 VPWR VGND sg13g2_decap_8
XFILLER_70_1719 VPWR VGND sg13g2_decap_8
X_22584_ _22584_/Q clkload25/A _22584_/D fanout2885/X VPWR VGND sg13g2_dfrbpq_1
XFILLER_107_1344 VPWR VGND sg13g2_decap_8
XFILLER_16_1249 VPWR VGND sg13g2_decap_8
XFILLER_55_1298 VPWR VGND sg13g2_fill_1
X_21535_ _23783_/D _21962_/A1 _21555_/B _21534_/Y VPWR VGND sg13g2_o21ai_1
XFILLER_72_1590 VPWR VGND sg13g2_fill_2
X_24254_ _24254_/X _24254_/A VPWR VGND sg13g2_buf_1
X_21466_ _23750_/D _21960_/A1 _21473_/B _21465_/Y VPWR VGND sg13g2_o21ai_1
XFILLER_33_1596 VPWR VGND sg13g2_decap_8
Xplace3260 _22315_/A0 _21848_/A VPWR VGND sg13g2_buf_1
X_23205_ _23205_/Q _23215_/CLK _23205_/D fanout2926/X VPWR VGND sg13g2_dfrbpq_1
XFILLER_4_116 VPWR VGND sg13g2_decap_8
Xplace3271 _22305_/A1 _20702_/A1 VPWR VGND sg13g2_buf_1
XFILLER_107_534 VPWR VGND sg13g2_decap_8
Xplace3282 _21333_/A1 _22296_/A1 VPWR VGND sg13g2_buf_1
X_20417_ _23272_/D _20172_/Y _23272_/Q _20435_/B VPWR VGND sg13g2_mux2_1
Xplace3293 _21950_/A1 _22284_/A1 VPWR VGND sg13g2_buf_1
X_24185_ _24185_/Q _24190_/CLK _24185_/D fanout2769/X VPWR VGND sg13g2_dfrbpq_1
X_21397_ _23717_/D _21958_/A1 _21398_/B _21396_/Y VPWR VGND sg13g2_o21ai_1
X_23136_ _23136_/Q clkload5/A _23136_/D fanout2833/X VPWR VGND sg13g2_dfrbpq_1
X_20348_ _23251_/D _22449_/A1 _23251_/Q _20365_/B VPWR VGND sg13g2_mux2_1
XFILLER_108_63 VPWR VGND sg13g2_decap_8
X_23067_ _23067_/Q clkload14/A _23067_/D fanout2903/X VPWR VGND sg13g2_dfrbpq_1
XFILLER_46_1946 VPWR VGND sg13g2_decap_8
X_20279_ _20280_/B _20344_/A1 _20278_/X _20107_/Y VPWR VGND sg13g2_o21ai_1
XFILLER_7_1406 VPWR VGND sg13g2_fill_1
XFILLER_7_1428 VPWR VGND sg13g2_decap_8
X_22018_ _24002_/D _22286_/A1 _22017_/B _22017_/Y VPWR VGND sg13g2_o21ai_1
XFILLER_68_89 VPWR VGND sg13g2_decap_4
XFILLER_103_784 VPWR VGND sg13g2_decap_8
XFILLER_76_624 VPWR VGND sg13g2_decap_8
XFILLER_40_1501 VPWR VGND sg13g2_decap_8
XFILLER_76_646 VPWR VGND sg13g2_fill_2
XFILLER_84_11 VPWR VGND sg13g2_fill_2
X_14840_ _14840_/Y _14836_/Y _14838_/Y _14839_/Y VPWR VGND sg13g2_o21ai_1
XFILLER_75_134 VPWR VGND sg13g2_decap_8
XFILLER_79_1700 VPWR VGND sg13g2_decap_4
XFILLER_84_33 VPWR VGND sg13g2_decap_8
XFILLER_17_702 VPWR VGND sg13g2_decap_8
XFILLER_63_307 VPWR VGND sg13g2_decap_8
XFILLER_1_1016 VPWR VGND sg13g2_fill_1
X_11983_ _11983_/Y _11983_/A _11983_/B _11983_/C _11983_/D VPWR VGND sg13g2_nor4_1
X_23969_ _23969_/Q clkload39/A _23969_/D fanout2738/X VPWR VGND sg13g2_dfrbpq_1
XFILLER_5_1196 VPWR VGND sg13g2_decap_8
XFILLER_90_137 VPWR VGND sg13g2_decap_8
XFILLER_56_392 VPWR VGND sg13g2_fill_2
X_13722_ _13722_/Y _20271_/B _13734_/A VPWR VGND sg13g2_nand2b_1
XFILLER_44_554 VPWR VGND sg13g2_decap_4
X_17490_ _22861_/D _16154_/X _17489_/B _17489_/Y VPWR VGND sg13g2_o21ai_1
XFILLER_16_267 VPWR VGND sg13g2_decap_4
X_16441_ _16456_/B _16441_/A _16441_/B VPWR VGND sg13g2_nand2_1
X_13653_ _13743_/A _20271_/B _13734_/A VPWR VGND sg13g2_xnor2_1
XFILLER_92_1944 VPWR VGND sg13g2_decap_8
XFILLER_38_1441 VPWR VGND sg13g2_decap_8
XFILLER_44_598 VPWR VGND sg13g2_decap_8
XFILLER_13_930 VPWR VGND sg13g2_decap_8
X_12604_ _12604_/X _23425_/Q _23457_/Q _23489_/Q _23521_/Q _13006_/S0 _13006_/S1 VPWR
+ VGND sg13g2_mux4_1
X_19160_ _23133_/D _23133_/Q _14902_/Y _19171_/S VPWR VGND sg13g2_mux2_1
XFILLER_31_259 VPWR VGND sg13g2_decap_8
XFILLER_38_1485 VPWR VGND sg13g2_decap_4
X_13584_ _13584_/Y _13586_/A1 _23662_/Q _13583_/Y VPWR VGND sg13g2_o21ai_1
XFILLER_12_440 VPWR VGND sg13g2_fill_1
X_15323_ _15323_/X _16681_/B _15625_/B VPWR VGND sg13g2_and2_1
X_12535_ _12535_/X _12535_/A _12535_/B _12535_/C _12535_/D VPWR VGND sg13g2_and4_1
XFILLER_13_996 VPWR VGND sg13g2_decap_8
XFILLER_34_1349 VPWR VGND sg13g2_decap_4
X_19091_ _23081_/D _23081_/Q _19089_/X _19099_/S VPWR VGND sg13g2_mux2_1
XFILLER_9_967 VPWR VGND sg13g2_decap_8
XFILLER_8_433 VPWR VGND sg13g2_fill_2
X_15254_ _16781_/B _15294_/C VPWR VGND sg13g2_inv_1
XFILLER_12_1625 VPWR VGND sg13g2_decap_8
X_12466_ _12466_/X _22971_/Q _22995_/Q _12550_/A VPWR VGND sg13g2_mux2_1
XFILLER_86_1704 VPWR VGND sg13g2_fill_1
X_14205_ _14206_/B _14205_/A _22830_/Q VPWR VGND sg13g2_nand2_1
X_11417_ _11417_/Y _11416_/B _23638_/Q _11416_/Y VPWR VGND sg13g2_o21ai_1
X_12397_ _12397_/X _13611_/A _12397_/B VPWR VGND sg13g2_or2_1
XFILLER_67_1114 VPWR VGND sg13g2_decap_8
XFILLER_4_650 VPWR VGND sg13g2_decap_8
X_14136_ _14138_/B _14438_/C _14341_/B VPWR VGND sg13g2_or2_1
X_11348_ _11348_/Y _11920_/C1 _11345_/X _13911_/A2 _23543_/Q VPWR VGND sg13g2_a22oi_1
XFILLER_99_738 VPWR VGND sg13g2_fill_2
X_19993_ _19993_/Y _20071_/A _19993_/B VPWR VGND sg13g2_nand2_1
XFILLER_113_526 VPWR VGND sg13g2_decap_8
X_18944_ _18944_/Y _18955_/A _18944_/B VPWR VGND sg13g2_nand2_1
X_11279_ _11280_/B _13193_/S0 _11275_/X _13798_/A2 _23895_/Q VPWR VGND sg13g2_a22oi_1
XFILLER_95_911 VPWR VGND sg13g2_decap_8
X_13018_ _13019_/B _24039_/Q _24071_/Q _24103_/Q _24135_/Q _13707_/S0 _13016_/S VPWR
+ VGND sg13g2_mux4_1
XFILLER_80_1358 VPWR VGND sg13g2_fill_1
X_18875_ _18875_/Y _18899_/A _18875_/B VPWR VGND sg13g2_nand2_1
XFILLER_67_646 VPWR VGND sg13g2_decap_4
X_17826_ _22909_/D _17825_/B _17824_/Y _17825_/Y VPWR VGND sg13g2_a21oi_1
XFILLER_39_348 VPWR VGND sg13g2_decap_4
XFILLER_114_1860 VPWR VGND sg13g2_decap_8
XFILLER_48_860 VPWR VGND sg13g2_fill_1
XFILLER_97_1822 VPWR VGND sg13g2_decap_4
XFILLER_3_1848 VPWR VGND sg13g2_decap_8
X_17757_ _17757_/Y _23178_/Q _17590_/B _17815_/B1 _14146_/B VPWR VGND sg13g2_a22oi_1
X_14969_ _14969_/Y _15068_/A _14969_/B _14969_/C _14969_/D VPWR VGND sg13g2_nand4_1
XFILLER_81_137 VPWR VGND sg13g2_decap_8
XFILLER_78_1243 VPWR VGND sg13g2_decap_8
XFILLER_47_392 VPWR VGND sg13g2_fill_1
X_16708_ _22656_/D _17316_/A1 _16707_/A _16707_/Y VPWR VGND sg13g2_a21oi_1
XFILLER_78_1254 VPWR VGND sg13g2_fill_1
XFILLER_35_554 VPWR VGND sg13g2_decap_8
X_17688_ _17688_/Y _11571_/B _17687_/A _17687_/Y VPWR VGND sg13g2_o21ai_1
XFILLER_90_660 VPWR VGND sg13g2_decap_8
XFILLER_23_716 VPWR VGND sg13g2_decap_8
X_19427_ _19757_/B _19638_/S _19652_/B VPWR VGND sg13g2_nand2_1
XFILLER_91_1410 VPWR VGND sg13g2_fill_2
XFILLER_23_749 VPWR VGND sg13g2_decap_8
XFILLER_50_546 VPWR VGND sg13g2_decap_8
XFILLER_95_0 VPWR VGND sg13g2_decap_8
XFILLER_17_1514 VPWR VGND sg13g2_decap_4
X_19358_ _19358_/X _19355_/Y _19357_/Y _19573_/S VPWR VGND sg13g2_mux2_1
XFILLER_108_1653 VPWR VGND sg13g2_decap_8
XFILLER_108_1664 VPWR VGND sg13g2_fill_2
XFILLER_108_1675 VPWR VGND sg13g2_fill_2
X_18309_ _18334_/B _18162_/A _18178_/Y _18385_/A VPWR VGND sg13g2_a21o_1
XFILLER_52_1449 VPWR VGND sg13g2_decap_8
XFILLER_108_309 VPWR VGND sg13g2_fill_1
X_21320_ _21320_/Y _23681_/Q _21330_/B VPWR VGND sg13g2_nand2_1
XFILLER_11_1146 VPWR VGND sg13g2_fill_2
X_21251_ _23647_/D _21317_/A1 _21271_/B _21250_/Y VPWR VGND sg13g2_o21ai_1
XFILLER_69_1946 VPWR VGND sg13g2_decap_8
XFILLER_89_1394 VPWR VGND sg13g2_fill_2
X_20202_ _20202_/X _20202_/A _20202_/B VPWR VGND sg13g2_and2_1
XFILLER_85_1247 VPWR VGND sg13g2_fill_2
XFILLER_89_215 VPWR VGND sg13g2_fill_1
X_21182_ _21182_/Y _21182_/A _21188_/B VPWR VGND sg13g2_nand2_1
XFILLER_104_526 VPWR VGND sg13g2_decap_8
XFILLER_89_226 VPWR VGND sg13g2_decap_4
X_20133_ _20133_/Y _14107_/A _20132_/A _20132_/Y VPWR VGND sg13g2_o21ai_1
XFILLER_67_1681 VPWR VGND sg13g2_fill_1
XFILLER_48_1080 VPWR VGND sg13g2_fill_2
XFILLER_115_1613 VPWR VGND sg13g2_decap_8
XFILLER_98_782 VPWR VGND sg13g2_decap_8
XFILLER_8_1748 VPWR VGND sg13g2_decap_8
XFILLER_58_613 VPWR VGND sg13g2_decap_8
X_20064_ _20064_/Y _20229_/A _20064_/B VPWR VGND sg13g2_nor2_1
XFILLER_86_933 VPWR VGND sg13g2_decap_8
XFILLER_85_410 VPWR VGND sg13g2_fill_1
XFILLER_57_101 VPWR VGND sg13g2_decap_4
XFILLER_97_281 VPWR VGND sg13g2_decap_8
XFILLER_57_134 VPWR VGND sg13g2_fill_1
XFILLER_115_1679 VPWR VGND sg13g2_decap_8
XFILLER_80_1881 VPWR VGND sg13g2_decap_8
XFILLER_6_1450 VPWR VGND sg13g2_decap_8
XFILLER_85_454 VPWR VGND sg13g2_decap_8
XFILLER_86_988 VPWR VGND sg13g2_decap_8
XFILLER_22_1231 VPWR VGND sg13g2_fill_2
XFILLER_57_156 VPWR VGND sg13g2_decap_8
XFILLER_86_999 VPWR VGND sg13g2_fill_2
XFILLER_61_1291 VPWR VGND sg13g2_fill_2
X_23823_ _23823_/Q clkload30/A _23823_/D fanout2656/X VPWR VGND sg13g2_dfrbpq_1
XFILLER_100_787 VPWR VGND sg13g2_fill_1
XFILLER_45_318 VPWR VGND sg13g2_fill_1
XFILLER_39_882 VPWR VGND sg13g2_decap_8
XFILLER_41_1887 VPWR VGND sg13g2_decap_4
X_23754_ _23754_/Q clkload45/A _23754_/D fanout2730/X VPWR VGND sg13g2_dfrbpq_1
XFILLER_92_1207 VPWR VGND sg13g2_decap_8
XFILLER_81_660 VPWR VGND sg13g2_decap_8
XFILLER_57_1338 VPWR VGND sg13g2_decap_8
X_22705_ _22705_/Q clkload20/A _22705_/D fanout2868/X VPWR VGND sg13g2_dfrbpq_1
XFILLER_81_693 VPWR VGND sg13g2_decap_8
XFILLER_80_170 VPWR VGND sg13g2_fill_1
X_23685_ _23685_/Q clkload42/A _23685_/D fanout2718/X VPWR VGND sg13g2_dfrbpq_1
X_20897_ _23494_/D _21331_/A1 _20896_/B _20896_/Y VPWR VGND sg13g2_o21ai_1
XFILLER_13_226 VPWR VGND sg13g2_fill_1
XFILLER_41_535 VPWR VGND sg13g2_decap_4
XFILLER_13_237 VPWR VGND sg13g2_fill_1
XFILLER_74_1652 VPWR VGND sg13g2_decap_8
XFILLER_110_42 VPWR VGND sg13g2_decap_8
X_22636_ _22636_/Q _22733_/CLK _22636_/D fanout2879/X VPWR VGND sg13g2_dfrbpq_1
XFILLER_16_1002 VPWR VGND sg13g2_fill_1
XFILLER_9_219 VPWR VGND sg13g2_decap_8
XFILLER_107_1152 VPWR VGND sg13g2_decap_8
XFILLER_16_1035 VPWR VGND sg13g2_decap_8
XFILLER_70_35 VPWR VGND sg13g2_decap_8
X_22567_ _22567_/Q _23029_/CLK _22567_/D fanout2825/X VPWR VGND sg13g2_dfrbpq_1
XFILLER_6_904 VPWR VGND sg13g2_decap_8
X_12320_ _12323_/C _12788_/B _12320_/B VPWR VGND sg13g2_nor2_1
XFILLER_103_1038 VPWR VGND sg13g2_decap_8
XFILLER_13_1934 VPWR VGND sg13g2_decap_8
X_21518_ _21518_/Y _23775_/Q _21530_/B VPWR VGND sg13g2_nand2_1
XFILLER_108_810 VPWR VGND sg13g2_fill_1
X_22498_ _22498_/Q _22869_/CLK _22498_/D fanout2802/X VPWR VGND sg13g2_dfrbpq_1
XFILLER_100_1904 VPWR VGND sg13g2_decap_8
XFILLER_108_832 VPWR VGND sg13g2_fill_1
XFILLER_108_843 VPWR VGND sg13g2_fill_2
X_24237_ _24237_/Q clkload15/A _24237_/D fanout2859/X VPWR VGND sg13g2_dfrbpq_1
X_12251_ _12251_/X _24029_/Q _24061_/Q _12293_/A VPWR VGND sg13g2_mux2_1
XFILLER_79_11 VPWR VGND sg13g2_fill_1
Xplace3090 _21534_/B _21555_/B VPWR VGND sg13g2_buf_1
XFILLER_107_353 VPWR VGND sg13g2_fill_1
X_11202_ _11205_/A _22978_/Q VPWR VGND sg13g2_inv_2
XFILLER_29_1407 VPWR VGND sg13g2_decap_8
X_24168_ _24168_/Q clkload32/A _24168_/D fanout2645/X VPWR VGND sg13g2_dfrbpq_1
X_12182_ _14871_/A _12439_/A _12531_/B _12435_/A VPWR VGND sg13g2_o21ai_1
XFILLER_79_88 VPWR VGND sg13g2_fill_1
X_23119_ _23119_/Q _23215_/CLK _23119_/D fanout2925/X VPWR VGND sg13g2_dfrbpq_1
Xclkbuf_leaf_72_clk_i clkload6/A clkbuf_leaf_0_clk_i/A VPWR VGND sg13g2_buf_16
X_24099_ _24099_/Q _24131_/CLK _24099_/D fanout2712/X VPWR VGND sg13g2_dfrbpq_1
X_16990_ _16990_/Y _17182_/A _17021_/B VPWR VGND sg13g2_nand2_1
XFILLER_89_771 VPWR VGND sg13g2_decap_8
XFILLER_81_1645 VPWR VGND sg13g2_fill_1
XFILLER_0_141 VPWR VGND sg13g2_decap_4
XFILLER_110_529 VPWR VGND sg13g2_decap_8
XFILLER_95_21 VPWR VGND sg13g2_decap_4
X_15941_ _15941_/Y _15941_/A _15941_/B _15941_/C _15941_/D VPWR VGND sg13g2_nand4_1
XFILLER_42_1618 VPWR VGND sg13g2_decap_8
XFILLER_114_1123 VPWR VGND sg13g2_decap_8
XFILLER_1_697 VPWR VGND sg13g2_decap_8
XFILLER_95_65 VPWR VGND sg13g2_decap_8
XFILLER_7_1269 VPWR VGND sg13g2_fill_1
X_18660_ _18666_/B _23007_/Q _23008_/Q _23009_/Q _23010_/Q VPWR VGND sg13g2_nand4_1
X_15872_ _15874_/C _22865_/Q _15966_/B1 _15872_/B1 _22830_/Q VPWR VGND sg13g2_a22oi_1
XFILLER_76_454 VPWR VGND sg13g2_decap_4
XFILLER_95_87 VPWR VGND sg13g2_decap_8
XFILLER_110_1009 VPWR VGND sg13g2_fill_1
XFILLER_20_1905 VPWR VGND sg13g2_decap_8
X_17611_ _22884_/D _17652_/B _17609_/Y _17610_/Y VPWR VGND sg13g2_a21oi_1
X_14823_ _14823_/Y _18613_/A _14822_/Y _24228_/Q VPWR VGND sg13g2_a21oi_1
XFILLER_48_178 VPWR VGND sg13g2_fill_1
XFILLER_76_487 VPWR VGND sg13g2_decap_8
XFILLER_79_1530 VPWR VGND sg13g2_decap_8
X_18591_ _22997_/D _22997_/Q _18586_/X _19061_/S VPWR VGND sg13g2_mux2_1
XFILLER_64_638 VPWR VGND sg13g2_fill_2
XFILLER_91_446 VPWR VGND sg13g2_fill_2
XFILLER_40_1397 VPWR VGND sg13g2_decap_8
XFILLER_91_479 VPWR VGND sg13g2_fill_2
XFILLER_60_800 VPWR VGND sg13g2_decap_4
XFILLER_17_587 VPWR VGND sg13g2_decap_8
X_13705_ _13705_/X _24176_/Q _24208_/Q _23248_/Q _23280_/Q _13840_/S0 _13707_/S1 VPWR
+ VGND sg13g2_mux4_1
XFILLER_60_822 VPWR VGND sg13g2_decap_8
X_14685_ _14685_/X _14642_/A _14645_/A _14686_/B VPWR VGND sg13g2_mux2_1
X_17473_ _17473_/Y _22854_/Q _17489_/B VPWR VGND sg13g2_nand2_1
XFILLER_60_833 VPWR VGND sg13g2_fill_2
XFILLER_72_693 VPWR VGND sg13g2_decap_4
Xclkbuf_leaf_10_clk_i _22917_/CLK clkload1/A VPWR VGND sg13g2_buf_16
XFILLER_18_1801 VPWR VGND sg13g2_fill_2
X_19212_ _23169_/D _24258_/A _23169_/Q _19221_/S VPWR VGND sg13g2_mux2_1
X_13636_ _13636_/X _13636_/A _13636_/B VPWR VGND sg13g2_or2_1
X_16424_ _22579_/D _16424_/A _16424_/B VPWR VGND sg13g2_nand2_1
XFILLER_53_1714 VPWR VGND sg13g2_decap_8
XFILLER_73_1140 VPWR VGND sg13g2_fill_2
XFILLER_38_1271 VPWR VGND sg13g2_decap_4
XFILLER_53_1725 VPWR VGND sg13g2_fill_1
XFILLER_60_899 VPWR VGND sg13g2_decap_8
XFILLER_38_1293 VPWR VGND sg13g2_fill_1
X_19143_ _23119_/D _23119_/Q _18973_/B _19149_/S VPWR VGND sg13g2_mux2_1
X_13567_ _13568_/B _14134_/D _13567_/B VPWR VGND sg13g2_nor2_1
XFILLER_12_270 VPWR VGND sg13g2_decap_4
Xclkbuf_leaf_25_clk_i clkload47/A clkbuf_leaf_43_clk_i/A VPWR VGND sg13g2_buf_16
X_12518_ _19430_/A _19928_/A VPWR VGND sg13g2_inv_2
X_15306_ _15322_/A _22580_/Q _15306_/B VPWR VGND sg13g2_nand2_1
X_16286_ _22529_/D _16286_/A _16286_/B VPWR VGND sg13g2_xnor2_1
X_19074_ _23073_/D _23073_/Q _19073_/X _19086_/S VPWR VGND sg13g2_mux2_1
X_18025_ _18025_/Y _18023_/Y _18024_/Y _18030_/A VPWR VGND sg13g2_a21oi_1
X_15237_ _16778_/A _15307_/A _15300_/B _15300_/C VPWR VGND sg13g2_nand3_1
XFILLER_86_1512 VPWR VGND sg13g2_fill_1
X_12449_ _12450_/D _13611_/A _12449_/B VPWR VGND sg13g2_nor2_1
XFILLER_12_1466 VPWR VGND sg13g2_decap_8
XFILLER_114_802 VPWR VGND sg13g2_decap_8
Xhold4709 _21215_/A _23632_/Q VPWR VGND sg13g2_dlygate4sd3_1
X_15168_ _16681_/B _19360_/B _16789_/A VPWR VGND sg13g2_nand2b_1
XFILLER_5_992 VPWR VGND sg13g2_decap_8
X_14119_ _14127_/A _14591_/A _14119_/B _14119_/C VPWR VGND sg13g2_nand3_1
XFILLER_114_879 VPWR VGND sg13g2_decap_8
XFILLER_87_708 VPWR VGND sg13g2_decap_8
X_15099_ _16326_/B _22541_/Q _15117_/A _18748_/A VPWR VGND sg13g2_a21o_1
X_19976_ _23231_/D _20052_/B _22412_/A1 _19975_/Y VPWR VGND sg13g2_o21ai_1
XFILLER_99_579 VPWR VGND sg13g2_decap_8
XFILLER_68_900 VPWR VGND sg13g2_decap_8
XFILLER_64_1854 VPWR VGND sg13g2_decap_8
X_18927_ _18927_/Y _23050_/Q _18953_/A _18960_/B1 VPWR VGND sg13g2_o21ai_1
XFILLER_64_1876 VPWR VGND sg13g2_fill_2
XFILLER_79_270 VPWR VGND sg13g2_fill_1
XFILLER_68_944 VPWR VGND sg13g2_fill_2
XFILLER_25_1849 VPWR VGND sg13g2_decap_4
XFILLER_112_1819 VPWR VGND sg13g2_decap_8
X_18858_ _23043_/D _18858_/A _18858_/B _18858_/C VPWR VGND sg13g2_nand3_1
XFILLER_68_977 VPWR VGND sg13g2_decap_8
XFILLER_10_0 VPWR VGND sg13g2_decap_4
XFILLER_83_925 VPWR VGND sg13g2_decap_4
XFILLER_3_1623 VPWR VGND sg13g2_decap_8
XFILLER_67_476 VPWR VGND sg13g2_fill_2
XFILLER_7_1792 VPWR VGND sg13g2_decap_8
X_17809_ _17809_/Y _17809_/A1 _17807_/Y _17808_/Y VPWR VGND sg13g2_o21ai_1
XFILLER_94_284 VPWR VGND sg13g2_decap_8
X_18789_ _18794_/A _23033_/Q _18821_/B _18821_/C VPWR VGND sg13g2_nand3_1
XFILLER_55_649 VPWR VGND sg13g2_decap_4
XFILLER_48_690 VPWR VGND sg13g2_decap_8
XFILLER_3_1667 VPWR VGND sg13g2_fill_2
XFILLER_110_1576 VPWR VGND sg13g2_decap_8
XFILLER_82_479 VPWR VGND sg13g2_decap_4
XFILLER_78_1062 VPWR VGND sg13g2_decap_8
XFILLER_93_1527 VPWR VGND sg13g2_decap_8
XFILLER_23_502 VPWR VGND sg13g2_fill_2
XFILLER_51_811 VPWR VGND sg13g2_fill_2
XFILLER_63_671 VPWR VGND sg13g2_decap_8
XFILLER_23_524 VPWR VGND sg13g2_decap_4
X_20751_ _20751_/Y _23426_/Q _20751_/B VPWR VGND sg13g2_nand2_1
XFILLER_36_1912 VPWR VGND sg13g2_decap_8
XFILLER_51_855 VPWR VGND sg13g2_fill_2
XFILLER_62_192 VPWR VGND sg13g2_fill_1
XFILLER_36_1923 VPWR VGND sg13g2_fill_1
XFILLER_50_343 VPWR VGND sg13g2_decap_8
XFILLER_17_1311 VPWR VGND sg13g2_decap_8
X_23470_ _23470_/Q _24170_/CLK _23470_/D fanout2640/X VPWR VGND sg13g2_dfrbpq_1
XFILLER_71_1814 VPWR VGND sg13g2_decap_8
X_20682_ _20682_/Y _23394_/Q _20682_/B VPWR VGND sg13g2_nand2_1
XFILLER_71_1825 VPWR VGND sg13g2_fill_1
X_22421_ _24195_/D _20075_/Y _22434_/B _22420_/Y VPWR VGND sg13g2_o21ai_1
XFILLER_50_398 VPWR VGND sg13g2_decap_4
XFILLER_104_1325 VPWR VGND sg13g2_fill_2
XFILLER_109_629 VPWR VGND sg13g2_decap_8
XFILLER_104_1347 VPWR VGND sg13g2_decap_8
Xoutput4540 instr_addr_o[14] _14954_/Y VPWR VGND sg13g2_buf_1
XFILLER_30_1511 VPWR VGND sg13g2_decap_8
Xoutput4551 instr_addr_o[25] _15064_/X VPWR VGND sg13g2_buf_1
X_21303_ _23673_/D _21303_/A1 _21313_/B _21302_/Y VPWR VGND sg13g2_o21ai_1
Xoutput4562 instr_addr_o[6] _14869_/X VPWR VGND sg13g2_buf_1
X_22283_ _22283_/Y _22283_/A _22285_/B VPWR VGND sg13g2_nand2_1
X_24022_ _24022_/Q clkload46/A _24022_/D fanout2676/X VPWR VGND sg13g2_dfrbpq_1
X_21234_ _21234_/Y _21234_/A _21234_/B VPWR VGND sg13g2_nand2_1
XFILLER_89_1191 VPWR VGND sg13g2_decap_8
XFILLER_49_14 VPWR VGND sg13g2_decap_8
XFILLER_85_1077 VPWR VGND sg13g2_decap_4
X_21165_ _23607_/D _21299_/A1 _21215_/B _21164_/Y VPWR VGND sg13g2_o21ai_1
XFILLER_59_900 VPWR VGND sg13g2_decap_8
XFILLER_115_1410 VPWR VGND sg13g2_decap_8
X_20116_ _20118_/A _20117_/A _20116_/B VPWR VGND sg13g2_nand2b_1
X_21096_ _23574_/D _21297_/A1 _21099_/B _21095_/Y VPWR VGND sg13g2_o21ai_1
XFILLER_59_944 VPWR VGND sg13g2_fill_2
XFILLER_58_432 VPWR VGND sg13g2_decap_8
XFILLER_105_42 VPWR VGND sg13g2_decap_8
XFILLER_4_1409 VPWR VGND sg13g2_fill_1
XFILLER_63_1386 VPWR VGND sg13g2_decap_8
X_20047_ _20047_/Y _20047_/A VPWR VGND sg13g2_inv_1
XFILLER_24_1348 VPWR VGND sg13g2_decap_4
XFILLER_59_988 VPWR VGND sg13g2_decap_8
XFILLER_115_1476 VPWR VGND sg13g2_decap_8
XFILLER_65_13 VPWR VGND sg13g2_fill_2
XFILLER_74_914 VPWR VGND sg13g2_decap_4
XFILLER_41_1640 VPWR VGND sg13g2_decap_8
XFILLER_65_24 VPWR VGND sg13g2_fill_2
XFILLER_100_595 VPWR VGND sg13g2_decap_8
XFILLER_85_284 VPWR VGND sg13g2_fill_1
XFILLER_85_295 VPWR VGND sg13g2_decap_4
XFILLER_73_446 VPWR VGND sg13g2_decap_4
X_11820_ _11981_/B _14144_/C _11681_/Y _11819_/Y VPWR VGND sg13g2_a21oi_2
XFILLER_22_1072 VPWR VGND sg13g2_decap_4
XFILLER_76_1703 VPWR VGND sg13g2_decap_4
X_23806_ _23806_/Q _23966_/CLK _23806_/D fanout2785/X VPWR VGND sg13g2_dfrbpq_1
X_21998_ _23993_/D _22266_/A1 _22003_/B _21997_/Y VPWR VGND sg13g2_o21ai_1
XFILLER_26_351 VPWR VGND sg13g2_fill_1
XFILLER_27_874 VPWR VGND sg13g2_decap_4
XFILLER_2_1177 VPWR VGND sg13g2_decap_4
XFILLER_60_107 VPWR VGND sg13g2_fill_1
X_23737_ _23737_/Q _23966_/CLK _23737_/D fanout2783/X VPWR VGND sg13g2_dfrbpq_1
X_11751_ _11751_/Y _11384_/Y _11745_/Y _11747_/Y _11393_/Y _11750_/Y VPWR VGND sg13g2_a221oi_1
X_20949_ _23519_/D _21317_/A1 _20954_/B _20948_/Y VPWR VGND sg13g2_o21ai_1
XFILLER_41_310 VPWR VGND sg13g2_decap_4
XFILLER_57_1157 VPWR VGND sg13g2_decap_8
XFILLER_18_1119 VPWR VGND sg13g2_decap_8
XFILLER_57_1168 VPWR VGND sg13g2_decap_8
XFILLER_92_1059 VPWR VGND sg13g2_fill_2
X_14470_ _14471_/B _14470_/A _14470_/B VPWR VGND sg13g2_nor2_1
X_23668_ _23668_/Q clkload46/A _23668_/D fanout2671/X VPWR VGND sg13g2_dfrbpq_1
XFILLER_14_579 VPWR VGND sg13g2_decap_8
XFILLER_74_1471 VPWR VGND sg13g2_fill_1
X_13421_ _13421_/Y _13589_/B _24108_/Q _13420_/Y VPWR VGND sg13g2_o21ai_1
X_22619_ _22619_/Q _22917_/CLK _22619_/D fanout2896/X VPWR VGND sg13g2_dfrbpq_1
X_23599_ _23599_/Q clkload50/A _23599_/D fanout2658/X VPWR VGND sg13g2_dfrbpq_1
XFILLER_10_730 VPWR VGND sg13g2_fill_2
X_16140_ _16142_/A _20166_/A _15754_/Y _15755_/Y VPWR VGND sg13g2_a21oi_1
XFILLER_14_94 VPWR VGND sg13g2_decap_8
XFILLER_52_1780 VPWR VGND sg13g2_decap_8
XFILLER_5_200 VPWR VGND sg13g2_fill_2
XFILLER_52_1791 VPWR VGND sg13g2_fill_1
X_12303_ _12514_/B _12628_/A1 _12300_/X _12302_/Y VPWR VGND sg13g2_a21o_1
XFILLER_100_1712 VPWR VGND sg13g2_decap_4
X_16071_ _16071_/Y _17523_/A _16071_/B VPWR VGND sg13g2_nor2_1
XFILLER_87_1832 VPWR VGND sg13g2_fill_1
XFILLER_13_1775 VPWR VGND sg13g2_fill_1
X_15022_ _16296_/A _15022_/A _15022_/B VPWR VGND sg13g2_nand2_1
X_12234_ _12241_/A _12243_/A _12234_/B VPWR VGND sg13g2_nor2_1
XFILLER_87_1865 VPWR VGND sg13g2_fill_2
XFILLER_107_161 VPWR VGND sg13g2_decap_8
XFILLER_30_82 VPWR VGND sg13g2_decap_4
X_19830_ _19831_/C _20058_/A _19830_/B VPWR VGND sg13g2_nor2_1
XFILLER_9_1309 VPWR VGND sg13g2_decap_4
Xfanout2910 fanout2910/X fanout2913/X VPWR VGND sg13g2_buf_1
X_12165_ _12165_/Y _12166_/B _23900_/Q _12164_/Y VPWR VGND sg13g2_o21ai_1
Xfanout2921 fanout2921/X fanout2922/X VPWR VGND sg13g2_buf_1
XFILLER_69_719 VPWR VGND sg13g2_decap_8
Xfanout2932 fanout2932/X fanout2933/X VPWR VGND sg13g2_buf_1
X_19761_ _20004_/B _19378_/X _19760_/A _19760_/Y VPWR VGND sg13g2_o21ai_1
XFILLER_96_538 VPWR VGND sg13g2_decap_4
XFILLER_111_849 VPWR VGND sg13g2_decap_8
X_12096_ _12957_/B _12096_/A _12096_/B _12096_/C VPWR VGND sg13g2_nor3_1
X_16973_ _22704_/D _16972_/B _16971_/Y _16972_/Y VPWR VGND sg13g2_o21ai_1
XFILLER_49_421 VPWR VGND sg13g2_decap_8
XFILLER_110_348 VPWR VGND sg13g2_fill_1
X_18712_ _18713_/B _18712_/A _18714_/B VPWR VGND sg13g2_nand2_1
X_15924_ _15928_/A _22937_/Q _15924_/B VPWR VGND sg13g2_nand2_1
XFILLER_77_752 VPWR VGND sg13g2_decap_4
X_19692_ _23223_/D _20190_/S _21299_/A1 _19691_/Y VPWR VGND sg13g2_o21ai_1
XFILLER_81_1497 VPWR VGND sg13g2_fill_2
XFILLER_76_240 VPWR VGND sg13g2_fill_1
XFILLER_49_465 VPWR VGND sg13g2_decap_8
XFILLER_4_1921 VPWR VGND sg13g2_decap_8
XFILLER_77_785 VPWR VGND sg13g2_decap_8
XFILLER_7_1099 VPWR VGND sg13g2_decap_8
X_18643_ _18643_/Y _18689_/A _18642_/Y _23006_/Q VPWR VGND sg13g2_a21oi_1
XFILLER_76_273 VPWR VGND sg13g2_fill_1
X_15855_ _15856_/D _22774_/Q _15940_/B VPWR VGND sg13g2_nand2_1
XFILLER_92_744 VPWR VGND sg13g2_decap_8
X_14806_ _14806_/Y _22945_/Q _14446_/B _14596_/A VPWR VGND sg13g2_o21ai_1
XFILLER_18_863 VPWR VGND sg13g2_fill_1
XFILLER_0_1829 VPWR VGND sg13g2_decap_4
XFILLER_111_1885 VPWR VGND sg13g2_decap_8
X_15786_ _15798_/A _22771_/Q _15700_/B _16007_/B _22803_/Q VPWR VGND sg13g2_a22oi_1
XFILLER_52_619 VPWR VGND sg13g2_decap_8
X_12998_ _12999_/A _23558_/Q _12998_/A2 _12997_/X _12816_/A VPWR VGND sg13g2_a22oi_1
XFILLER_45_660 VPWR VGND sg13g2_decap_8
X_17525_ _17525_/Y _22877_/Q _17540_/B VPWR VGND sg13g2_nor2_1
XFILLER_73_991 VPWR VGND sg13g2_fill_1
XFILLER_75_1224 VPWR VGND sg13g2_decap_8
XFILLER_17_384 VPWR VGND sg13g2_decap_8
X_14737_ _14737_/X _14711_/Y _14709_/X _14737_/S VPWR VGND sg13g2_mux2_1
XFILLER_44_170 VPWR VGND sg13g2_fill_1
X_11949_ _11950_/B _24186_/Q _23258_/Q _23322_/Q _23386_/Q _11797_/S _12567_/A VPWR
+ VGND sg13g2_mux4_1
X_17456_ _22846_/D _16067_/A _17467_/B _17455_/Y VPWR VGND sg13g2_o21ai_1
X_14668_ _14668_/Y _14707_/A1 _14642_/B _14667_/Y VPWR VGND sg13g2_o21ai_1
X_16407_ _16407_/Y _22571_/Q _16413_/S VPWR VGND sg13g2_nand2_1
X_13619_ _13619_/Y _24079_/Q _13621_/S VPWR VGND sg13g2_nand2b_1
XFILLER_32_398 VPWR VGND sg13g2_decap_8
Xrebuffer5506 rebuffer5506/X rebuffer5507/X VPWR VGND sg13g2_buf_1
Xrebuffer5517 rebuffer5517/X rebuffer5518/X VPWR VGND sg13g2_buf_1
X_17387_ _22817_/D _17386_/B _17385_/X _17386_/Y VPWR VGND sg13g2_o21ai_1
Xplace3804 _12628_/A1 _11993_/A VPWR VGND sg13g2_buf_4
X_14599_ _24224_/D _22877_/Q _14742_/B _14599_/C _14612_/B VPWR VGND sg13g2_and4_1
Xrebuffer5528 rebuffer5528/X rebuffer5529/X VPWR VGND sg13g2_buf_1
XFILLER_53_1577 VPWR VGND sg13g2_fill_1
X_19126_ _23103_/D _23103_/Q _19126_/A1 _19130_/S VPWR VGND sg13g2_mux2_1
Xrebuffer5539 rebuffer5539/X rebuffer5540/X VPWR VGND sg13g2_buf_1
Xplace3815 _15785_/B _14434_/Y VPWR VGND sg13g2_buf_1
X_16338_ _16351_/A _22750_/Q _17234_/A _17303_/A _22782_/Q _16337_/Y VPWR VGND sg13g2_a221oi_1
XFILLER_31_1820 VPWR VGND sg13g2_decap_8
Xplace3826 _13904_/B _12899_/S VPWR VGND sg13g2_buf_1
XFILLER_88_1607 VPWR VGND sg13g2_fill_2
Xplace3837 _16352_/B _14434_/B VPWR VGND sg13g2_buf_1
Xplace3848 _12824_/B1 _11441_/S VPWR VGND sg13g2_buf_1
Xplace3859 _20305_/A _20272_/A VPWR VGND sg13g2_buf_1
X_19057_ _23065_/D _23065_/Q _19056_/X _19061_/S VPWR VGND sg13g2_mux2_1
Xhold5207 _17358_/A _22806_/Q VPWR VGND sg13g2_dlygate4sd3_1
X_16269_ _22526_/D _16269_/A _16269_/B VPWR VGND sg13g2_xnor2_1
X_18008_ _18008_/X _18984_/A _23056_/Q _18015_/S VPWR VGND sg13g2_mux2_1
XFILLER_58_0 VPWR VGND sg13g2_decap_8
XFILLER_12_1285 VPWR VGND sg13g2_decap_8
XFILLER_66_1916 VPWR VGND sg13g2_fill_2
XFILLER_99_343 VPWR VGND sg13g2_decap_4
XFILLER_114_676 VPWR VGND sg13g2_decap_8
XFILLER_29_1760 VPWR VGND sg13g2_fill_2
XFILLER_9_1843 VPWR VGND sg13g2_decap_8
XFILLER_25_1602 VPWR VGND sg13g2_decap_8
XFILLER_113_175 VPWR VGND sg13g2_decap_8
XFILLER_102_849 VPWR VGND sg13g2_decap_8
X_19959_ _19959_/Y _20031_/A _19959_/B VPWR VGND sg13g2_nand2_1
XFILLER_60_1504 VPWR VGND sg13g2_decap_8
XFILLER_60_1515 VPWR VGND sg13g2_fill_1
XFILLER_101_348 VPWR VGND sg13g2_decap_8
XFILLER_5_1707 VPWR VGND sg13g2_decap_8
XFILLER_101_359 VPWR VGND sg13g2_fill_1
X_22970_ _22970_/Q clkload16/A _22970_/D fanout2920/X VPWR VGND sg13g2_dfrbpq_1
XFILLER_56_903 VPWR VGND sg13g2_decap_8
XFILLER_68_763 VPWR VGND sg13g2_decap_4
XFILLER_99_1725 VPWR VGND sg13g2_fill_1
XFILLER_67_240 VPWR VGND sg13g2_fill_1
XFILLER_110_871 VPWR VGND sg13g2_decap_8
XFILLER_99_1736 VPWR VGND sg13g2_decap_8
XFILLER_83_711 VPWR VGND sg13g2_decap_8
XFILLER_110_882 VPWR VGND sg13g2_fill_2
XFILLER_27_104 VPWR VGND sg13g2_fill_2
XFILLER_112_1649 VPWR VGND sg13g2_decap_8
XFILLER_28_638 VPWR VGND sg13g2_decap_8
XFILLER_55_424 VPWR VGND sg13g2_decap_8
XFILLER_27_137 VPWR VGND sg13g2_decap_8
XFILLER_71_906 VPWR VGND sg13g2_decap_8
X_21852_ _21916_/B _21918_/D _22050_/B _22050_/C _22186_/A VPWR VGND sg13g2_nand4_1
XFILLER_97_1460 VPWR VGND sg13g2_decap_8
Xinput4405 _20316_/A2 data_rdata_i[5] VPWR VGND sg13g2_buf_1
XFILLER_3_1497 VPWR VGND sg13g2_decap_8
XFILLER_64_980 VPWR VGND sg13g2_decap_4
XFILLER_93_1324 VPWR VGND sg13g2_fill_1
X_20803_ _20803_/Y _20803_/A _20809_/B VPWR VGND sg13g2_nand2_1
Xinput4416 _18010_/B instr_rdata_i[10] VPWR VGND sg13g2_buf_1
XFILLER_19_1406 VPWR VGND sg13g2_decap_4
Xinput4427 _18918_/B instr_rdata_i[20] VPWR VGND sg13g2_buf_1
X_21783_ _21783_/Y _21783_/A _21783_/B VPWR VGND sg13g2_nand2_1
Xinput4438 _19028_/A instr_rdata_i[30] VPWR VGND sg13g2_buf_1
XFILLER_51_630 VPWR VGND sg13g2_decap_8
XFILLER_58_1466 VPWR VGND sg13g2_decap_8
Xinput4449 _14202_/A irqs_i[10] VPWR VGND sg13g2_buf_1
XFILLER_58_1477 VPWR VGND sg13g2_fill_2
X_23522_ _23522_/Q clkload41/A _23522_/D fanout2726/X VPWR VGND sg13g2_dfrbpq_1
X_20734_ _20734_/Y _20734_/A _20738_/B VPWR VGND sg13g2_nand2_1
XFILLER_11_516 VPWR VGND sg13g2_decap_8
X_23453_ _23453_/Q clkload55/A _23453_/D fanout2779/X VPWR VGND sg13g2_dfrbpq_1
XFILLER_50_173 VPWR VGND sg13g2_decap_8
X_20665_ _23386_/D _19817_/Y _20666_/B _20664_/Y VPWR VGND sg13g2_o21ai_1
XFILLER_17_1152 VPWR VGND sg13g2_decap_8
XFILLER_71_1655 VPWR VGND sg13g2_decap_4
XFILLER_32_1628 VPWR VGND sg13g2_decap_8
X_22404_ _22404_/Y _24188_/Q _22408_/B VPWR VGND sg13g2_nand2_1
XFILLER_71_1688 VPWR VGND sg13g2_decap_4
X_23384_ _23384_/Q clkload54/A _23384_/D fanout2752/X VPWR VGND sg13g2_dfrbpq_1
X_20596_ _20596_/Y _20596_/A _20607_/B VPWR VGND sg13g2_nand2_1
XFILLER_104_1166 VPWR VGND sg13g2_decap_8
X_22335_ _22335_/Y _22335_/A _22335_/B VPWR VGND sg13g2_nand2_1
XFILLER_87_1139 VPWR VGND sg13g2_decap_8
XFILLER_69_1551 VPWR VGND sg13g2_fill_2
XFILLER_2_203 VPWR VGND sg13g2_fill_2
X_22266_ _24121_/D _22266_/A1 _22276_/B _22265_/Y VPWR VGND sg13g2_o21ai_1
XFILLER_105_621 VPWR VGND sg13g2_decap_8
XFILLER_65_1415 VPWR VGND sg13g2_decap_4
X_24005_ _24005_/Q clkload37/A _24005_/D fanout2714/X VPWR VGND sg13g2_dfrbpq_1
X_21217_ _23633_/D _23633_/Q _21617_/A0 _21220_/S VPWR VGND sg13g2_mux2_1
X_22197_ _22197_/Y _22197_/A _22249_/S VPWR VGND sg13g2_nand2_1
XFILLER_105_676 VPWR VGND sg13g2_decap_8
XFILLER_78_516 VPWR VGND sg13g2_decap_8
XFILLER_104_164 VPWR VGND sg13g2_decap_8
X_21148_ _21148_/Y _23600_/Q _21151_/B VPWR VGND sg13g2_nand2_1
XFILLER_43_1713 VPWR VGND sg13g2_decap_8
XFILLER_82_1773 VPWR VGND sg13g2_decap_4
XFILLER_47_1893 VPWR VGND sg13g2_fill_2
XFILLER_93_508 VPWR VGND sg13g2_fill_2
XFILLER_28_1292 VPWR VGND sg13g2_fill_2
XFILLER_24_1134 VPWR VGND sg13g2_decap_8
X_21079_ _21079_/Y _21079_/A _21079_/B VPWR VGND sg13g2_nand2_1
X_13970_ _13970_/Y _13970_/A _13970_/B VPWR VGND sg13g2_nand2_1
XFILLER_115_1262 VPWR VGND sg13g2_decap_8
XFILLER_86_560 VPWR VGND sg13g2_fill_2
XFILLER_24_1145 VPWR VGND sg13g2_fill_2
XFILLER_76_67 VPWR VGND sg13g2_fill_2
XFILLER_46_413 VPWR VGND sg13g2_fill_2
XFILLER_47_936 VPWR VGND sg13g2_decap_8
XFILLER_111_1126 VPWR VGND sg13g2_decap_8
X_12921_ _12921_/X _24037_/Q _24069_/Q _12921_/S VPWR VGND sg13g2_mux2_1
XFILLER_98_1235 VPWR VGND sg13g2_fill_1
XFILLER_111_1137 VPWR VGND sg13g2_fill_1
XFILLER_18_126 VPWR VGND sg13g2_decap_8
XFILLER_58_295 VPWR VGND sg13g2_decap_8
XFILLER_111_1148 VPWR VGND sg13g2_decap_4
XFILLER_47_969 VPWR VGND sg13g2_decap_8
XFILLER_98_1268 VPWR VGND sg13g2_fill_1
XFILLER_92_11 VPWR VGND sg13g2_fill_2
X_15640_ _15642_/A _22854_/Q _15989_/A2 _15684_/B _22892_/Q VPWR VGND sg13g2_a22oi_1
XFILLER_73_243 VPWR VGND sg13g2_decap_8
XFILLER_74_777 VPWR VGND sg13g2_fill_2
XFILLER_62_928 VPWR VGND sg13g2_fill_1
X_12852_ _13082_/A _12852_/A _12852_/B VPWR VGND sg13g2_nor2_1
XFILLER_55_980 VPWR VGND sg13g2_decap_4
XFILLER_61_416 VPWR VGND sg13g2_decap_8
Xclkbuf_4_13__f_clk_i clkload3/A clkbuf_3_6_0_clk_i/X VPWR VGND sg13g2_buf_8
XFILLER_76_1533 VPWR VGND sg13g2_decap_8
X_11803_ _11818_/B _11803_/A _11803_/B _11803_/C _11803_/D VPWR VGND sg13g2_nor4_2
X_15571_ _16099_/A _18657_/A _15633_/S _15570_/Y VPWR VGND sg13g2_o21ai_1
X_12783_ _12783_/Y _12779_/X _12780_/Y _12781_/X _12782_/X VPWR VGND sg13g2_a22oi_1
XFILLER_73_298 VPWR VGND sg13g2_decap_4
XFILLER_109_1000 VPWR VGND sg13g2_fill_2
XFILLER_61_449 VPWR VGND sg13g2_fill_2
XFILLER_76_1555 VPWR VGND sg13g2_decap_4
XFILLER_37_1517 VPWR VGND sg13g2_decap_4
XFILLER_76_1566 VPWR VGND sg13g2_decap_8
X_17310_ _22783_/D _16043_/A _17315_/B _17309_/Y VPWR VGND sg13g2_o21ai_1
XFILLER_26_192 VPWR VGND sg13g2_decap_8
X_11734_ _11778_/A _11734_/A _11734_/B VPWR VGND sg13g2_nand2_2
X_14522_ _14599_/C _24239_/D _14522_/B VPWR VGND sg13g2_nor2_1
X_18290_ _18290_/Y _18290_/A _18464_/A _18290_/C VPWR VGND sg13g2_nand3_1
XFILLER_19_1940 VPWR VGND sg13g2_decap_8
XFILLER_15_899 VPWR VGND sg13g2_decap_8
XFILLER_14_376 VPWR VGND sg13g2_decap_8
XFILLER_109_1066 VPWR VGND sg13g2_decap_8
X_17241_ _22751_/D _16043_/A _17252_/B _17240_/Y VPWR VGND sg13g2_o21ai_1
XFILLER_35_1230 VPWR VGND sg13g2_decap_8
X_11665_ _19671_/A _11254_/Y _11265_/Y _11302_/X VPWR VGND sg13g2_a21oi_2
X_14453_ _16681_/A _15268_/A _17390_/A _15268_/B _14453_/D VPWR VGND sg13g2_nor4_1
XFILLER_15_1815 VPWR VGND sg13g2_decap_8
XFILLER_54_1875 VPWR VGND sg13g2_decap_8
XFILLER_70_1143 VPWR VGND sg13g2_decap_8
XFILLER_35_1263 VPWR VGND sg13g2_decap_4
X_13404_ _13406_/A _13649_/A _13404_/B VPWR VGND sg13g2_nand2_1
X_17172_ _17173_/C _22737_/Q _17178_/D VPWR VGND sg13g2_nand2_1
XFILLER_35_1296 VPWR VGND sg13g2_decap_8
X_11596_ _11596_/Y _14098_/A _14098_/B _11596_/C _11596_/D VPWR VGND sg13g2_nor4_1
XFILLER_89_1927 VPWR VGND sg13g2_decap_8
X_13335_ _13335_/X _24171_/Q _24203_/Q _23243_/Q _23275_/Q _13840_/S0 _13707_/S1 VPWR
+ VGND sg13g2_mux4_1
XFILLER_115_418 VPWR VGND sg13g2_decap_8
XFILLER_100_1542 VPWR VGND sg13g2_decap_8
X_13266_ _13267_/C _13266_/A1 _13263_/Y _13265_/Y _14189_/A VPWR VGND sg13g2_a22oi_1
X_16054_ _16054_/Y _16054_/A _16075_/B VPWR VGND sg13g2_nor2_1
XFILLER_83_1515 VPWR VGND sg13g2_decap_8
X_12217_ _12218_/D _12318_/A _12216_/X _12316_/A VPWR VGND sg13g2_o21ai_1
X_15005_ _15010_/A _22532_/Q _16304_/A VPWR VGND sg13g2_nor2_1
X_13197_ _13216_/B _13194_/Y _13196_/Y _13641_/A VPWR VGND sg13g2_a21oi_1
XFILLER_9_1106 VPWR VGND sg13g2_fill_1
XFILLER_9_1117 VPWR VGND sg13g2_fill_2
XFILLER_97_825 VPWR VGND sg13g2_fill_2
X_19813_ _19813_/Y _19850_/A _19813_/B VPWR VGND sg13g2_nor2_1
X_12148_ _12148_/Y _12148_/A _12148_/B _12148_/C _12148_/D VPWR VGND sg13g2_nor4_2
Xfanout2740 fanout2740/X fanout2741/X VPWR VGND sg13g2_buf_1
Xfanout2751 fanout2751/X fanout2752/X VPWR VGND sg13g2_buf_1
XFILLER_29_1078 VPWR VGND sg13g2_fill_2
XFILLER_110_112 VPWR VGND sg13g2_decap_8
Xfanout2762 fanout2762/X fanout2767/X VPWR VGND sg13g2_buf_1
XFILLER_69_549 VPWR VGND sg13g2_fill_1
XFILLER_111_646 VPWR VGND sg13g2_decap_8
XFILLER_1_280 VPWR VGND sg13g2_fill_1
Xfanout2773 fanout2773/X fanout2776/X VPWR VGND sg13g2_buf_1
Xfanout2784 fanout2784/X fanout2786/X VPWR VGND sg13g2_buf_1
X_19744_ _19744_/Y _19782_/A1 _19742_/Y _19743_/Y VPWR VGND sg13g2_a21oi_1
X_12079_ _12079_/Y _19322_/A _19728_/B _15319_/A VPWR VGND sg13g2_nand3_1
Xfanout2795 fanout2795/X fanout2796/X VPWR VGND sg13g2_buf_1
XFILLER_2_42 VPWR VGND sg13g2_decap_8
X_16956_ _16956_/X _22701_/Q _16956_/B VPWR VGND sg13g2_xor2_1
XFILLER_77_560 VPWR VGND sg13g2_fill_2
XFILLER_61_1879 VPWR VGND sg13g2_decap_8
XFILLER_110_189 VPWR VGND sg13g2_decap_8
X_15907_ _17197_/A _15906_/A _15905_/Y _15906_/Y VPWR VGND sg13g2_a21o_1
X_19675_ _19676_/B _24247_/A _19977_/B _19668_/Y _19671_/A _19674_/Y VPWR VGND sg13g2_a221oi_1
XFILLER_64_210 VPWR VGND sg13g2_decap_8
X_16887_ _16888_/B _22687_/Q _16907_/C VPWR VGND sg13g2_nand2_1
X_18626_ _18629_/C _18626_/A VPWR VGND sg13g2_inv_1
X_15838_ _15838_/Y _15905_/A _20234_/A VPWR VGND sg13g2_nor2_1
XFILLER_92_574 VPWR VGND sg13g2_decap_8
XFILLER_0_1626 VPWR VGND sg13g2_fill_1
XFILLER_4_1795 VPWR VGND sg13g2_decap_8
XFILLER_98_1791 VPWR VGND sg13g2_fill_1
XFILLER_18_671 VPWR VGND sg13g2_fill_2
X_18557_ _18557_/Y _22994_/Q _18557_/B VPWR VGND sg13g2_nand2_1
X_15769_ _15771_/C _22930_/Q _15924_/B _15804_/B1 _14224_/A VPWR VGND sg13g2_a22oi_1
XFILLER_61_950 VPWR VGND sg13g2_fill_1
X_17508_ _17528_/B _17835_/B _17517_/B VPWR VGND sg13g2_nand2_1
XFILLER_21_803 VPWR VGND sg13g2_decap_8
XFILLER_61_972 VPWR VGND sg13g2_fill_1
XFILLER_21_814 VPWR VGND sg13g2_fill_1
X_18488_ _18488_/Y _22989_/Q _18557_/B VPWR VGND sg13g2_nand2_1
XFILLER_21_825 VPWR VGND sg13g2_fill_2
XFILLER_36_1038 VPWR VGND sg13g2_decap_8
XFILLER_61_994 VPWR VGND sg13g2_decap_4
Xplace4302 _12459_/S0 _12909_/B VPWR VGND sg13g2_buf_2
X_17439_ _17439_/Y _17439_/A _17439_/B VPWR VGND sg13g2_nand2_1
XFILLER_18_1450 VPWR VGND sg13g2_decap_8
Xplace4313 _12401_/B _12453_/S VPWR VGND sg13g2_buf_1
XFILLER_72_1953 VPWR VGND sg13g2_fill_2
XFILLER_18_1461 VPWR VGND sg13g2_fill_1
XFILLER_32_184 VPWR VGND sg13g2_fill_2
XFILLER_53_1341 VPWR VGND sg13g2_decap_8
Xplace4324 _11855_/S _11752_/B VPWR VGND sg13g2_buf_1
XFILLER_14_1303 VPWR VGND sg13g2_decap_4
Xrebuffer5303 _15216_/C _14129_/Y VPWR VGND sg13g2_buf_1
Xrebuffer5314 _12249_/A1 _11407_/A VPWR VGND sg13g2_buf_2
XFILLER_33_1937 VPWR VGND sg13g2_decap_8
Xplace4335 _15216_/A _11634_/A VPWR VGND sg13g2_buf_1
Xplace4346 _14120_/C _22967_/Q VPWR VGND sg13g2_buf_1
Xrebuffer5325 _13950_/C _13083_/Y VPWR VGND sg13g2_buf_1
Xplace3601 _17670_/B1 _17583_/A VPWR VGND sg13g2_buf_1
X_20450_ _23287_/D _19688_/Y _20451_/B _20449_/Y VPWR VGND sg13g2_o21ai_1
Xplace3612 _15042_/B _18602_/A VPWR VGND sg13g2_buf_1
Xrebuffer5336 _14065_/A _13065_/Y VPWR VGND sg13g2_buf_2
Xplace3623 _19696_/B _19634_/B VPWR VGND sg13g2_buf_1
Xrebuffer4602 _12831_/B _12585_/Y VPWR VGND sg13g2_buf_8
XFILLER_105_1464 VPWR VGND sg13g2_decap_4
XFILLER_14_1347 VPWR VGND sg13g2_decap_8
Xrebuffer5347 _11393_/B _11377_/A VPWR VGND sg13g2_buf_1
XFILLER_101_1306 VPWR VGND sg13g2_decap_8
Xrebuffer4613 _12965_/A _12098_/A1 VPWR VGND sg13g2_buf_1
Xrebuffer5358 _14890_/B2 _12278_/X VPWR VGND sg13g2_buf_8
Xplace3634 _15113_/B _14912_/B VPWR VGND sg13g2_buf_1
Xrebuffer5369 _15245_/A _12525_/B VPWR VGND sg13g2_buf_1
Xplace3645 _14718_/B _19238_/A VPWR VGND sg13g2_buf_1
X_19109_ _23090_/D _23090_/Q _19108_/X _19115_/S VPWR VGND sg13g2_mux2_1
Xrebuffer4624 _20064_/B _12748_/B VPWR VGND sg13g2_buf_1
XFILLER_107_908 VPWR VGND sg13g2_decap_8
Xplace3656 _17629_/B _16060_/B VPWR VGND sg13g2_buf_1
Xplace3667 _15487_/A2 _15307_/B VPWR VGND sg13g2_buf_1
X_20381_ _23255_/D _20931_/A1 _20380_/B _20380_/Y VPWR VGND sg13g2_o21ai_1
Xhold5004 _21703_/A _23863_/Q VPWR VGND sg13g2_dlygate4sd3_1
Xplace3678 _15006_/B _15114_/A2 VPWR VGND sg13g2_buf_1
Xplace2944 _21295_/A1 _19526_/Y VPWR VGND sg13g2_buf_1
Xhold5015 _22184_/A _24084_/Q VPWR VGND sg13g2_dlygate4sd3_1
Xhold5026 _20376_/A _23253_/Q VPWR VGND sg13g2_dlygate4sd3_1
XFILLER_12_1060 VPWR VGND sg13g2_fill_2
Xplace3689 _13440_/B _20208_/A VPWR VGND sg13g2_buf_1
Xplace2955 _19047_/C _18959_/C VPWR VGND sg13g2_buf_1
Xhold5037 _22313_/A _24146_/Q VPWR VGND sg13g2_dlygate4sd3_1
Xhold5048 _20588_/A _23349_/Q VPWR VGND sg13g2_dlygate4sd3_1
Xplace2966 _16388_/B _18657_/B VPWR VGND sg13g2_buf_1
Xplace2977 _18140_/B _18524_/B VPWR VGND sg13g2_buf_2
Xhold5059 _22071_/A _24028_/Q VPWR VGND sg13g2_dlygate4sd3_1
Xplace2988 _18868_/S _18889_/B VPWR VGND sg13g2_buf_1
Xplace2999 _17090_/A _17144_/B VPWR VGND sg13g2_buf_1
XFILLER_115_963 VPWR VGND sg13g2_decap_8
XFILLER_88_803 VPWR VGND sg13g2_decap_8
XFILLER_114_473 VPWR VGND sg13g2_decap_8
XFILLER_102_624 VPWR VGND sg13g2_decap_8
XFILLER_82_1047 VPWR VGND sg13g2_decap_8
XFILLER_87_324 VPWR VGND sg13g2_fill_1
XFILLER_82_1058 VPWR VGND sg13g2_fill_1
XFILLER_60_1301 VPWR VGND sg13g2_decap_8
XFILLER_68_582 VPWR VGND sg13g2_decap_4
XFILLER_29_947 VPWR VGND sg13g2_decap_8
X_22953_ _22953_/Q _23187_/CLK _22953_/D fanout2917/X VPWR VGND sg13g2_dfrbpq_1
XFILLER_110_690 VPWR VGND sg13g2_decap_8
X_21904_ _21904_/Y _21904_/A _21910_/B VPWR VGND sg13g2_nand2_1
XFILLER_83_563 VPWR VGND sg13g2_decap_8
XFILLER_28_479 VPWR VGND sg13g2_decap_4
X_22884_ _22884_/Q clkload28/A _22884_/D fanout2871/X VPWR VGND sg13g2_dfrbpq_1
XFILLER_102_21 VPWR VGND sg13g2_decap_8
XFILLER_71_725 VPWR VGND sg13g2_fill_2
X_21835_ _21835_/Y _21835_/A _21850_/B VPWR VGND sg13g2_nand2_1
XFILLER_70_224 VPWR VGND sg13g2_decap_8
XFILLER_71_758 VPWR VGND sg13g2_fill_2
XFILLER_93_1165 VPWR VGND sg13g2_decap_4
XFILLER_19_1236 VPWR VGND sg13g2_decap_8
XFILLER_58_1285 VPWR VGND sg13g2_fill_1
XFILLER_23_151 VPWR VGND sg13g2_decap_8
XFILLER_70_279 VPWR VGND sg13g2_fill_2
XFILLER_93_1198 VPWR VGND sg13g2_decap_8
XFILLER_11_313 VPWR VGND sg13g2_fill_1
XFILLER_106_1217 VPWR VGND sg13g2_decap_8
X_23505_ _23505_/Q _24113_/CLK _23505_/D fanout2682/X VPWR VGND sg13g2_dfrbpq_1
X_20717_ _20921_/B _22050_/A _21289_/C VPWR VGND sg13g2_and2_1
X_21697_ _21697_/Y _23861_/Q _21713_/B VPWR VGND sg13g2_nand2_1
XFILLER_71_1441 VPWR VGND sg13g2_decap_8
XFILLER_8_818 VPWR VGND sg13g2_fill_1
XFILLER_32_1403 VPWR VGND sg13g2_decap_8
XFILLER_71_1463 VPWR VGND sg13g2_decap_8
X_23436_ _23436_/Q clkload38/A _23436_/D fanout2630/X VPWR VGND sg13g2_dfrbpq_1
X_20648_ _23380_/D _20362_/Y _20644_/B _20647_/Y VPWR VGND sg13g2_o21ai_1
XFILLER_32_1458 VPWR VGND sg13g2_decap_4
XFILLER_109_245 VPWR VGND sg13g2_decap_4
XFILLER_10_1701 VPWR VGND sg13g2_decap_8
X_23367_ _23367_/Q clkload35/A _23367_/D fanout2632/X VPWR VGND sg13g2_dfrbpq_1
X_20579_ _23346_/D _22448_/A1 _20578_/B _20578_/Y VPWR VGND sg13g2_o21ai_1
X_13120_ _13120_/Y _13120_/A _13120_/B VPWR VGND sg13g2_nor2_1
X_22318_ _22383_/B _22430_/A _22318_/B VPWR VGND sg13g2_nand2b_1
X_23298_ _23298_/Q _24196_/CLK _23298_/D fanout2719/X VPWR VGND sg13g2_dfrbpq_1
XFILLER_101_1873 VPWR VGND sg13g2_decap_8
XFILLER_10_1767 VPWR VGND sg13g2_fill_2
X_13051_ _13051_/X _23591_/Q _23623_/Q _23655_/Q _23687_/Q _13243_/S0 _13042_/A VPWR
+ VGND sg13g2_mux4_1
X_22249_ _24115_/D _22249_/A0 _24115_/Q _22249_/S VPWR VGND sg13g2_mux2_1
XFILLER_106_974 VPWR VGND sg13g2_decap_8
XFILLER_79_814 VPWR VGND sg13g2_fill_1
X_12002_ _12003_/A _12002_/A _12002_/B _12002_/C _12084_/C VPWR VGND sg13g2_and4_1
XFILLER_45_1819 VPWR VGND sg13g2_decap_4
XFILLER_78_313 VPWR VGND sg13g2_decap_4
Xhold4870 _22069_/A _24027_/Q VPWR VGND sg13g2_dlygate4sd3_1
XFILLER_26_1229 VPWR VGND sg13g2_fill_2
Xhold4881 _22175_/A _24078_/Q VPWR VGND sg13g2_dlygate4sd3_1
Xclkbuf_3_5_0_clk_i clkbuf_3_5_0_clk_i/X clkbuf_0_clk_i/X VPWR VGND sg13g2_buf_16
Xhold4892 _21732_/A _23872_/Q VPWR VGND sg13g2_dlygate4sd3_1
XFILLER_78_346 VPWR VGND sg13g2_fill_1
XFILLER_94_806 VPWR VGND sg13g2_fill_1
X_16810_ _16810_/Y _16830_/A _16810_/B VPWR VGND sg13g2_nand2_1
XFILLER_82_1592 VPWR VGND sg13g2_decap_4
X_17790_ _22904_/D _17789_/B _17788_/Y _17789_/Y VPWR VGND sg13g2_a21oi_1
XFILLER_43_1565 VPWR VGND sg13g2_fill_1
XFILLER_47_722 VPWR VGND sg13g2_decap_8
X_16741_ _16741_/Y _16755_/A _16741_/B VPWR VGND sg13g2_nor2_1
XFILLER_47_733 VPWR VGND sg13g2_fill_2
XFILLER_101_690 VPWR VGND sg13g2_fill_2
XFILLER_86_390 VPWR VGND sg13g2_decap_8
XFILLER_19_457 VPWR VGND sg13g2_decap_8
XFILLER_1_1902 VPWR VGND sg13g2_decap_8
XFILLER_60_1890 VPWR VGND sg13g2_fill_1
X_19460_ _19460_/Y _20338_/A _19460_/B VPWR VGND sg13g2_nand2_1
X_12904_ _12904_/X _12902_/X _12903_/X _13244_/S VPWR VGND sg13g2_mux2_1
X_16672_ _16673_/B _22650_/Q _16672_/B VPWR VGND sg13g2_xnor2_1
XFILLER_74_563 VPWR VGND sg13g2_fill_1
X_13884_ _13885_/B _14004_/B _13932_/D _13880_/B VPWR VGND sg13g2_a21oi_1
XFILLER_35_939 VPWR VGND sg13g2_decap_8
X_18411_ _22984_/D _14758_/A _18471_/S _18410_/Y VPWR VGND sg13g2_a21oi_1
XFILLER_74_596 VPWR VGND sg13g2_decap_4
XFILLER_28_991 VPWR VGND sg13g2_fill_1
X_15623_ _15628_/C _15623_/A _15623_/B VPWR VGND sg13g2_nor2_1
XFILLER_95_1953 VPWR VGND sg13g2_fill_2
X_19391_ _19561_/B _19728_/B _19423_/B _19390_/Y VPWR VGND sg13g2_a21oi_1
XFILLER_21_1896 VPWR VGND sg13g2_decap_8
X_12835_ _12835_/X _20066_/A _20064_/B VPWR VGND sg13g2_or2_1
XFILLER_34_449 VPWR VGND sg13g2_decap_8
X_18342_ _18342_/Y _18562_/B _18363_/B VPWR VGND sg13g2_nand2_1
XFILLER_72_1205 VPWR VGND sg13g2_fill_1
X_15554_ _15562_/B _16871_/C _15551_/Y _15553_/Y VPWR VGND sg13g2_o21ai_1
XFILLER_37_1336 VPWR VGND sg13g2_decap_8
X_12766_ _12766_/Y _12766_/A _12766_/B VPWR VGND sg13g2_nor2_1
XFILLER_76_1385 VPWR VGND sg13g2_fill_1
XFILLER_99_7 VPWR VGND sg13g2_decap_8
XFILLER_72_1227 VPWR VGND sg13g2_decap_8
XFILLER_70_780 VPWR VGND sg13g2_fill_2
XFILLER_72_1238 VPWR VGND sg13g2_fill_1
X_14505_ _14507_/C _22617_/Q _23028_/Q VPWR VGND sg13g2_xor2_1
X_11717_ _11718_/B _23736_/Q _23864_/Q _11723_/S VPWR VGND sg13g2_mux2_1
X_18273_ _18274_/C _18115_/Y _18517_/B _18361_/B _18272_/Y VPWR VGND sg13g2_a22oi_1
X_15485_ _15486_/C _22594_/Q _16441_/A _17234_/A _22757_/Q _15391_/A VPWR VGND sg13g2_a221oi_1
XFILLER_14_195 VPWR VGND sg13g2_decap_8
X_12697_ _12853_/B _12697_/A _12697_/B VPWR VGND sg13g2_xnor2_1
XFILLER_19_1792 VPWR VGND sg13g2_fill_2
X_17224_ _17227_/C _17224_/A _17224_/B VPWR VGND sg13g2_or2_1
XFILLER_50_1514 VPWR VGND sg13g2_decap_8
X_14436_ _14436_/Y _14436_/A _22994_/Q _14436_/C VPWR VGND sg13g2_nor3_1
XFILLER_89_1702 VPWR VGND sg13g2_fill_1
XFILLER_30_699 VPWR VGND sg13g2_fill_2
XFILLER_102_1615 VPWR VGND sg13g2_decap_8
XFILLER_15_1678 VPWR VGND sg13g2_decap_8
X_17155_ _17156_/A _22734_/Q VPWR VGND sg13g2_inv_1
XFILLER_15_1689 VPWR VGND sg13g2_fill_2
XFILLER_102_1648 VPWR VGND sg13g2_decap_4
X_14367_ _14378_/C _15319_/A _16779_/B _15389_/A VPWR VGND sg13g2_o21ai_1
X_11579_ _11579_/Y _22994_/Q _14591_/A _11861_/B VPWR VGND sg13g2_nand3b_1
XFILLER_10_390 VPWR VGND sg13g2_decap_8
X_16106_ _22494_/D _16205_/B _16104_/Y _16105_/Y VPWR VGND sg13g2_o21ai_1
X_13318_ _13318_/X _23723_/Q _23755_/Q _23787_/Q _23819_/Q _13671_/B _13680_/S1 VPWR
+ VGND sg13g2_mux4_1
X_14298_ _14359_/C _15262_/A _15233_/B VPWR VGND sg13g2_nor2b_1
XFILLER_115_259 VPWR VGND sg13g2_decap_8
X_13249_ _13249_/Y _24106_/Q _13253_/S VPWR VGND sg13g2_nand2b_1
XFILLER_97_611 VPWR VGND sg13g2_decap_8
XFILLER_112_922 VPWR VGND sg13g2_decap_4
XFILLER_96_132 VPWR VGND sg13g2_decap_8
XFILLER_26_1741 VPWR VGND sg13g2_decap_8
XFILLER_113_1711 VPWR VGND sg13g2_fill_2
X_17988_ _17988_/Y _18009_/A _18856_/A VPWR VGND sg13g2_nand2b_1
X_19727_ _19727_/X _20162_/A _19803_/B _19727_/S VPWR VGND sg13g2_mux2_1
XFILLER_96_198 VPWR VGND sg13g2_fill_2
X_16939_ _16940_/B _16939_/A _17024_/A _16947_/C VPWR VGND sg13g2_nor3_2
XFILLER_6_1868 VPWR VGND sg13g2_decap_8
XFILLER_22_1627 VPWR VGND sg13g2_fill_1
XFILLER_37_210 VPWR VGND sg13g2_fill_1
XFILLER_61_1676 VPWR VGND sg13g2_decap_4
XFILLER_26_906 VPWR VGND sg13g2_decap_8
XFILLER_65_552 VPWR VGND sg13g2_fill_1
X_19658_ _19658_/Y _20031_/A _19658_/B VPWR VGND sg13g2_nand2_1
XFILLER_65_563 VPWR VGND sg13g2_decap_8
XFILLER_4_1570 VPWR VGND sg13g2_decap_8
XFILLER_26_939 VPWR VGND sg13g2_decap_8
XFILLER_37_276 VPWR VGND sg13g2_fill_2
XFILLER_80_522 VPWR VGND sg13g2_fill_2
X_18609_ _18666_/A _23000_/Q _23001_/Q _18616_/D VPWR VGND sg13g2_nand3_1
XFILLER_80_533 VPWR VGND sg13g2_fill_2
X_19589_ _19589_/Y _19589_/A _19589_/B VPWR VGND sg13g2_nand2_1
XFILLER_0_1445 VPWR VGND sg13g2_fill_2
XFILLER_25_449 VPWR VGND sg13g2_fill_1
XFILLER_53_758 VPWR VGND sg13g2_fill_1
XFILLER_80_555 VPWR VGND sg13g2_decap_8
XFILLER_52_246 VPWR VGND sg13g2_decap_8
X_21620_ _23827_/D _22249_/A0 _23827_/Q _21620_/S VPWR VGND sg13g2_mux2_1
XFILLER_34_972 VPWR VGND sg13g2_decap_4
XFILLER_90_1327 VPWR VGND sg13g2_decap_4
X_21551_ _23793_/D _21617_/A0 _23793_/Q _21554_/S VPWR VGND sg13g2_mux2_1
XFILLER_20_110 VPWR VGND sg13g2_fill_2
Xplace4110 _14438_/C _22990_/Q VPWR VGND sg13g2_buf_1
XFILLER_32_28 VPWR VGND sg13g2_decap_4
Xplace4121 _12788_/A _12778_/A VPWR VGND sg13g2_buf_1
XFILLER_32_39 VPWR VGND sg13g2_fill_1
Xplace4132 _13019_/A _12982_/S1 VPWR VGND sg13g2_buf_4
X_24270_ _24270_/X _24270_/A VPWR VGND sg13g2_buf_1
X_21482_ _23759_/D _23759_/Q _21975_/A0 _21488_/S VPWR VGND sg13g2_mux2_1
Xplace4143 _11708_/B _11792_/S VPWR VGND sg13g2_buf_1
Xplace4154 _13331_/S _13707_/S1 VPWR VGND sg13g2_buf_1
XFILLER_53_1182 VPWR VGND sg13g2_fill_1
Xplace4165 _12004_/S _11815_/S1 VPWR VGND sg13g2_buf_1
Xplace3420 _16470_/B _16456_/B VPWR VGND sg13g2_buf_1
X_23221_ _23221_/Q clkload48/A _23221_/D fanout2754/X VPWR VGND sg13g2_dfrbpq_1
Xplace3431 _17854_/A1 _17523_/A VPWR VGND sg13g2_buf_1
Xplace4176 _13253_/S _12733_/S VPWR VGND sg13g2_buf_2
X_20433_ _23282_/D _22448_/A1 _20434_/S _20432_/Y VPWR VGND sg13g2_o21ai_1
Xplace3442 _17661_/B _17642_/B VPWR VGND sg13g2_buf_1
Xplace4187 _12216_/S _12203_/S VPWR VGND sg13g2_buf_1
XFILLER_88_1234 VPWR VGND sg13g2_fill_2
Xplace3453 _17209_/B _17182_/B VPWR VGND sg13g2_buf_1
XFILLER_10_1008 VPWR VGND sg13g2_decap_4
Xplace4198 _12983_/A _13962_/S0 VPWR VGND sg13g2_buf_1
Xplace3464 _16728_/A _16711_/A VPWR VGND sg13g2_buf_1
XFILLER_107_727 VPWR VGND sg13g2_decap_8
Xplace3475 _16626_/A _16637_/S VPWR VGND sg13g2_buf_1
X_23152_ _23152_/Q clkload14/A _23152_/D fanout2842/X VPWR VGND sg13g2_dfrbpq_1
Xplace3486 _16119_/B _16207_/B VPWR VGND sg13g2_buf_1
Xplace3497 _16946_/S _16921_/S VPWR VGND sg13g2_buf_1
X_22103_ _22103_/Y _22103_/A _22117_/B VPWR VGND sg13g2_nand2_1
X_23083_ _23083_/Q _23215_/CLK _23083_/D fanout2911/X VPWR VGND sg13g2_dfrbpq_1
XFILLER_103_900 VPWR VGND sg13g2_decap_8
XFILLER_88_600 VPWR VGND sg13g2_decap_8
X_20295_ _20296_/D _20295_/A1 _19769_/B _20294_/Y VPWR VGND sg13g2_a21oi_1
XFILLER_66_1543 VPWR VGND sg13g2_fill_1
XFILLER_115_782 VPWR VGND sg13g2_decap_8
X_22034_ _22034_/Y _22034_/A _22045_/B VPWR VGND sg13g2_nand2_1
XFILLER_103_944 VPWR VGND sg13g2_decap_8
XFILLER_102_421 VPWR VGND sg13g2_decap_8
XFILLER_102_432 VPWR VGND sg13g2_fill_2
XFILLER_87_121 VPWR VGND sg13g2_fill_2
XFILLER_66_1598 VPWR VGND sg13g2_fill_2
XFILLER_114_1508 VPWR VGND sg13g2_decap_4
XFILLER_83_1890 VPWR VGND sg13g2_decap_8
XFILLER_5_1301 VPWR VGND sg13g2_decap_8
XFILLER_87_176 VPWR VGND sg13g2_fill_1
XFILLER_112_1210 VPWR VGND sg13g2_fill_2
XFILLER_44_1885 VPWR VGND sg13g2_decap_8
XFILLER_60_1142 VPWR VGND sg13g2_decap_8
XFILLER_102_498 VPWR VGND sg13g2_decap_8
XFILLER_25_1273 VPWR VGND sg13g2_decap_8
X_23985_ _23985_/Q _24113_/CLK _23985_/D fanout2683/X VPWR VGND sg13g2_dfrbpq_1
XFILLER_25_1284 VPWR VGND sg13g2_fill_2
XFILLER_21_1137 VPWR VGND sg13g2_fill_1
XFILLER_113_42 VPWR VGND sg13g2_decap_8
XFILLER_95_1205 VPWR VGND sg13g2_decap_8
XFILLER_44_703 VPWR VGND sg13g2_decap_8
X_22936_ _22936_/Q _22941_/CLK _22936_/D fanout2805/X VPWR VGND sg13g2_dfrbpq_1
XFILLER_56_585 VPWR VGND sg13g2_decap_8
XFILLER_71_511 VPWR VGND sg13g2_decap_4
XFILLER_44_736 VPWR VGND sg13g2_decap_8
XFILLER_16_438 VPWR VGND sg13g2_decap_8
XFILLER_73_46 VPWR VGND sg13g2_fill_1
X_22867_ _22867_/Q clkload8/A _22867_/D fanout2798/X VPWR VGND sg13g2_dfrbpq_1
XFILLER_38_1612 VPWR VGND sg13g2_decap_8
XFILLER_38_1623 VPWR VGND sg13g2_fill_2
XFILLER_58_1071 VPWR VGND sg13g2_decap_4
X_21818_ _21818_/Y _21818_/A _21818_/B VPWR VGND sg13g2_nand2_1
XFILLER_19_1033 VPWR VGND sg13g2_fill_2
XFILLER_25_983 VPWR VGND sg13g2_decap_8
X_22798_ _22798_/Q _22893_/CLK _22798_/D fanout2818/X VPWR VGND sg13g2_dfrbpq_1
XFILLER_12_611 VPWR VGND sg13g2_decap_8
XFILLER_40_920 VPWR VGND sg13g2_decap_8
XFILLER_71_599 VPWR VGND sg13g2_decap_8
X_12551_ _12551_/X _13186_/B _12551_/B _12551_/C _13968_/B VPWR VGND sg13g2_or4_1
X_21749_ _23877_/D _21958_/A1 _21754_/B _21748_/Y VPWR VGND sg13g2_o21ai_1
X_11502_ _13280_/B _11502_/A _11502_/B _11502_/C _11502_/D VPWR VGND sg13g2_nand4_1
X_15270_ _15496_/S _15270_/A _17056_/B VPWR VGND sg13g2_nand2_1
XFILLER_16_1954 VPWR VGND sg13g2_fill_1
XFILLER_11_154 VPWR VGND sg13g2_decap_4
X_12482_ _12489_/A _12774_/B _12482_/B VPWR VGND sg13g2_nor2_1
XFILLER_90_1894 VPWR VGND sg13g2_fill_1
XFILLER_51_1845 VPWR VGND sg13g2_decap_4
XFILLER_103_1924 VPWR VGND sg13g2_decap_8
X_11433_ _11433_/Y _11433_/A _11433_/B _11433_/C _11433_/D VPWR VGND sg13g2_nor4_1
X_23419_ _23419_/Q clkload59/A _23419_/D fanout2788/X VPWR VGND sg13g2_dfrbpq_1
X_14152_ _14152_/X _15216_/B _14152_/B VPWR VGND sg13g2_and2_1
XFILLER_98_21 VPWR VGND sg13g2_decap_8
X_11364_ _11364_/Y _11351_/X _13624_/A _11363_/Y VPWR VGND sg13g2_o21ai_1
XFILLER_113_708 VPWR VGND sg13g2_decap_8
X_13103_ _13103_/X _13778_/A1 _13923_/A2 _22567_/Q VPWR VGND sg13g2_a21o_1
X_18960_ _18960_/Y _23053_/Q _18953_/A _18960_/B1 VPWR VGND sg13g2_o21ai_1
X_14083_ _19331_/A _14083_/A _14102_/C VPWR VGND sg13g2_nand2_1
X_11295_ _11295_/X _11295_/A _11295_/B VPWR VGND sg13g2_and2_1
XFILLER_65_1020 VPWR VGND sg13g2_decap_4
XFILLER_84_1654 VPWR VGND sg13g2_decap_8
XFILLER_79_622 VPWR VGND sg13g2_decap_8
X_17911_ _17913_/A _17911_/A1 _17929_/A2 _17920_/B1 _17192_/A VPWR VGND sg13g2_a22oi_1
X_13034_ _13034_/Y _14653_/D _14653_/B _14653_/C _14653_/A VPWR VGND sg13g2_nor4_2
X_18891_ _18891_/Y _18922_/A _18891_/B _18891_/C VPWR VGND sg13g2_nand3b_1
XFILLER_105_281 VPWR VGND sg13g2_decap_8
XFILLER_80_1518 VPWR VGND sg13g2_fill_1
XFILLER_80_1529 VPWR VGND sg13g2_decap_8
XFILLER_78_132 VPWR VGND sg13g2_decap_8
XFILLER_26_1026 VPWR VGND sg13g2_decap_8
XFILLER_65_1075 VPWR VGND sg13g2_fill_1
XFILLER_79_666 VPWR VGND sg13g2_fill_2
XFILLER_79_677 VPWR VGND sg13g2_fill_2
X_17842_ _17842_/Y _22912_/Q _17853_/B _17849_/C VPWR VGND sg13g2_nand3_1
XFILLER_79_688 VPWR VGND sg13g2_fill_2
XFILLER_67_828 VPWR VGND sg13g2_decap_8
XFILLER_78_165 VPWR VGND sg13g2_decap_4
XFILLER_79_699 VPWR VGND sg13g2_fill_2
XFILLER_43_1340 VPWR VGND sg13g2_fill_1
XFILLER_78_187 VPWR VGND sg13g2_decap_4
XFILLER_66_327 VPWR VGND sg13g2_fill_1
XFILLER_66_338 VPWR VGND sg13g2_fill_2
XFILLER_19_210 VPWR VGND sg13g2_decap_4
XFILLER_23_1947 VPWR VGND sg13g2_decap_8
X_17773_ _17773_/Y _17187_/A _17810_/A2 _17810_/B1 _17772_/Y VPWR VGND sg13g2_a22oi_1
XFILLER_93_135 VPWR VGND sg13g2_decap_8
X_14985_ _14985_/X _22500_/Q _15067_/B _14966_/B VPWR VGND sg13g2_a21o_1
XFILLER_59_390 VPWR VGND sg13g2_fill_1
XFILLER_19_232 VPWR VGND sg13g2_decap_8
X_19512_ _19512_/Y _19512_/A _19512_/B VPWR VGND sg13g2_nor2_1
XFILLER_75_861 VPWR VGND sg13g2_fill_1
X_16724_ _16724_/Y _16728_/A _16724_/B VPWR VGND sg13g2_nor2_1
XFILLER_35_703 VPWR VGND sg13g2_decap_4
X_13936_ _24275_/A _13936_/A VPWR VGND sg13g2_inv_2
XFILLER_47_563 VPWR VGND sg13g2_fill_1
XFILLER_90_820 VPWR VGND sg13g2_fill_2
X_19443_ _19443_/Y _19443_/A _19443_/B VPWR VGND sg13g2_nand2_1
XFILLER_34_213 VPWR VGND sg13g2_decap_8
XFILLER_35_747 VPWR VGND sg13g2_fill_2
X_16655_ _16656_/B _22646_/Q _16655_/B VPWR VGND sg13g2_xnor2_1
XFILLER_95_1750 VPWR VGND sg13g2_fill_2
XFILLER_90_853 VPWR VGND sg13g2_decap_8
X_13867_ _13867_/Y _14104_/A _13867_/B _13867_/C VPWR VGND sg13g2_nor3_1
XFILLER_62_555 VPWR VGND sg13g2_decap_8
XFILLER_1_1776 VPWR VGND sg13g2_decap_8
XFILLER_22_408 VPWR VGND sg13g2_decap_8
X_15606_ _20015_/A _15606_/A _15606_/B _15606_/C _15606_/D VPWR VGND sg13g2_nand4_1
X_19374_ _19375_/B _15884_/A _19576_/B _19373_/Y VPWR VGND sg13g2_o21ai_1
X_12818_ _12818_/X _23780_/Q _23812_/Q _23940_/Q _23972_/Q _12819_/S0 _12906_/A VPWR
+ VGND sg13g2_mux4_1
XFILLER_108_1813 VPWR VGND sg13g2_decap_8
X_16586_ _16587_/B _22632_/Q _16586_/B VPWR VGND sg13g2_xnor2_1
X_13798_ _13798_/Y _23921_/Q _13798_/A2 _13797_/X _13798_/B2 VPWR VGND sg13g2_a22oi_1
XFILLER_15_471 VPWR VGND sg13g2_decap_4
X_18325_ _18325_/Y _18332_/A _18370_/B _18421_/A VPWR VGND sg13g2_a21oi_1
XFILLER_72_1068 VPWR VGND sg13g2_fill_2
XFILLER_8_30 VPWR VGND sg13g2_decap_4
XFILLER_30_452 VPWR VGND sg13g2_decap_8
X_18256_ _18256_/Y _18476_/B _18260_/A _18103_/B VPWR VGND sg13g2_o21ai_1
X_15468_ _15470_/A _19373_/A _15335_/B _15467_/Y VPWR VGND sg13g2_a21oi_1
XFILLER_30_1907 VPWR VGND sg13g2_decap_4
X_17207_ _17208_/B _17218_/A _17218_/B _17207_/C VPWR VGND sg13g2_nor3_1
XFILLER_11_1306 VPWR VGND sg13g2_fill_1
X_14419_ _14419_/Y _23030_/Q _23031_/Q _22996_/Q VPWR VGND sg13g2_a21oi_1
XFILLER_15_1475 VPWR VGND sg13g2_decap_4
X_18187_ _18322_/C _18187_/A _18187_/B VPWR VGND sg13g2_nand2_1
X_15399_ _15404_/B _15399_/A _15399_/B VPWR VGND sg13g2_nand2_1
XFILLER_102_1445 VPWR VGND sg13g2_decap_4
XFILLER_89_1554 VPWR VGND sg13g2_fill_1
X_17069_ _17069_/Y _22719_/Q _17069_/B VPWR VGND sg13g2_xnor2_1
XFILLER_100_1180 VPWR VGND sg13g2_decap_8
XFILLER_40_0 VPWR VGND sg13g2_decap_8
XFILLER_103_229 VPWR VGND sg13g2_decap_8
X_20080_ _20080_/Y _20080_/A _20080_/B VPWR VGND sg13g2_nand2_1
XFILLER_98_942 VPWR VGND sg13g2_decap_4
XFILLER_44_1126 VPWR VGND sg13g2_fill_1
XFILLER_83_1186 VPWR VGND sg13g2_decap_8
XFILLER_112_796 VPWR VGND sg13g2_decap_8
XFILLER_84_102 VPWR VGND sg13g2_decap_8
XFILLER_69_187 VPWR VGND sg13g2_fill_2
XFILLER_61_1462 VPWR VGND sg13g2_fill_1
XFILLER_113_1541 VPWR VGND sg13g2_fill_2
XFILLER_38_552 VPWR VGND sg13g2_decap_8
X_23770_ _23770_/Q clkload58/A _23770_/D fanout2762/X VPWR VGND sg13g2_dfrbpq_1
XFILLER_96_1514 VPWR VGND sg13g2_decap_8
X_20982_ _23535_/D _21346_/A0 _23535_/Q _20989_/S VPWR VGND sg13g2_mux2_1
XFILLER_93_680 VPWR VGND sg13g2_decap_8
XFILLER_53_522 VPWR VGND sg13g2_decap_4
X_22721_ _22721_/Q clkload23/A _22721_/D fanout2887/X VPWR VGND sg13g2_dfrbpq_1
XFILLER_81_842 VPWR VGND sg13g2_decap_4
X_22652_ _22652_/Q clkload25/A _22652_/D fanout2888/X VPWR VGND sg13g2_dfrbpq_1
XFILLER_41_717 VPWR VGND sg13g2_fill_1
XFILLER_39_1954 VPWR VGND sg13g2_fill_1
XFILLER_41_728 VPWR VGND sg13g2_decap_8
XFILLER_53_588 VPWR VGND sg13g2_decap_8
XFILLER_94_1282 VPWR VGND sg13g2_decap_8
X_21603_ _23816_/D _21898_/A0 _23816_/Q _21620_/S VPWR VGND sg13g2_mux2_1
XFILLER_35_1818 VPWR VGND sg13g2_decap_8
XFILLER_40_227 VPWR VGND sg13g2_decap_8
XFILLER_70_1709 VPWR VGND sg13g2_fill_1
XFILLER_22_953 VPWR VGND sg13g2_decap_8
X_22583_ _22583_/Q clkload19/A _22583_/D fanout2873/X VPWR VGND sg13g2_dfrbpq_1
XFILLER_22_964 VPWR VGND sg13g2_fill_2
X_21534_ _21534_/Y _21534_/A _21534_/B VPWR VGND sg13g2_nand2_1
XFILLER_107_1389 VPWR VGND sg13g2_decap_8
X_24253_ _24253_/X _24253_/A VPWR VGND sg13g2_buf_1
X_21465_ _21465_/Y _21465_/A _21473_/B VPWR VGND sg13g2_nand2_1
Xplace3250 _21151_/B _21138_/B VPWR VGND sg13g2_buf_1
XFILLER_107_513 VPWR VGND sg13g2_decap_8
X_23204_ _23204_/Q clkload35/A _23204_/D fanout2933/X VPWR VGND sg13g2_dfrbpq_1
Xplace3261 _21619_/A1 _21980_/A1 VPWR VGND sg13g2_buf_1
Xplace3272 _20702_/A1 _20237_/Y VPWR VGND sg13g2_buf_1
X_24184_ _24184_/Q clkload56/A _24184_/D fanout2752/X VPWR VGND sg13g2_dfrbpq_1
Xplace3283 _22296_/A1 _20156_/Y VPWR VGND sg13g2_buf_1
X_21396_ _21396_/Y _21396_/A _21398_/B VPWR VGND sg13g2_nand2_1
XFILLER_88_1064 VPWR VGND sg13g2_decap_8
Xplace3294 _22284_/A1 _20022_/Y VPWR VGND sg13g2_buf_1
XFILLER_49_1026 VPWR VGND sg13g2_decap_8
X_23135_ _23135_/Q clkload5/A _23135_/D fanout2834/X VPWR VGND sg13g2_dfrbpq_1
XFILLER_108_42 VPWR VGND sg13g2_decap_8
XFILLER_11_1895 VPWR VGND sg13g2_decap_8
X_23066_ _23066_/Q clkload14/A _23066_/D fanout2903/X VPWR VGND sg13g2_dfrbpq_1
X_20278_ _20278_/X _20278_/A0 _20278_/A1 _20278_/A2 _20278_/A3 _19505_/A _19514_/A
+ VPWR VGND sg13g2_mux4_1
XFILLER_81_1838 VPWR VGND sg13g2_fill_2
XFILLER_27_1335 VPWR VGND sg13g2_decap_8
XFILLER_103_752 VPWR VGND sg13g2_decap_8
XFILLER_88_441 VPWR VGND sg13g2_fill_1
XFILLER_88_452 VPWR VGND sg13g2_decap_8
X_22017_ _22017_/Y _22017_/A _22017_/B VPWR VGND sg13g2_nand2_1
XFILLER_89_986 VPWR VGND sg13g2_decap_8
XFILLER_0_389 VPWR VGND sg13g2_decap_4
XFILLER_44_1660 VPWR VGND sg13g2_decap_8
XFILLER_48_327 VPWR VGND sg13g2_fill_1
XFILLER_102_295 VPWR VGND sg13g2_fill_2
XFILLER_5_1131 VPWR VGND sg13g2_fill_1
XFILLER_40_1535 VPWR VGND sg13g2_fill_1
XFILLER_57_850 VPWR VGND sg13g2_decap_8
XFILLER_91_617 VPWR VGND sg13g2_fill_1
X_14770_ _14792_/B _24219_/Q _14770_/B _14786_/B VPWR VGND sg13g2_nand3_1
X_11982_ _11982_/Y _11734_/A _11734_/B _11877_/A _11877_/B _11646_/X VPWR VGND sg13g2_a221oi_1
X_23968_ _23968_/Q clkload43/A _23968_/D fanout2734/X VPWR VGND sg13g2_dfrbpq_1
XFILLER_56_371 VPWR VGND sg13g2_decap_8
X_13721_ _13753_/A _20292_/A _13721_/B VPWR VGND sg13g2_xor2_1
Xclkbuf_4_1__f_clk_i clkbuf_leaf_4_clk_i/A clkbuf_3_0_0_clk_i/X VPWR VGND sg13g2_buf_8
X_22919_ _22919_/Q clkload18/A _22919_/D fanout2827/X VPWR VGND sg13g2_dfrbpq_1
XFILLER_83_190 VPWR VGND sg13g2_fill_2
X_23899_ _23899_/Q clkload48/A _23899_/D fanout2755/X VPWR VGND sg13g2_dfrbpq_1
X_16440_ _22586_/D _16879_/A _22586_/Q _16440_/S VPWR VGND sg13g2_mux2_1
XFILLER_32_717 VPWR VGND sg13g2_decap_8
XFILLER_73_1300 VPWR VGND sg13g2_fill_2
XFILLER_31_205 VPWR VGND sg13g2_decap_8
XFILLER_25_780 VPWR VGND sg13g2_decap_8
X_12603_ _12603_/X _23585_/Q _23617_/Q _23649_/Q _23681_/Q _13006_/S0 _13006_/S1 VPWR
+ VGND sg13g2_mux4_1
XFILLER_38_1464 VPWR VGND sg13g2_decap_8
X_16371_ _22548_/D _16371_/A VPWR VGND sg13g2_inv_1
XFILLER_9_902 VPWR VGND sg13g2_decap_4
X_13583_ _13583_/Y _23694_/Q _13676_/B VPWR VGND sg13g2_nand2b_1
XFILLER_13_975 VPWR VGND sg13g2_decap_8
X_15322_ _15331_/A _15322_/A _15322_/B _15322_/C _15322_/D VPWR VGND sg13g2_nand4_1
X_12534_ _12535_/C _14387_/B _19351_/A VPWR VGND sg13g2_nand2b_1
XFILLER_9_946 VPWR VGND sg13g2_decap_8
XFILLER_51_1642 VPWR VGND sg13g2_fill_2
X_18041_ _18254_/A _18039_/X _18040_/X _18491_/A VPWR VGND sg13g2_mux2_1
XFILLER_32_1052 VPWR VGND sg13g2_decap_4
XFILLER_51_1686 VPWR VGND sg13g2_fill_1
XFILLER_8_489 VPWR VGND sg13g2_decap_4
X_14204_ _14206_/A _14204_/A _22829_/Q VPWR VGND sg13g2_nand2_1
X_11416_ _11416_/Y _23670_/Q _11416_/B VPWR VGND sg13g2_nand2b_1
XFILLER_86_1716 VPWR VGND sg13g2_fill_1
X_12396_ _12397_/B _23295_/Q _23327_/Q _23359_/Q _23391_/Q _12819_/S0 _13983_/S1 VPWR
+ VGND sg13g2_mux4_1
XFILLER_113_505 VPWR VGND sg13g2_decap_8
X_19992_ _19993_/B _20284_/A1 _20284_/A3 _20284_/A0 _20284_/A2 _20019_/S0 _20072_/S1
+ VPWR VGND sg13g2_mux4_1
XFILLER_10_1394 VPWR VGND sg13g2_decap_4
X_18943_ _18944_/B _18942_/Y _23052_/Q _18956_/B VPWR VGND sg13g2_mux2_1
X_14066_ _17041_/B _14430_/A _14430_/B _14430_/C VPWR VGND sg13g2_or3_1
XFILLER_49_1593 VPWR VGND sg13g2_decap_8
XFILLER_3_194 VPWR VGND sg13g2_fill_1
XFILLER_45_1435 VPWR VGND sg13g2_decap_4
X_13017_ _13017_/Y _23911_/Q _14147_/C _13016_/X _13707_/S0 VPWR VGND sg13g2_a22oi_1
X_18874_ _18875_/B _18873_/Y _23046_/Q _18889_/B VPWR VGND sg13g2_mux2_1
XFILLER_67_614 VPWR VGND sg13g2_decap_8
XFILLER_67_625 VPWR VGND sg13g2_fill_1
XFILLER_39_327 VPWR VGND sg13g2_decap_4
X_17825_ _17825_/Y _22909_/Q _17825_/B VPWR VGND sg13g2_nor2_1
XFILLER_94_433 VPWR VGND sg13g2_fill_2
XFILLER_94_455 VPWR VGND sg13g2_decap_4
XFILLER_110_1703 VPWR VGND sg13g2_fill_1
XFILLER_82_606 VPWR VGND sg13g2_decap_4
XFILLER_3_1827 VPWR VGND sg13g2_decap_8
XFILLER_66_157 VPWR VGND sg13g2_decap_8
XFILLER_82_628 VPWR VGND sg13g2_decap_8
X_14968_ _14969_/D _22467_/Q _15006_/B _15066_/B1 _22926_/Q VPWR VGND sg13g2_a22oi_1
XFILLER_47_371 VPWR VGND sg13g2_decap_4
XFILLER_48_894 VPWR VGND sg13g2_fill_2
X_16707_ _16707_/Y _16707_/A _16707_/B VPWR VGND sg13g2_nor2_1
X_13919_ _13919_/X _23731_/Q _23763_/Q _23795_/Q _23827_/Q _13919_/S0 _13919_/S1 VPWR
+ VGND sg13g2_mux4_1
XFILLER_35_533 VPWR VGND sg13g2_decap_8
XFILLER_97_1878 VPWR VGND sg13g2_fill_1
XFILLER_1_1540 VPWR VGND sg13g2_decap_8
X_17687_ _17687_/Y _17687_/A _22962_/Q VPWR VGND sg13g2_nand2_1
X_14899_ _16262_/A _14899_/A _14899_/B VPWR VGND sg13g2_or2_1
XFILLER_62_341 VPWR VGND sg13g2_fill_2
X_19426_ _19652_/B _19422_/Y _19425_/Y _19573_/S VPWR VGND sg13g2_mux2_1
XFILLER_78_1299 VPWR VGND sg13g2_decap_4
X_16638_ _16648_/C _22642_/Q _16638_/B _16638_/C VPWR VGND sg13g2_and3_1
XFILLER_35_588 VPWR VGND sg13g2_decap_4
X_19357_ _19357_/Y _15785_/A _19448_/B _19356_/Y VPWR VGND sg13g2_a21oi_1
X_16569_ _22628_/D _17098_/A _16678_/S _16568_/Y VPWR VGND sg13g2_a21oi_1
XFILLER_91_1455 VPWR VGND sg13g2_decap_8
X_18308_ _18308_/Y _18562_/C _18308_/B VPWR VGND sg13g2_nor2_1
XFILLER_17_1559 VPWR VGND sg13g2_fill_1
XFILLER_108_1687 VPWR VGND sg13g2_decap_4
XFILLER_104_1518 VPWR VGND sg13g2_fill_1
X_19288_ _23206_/D _23206_/Q _20255_/A3 _19299_/S VPWR VGND sg13g2_mux2_1
X_18239_ _18239_/Y _18236_/Y _18239_/B _18239_/C VPWR VGND sg13g2_nand3b_1
XFILLER_30_1726 VPWR VGND sg13g2_fill_2
X_21250_ _21250_/Y _23647_/Q _21271_/B VPWR VGND sg13g2_nand2_1
XFILLER_69_1925 VPWR VGND sg13g2_decap_8
XFILLER_102_1264 VPWR VGND sg13g2_fill_1
XFILLER_85_1204 VPWR VGND sg13g2_decap_8
X_20201_ _20202_/B _20200_/Y _20201_/B VPWR VGND sg13g2_nand2b_1
XFILLER_104_505 VPWR VGND sg13g2_decap_8
XFILLER_102_1297 VPWR VGND sg13g2_decap_4
X_20132_ _20132_/Y _20132_/A _20304_/B VPWR VGND sg13g2_nand2_1
XFILLER_86_912 VPWR VGND sg13g2_decap_8
X_20063_ _20063_/Y _20063_/A _20064_/B VPWR VGND sg13g2_nor2_1
XFILLER_24_1508 VPWR VGND sg13g2_decap_8
XFILLER_63_1557 VPWR VGND sg13g2_decap_8
XFILLER_58_636 VPWR VGND sg13g2_decap_4
XFILLER_112_593 VPWR VGND sg13g2_decap_8
XFILLER_85_422 VPWR VGND sg13g2_decap_8
XFILLER_100_744 VPWR VGND sg13g2_fill_1
XFILLER_86_967 VPWR VGND sg13g2_decap_8
XFILLER_22_1221 VPWR VGND sg13g2_fill_2
XFILLER_73_606 VPWR VGND sg13g2_decap_8
XFILLER_85_477 VPWR VGND sg13g2_decap_8
X_23822_ _23822_/Q clkload49/A _23822_/D fanout2744/X VPWR VGND sg13g2_dfrbpq_1
XFILLER_85_488 VPWR VGND sg13g2_fill_1
XFILLER_22_1287 VPWR VGND sg13g2_decap_4
X_23753_ _23753_/Q _24113_/CLK _23753_/D fanout2684/X VPWR VGND sg13g2_dfrbpq_1
X_20965_ _23527_/D _21333_/A1 _20983_/B _20964_/Y VPWR VGND sg13g2_o21ai_1
XFILLER_54_853 VPWR VGND sg13g2_fill_2
XFILLER_54_59 VPWR VGND sg13g2_fill_2
XFILLER_96_1388 VPWR VGND sg13g2_decap_8
XFILLER_14_717 VPWR VGND sg13g2_decap_4
X_22704_ _22704_/Q clkload19/A _22704_/D fanout2864/X VPWR VGND sg13g2_dfrbpq_1
XFILLER_81_683 VPWR VGND sg13g2_fill_1
XFILLER_0_1061 VPWR VGND sg13g2_fill_2
X_20896_ _20896_/Y _20896_/A _20896_/B VPWR VGND sg13g2_nand2_1
X_23684_ _23684_/Q clkload41/A _23684_/D fanout2702/X VPWR VGND sg13g2_dfrbpq_1
XFILLER_110_21 VPWR VGND sg13g2_decap_8
X_22635_ _22635_/Q _22733_/CLK _22635_/D fanout2879/X VPWR VGND sg13g2_dfrbpq_1
XFILLER_55_1041 VPWR VGND sg13g2_fill_1
XFILLER_107_1120 VPWR VGND sg13g2_fill_1
XFILLER_107_1131 VPWR VGND sg13g2_decap_8
XFILLER_16_1014 VPWR VGND sg13g2_decap_8
XFILLER_70_14 VPWR VGND sg13g2_decap_8
XFILLER_10_901 VPWR VGND sg13g2_fill_1
XFILLER_35_1648 VPWR VGND sg13g2_fill_2
X_22566_ _22566_/Q _23029_/CLK _22566_/D fanout2836/X VPWR VGND sg13g2_dfrbpq_1
XFILLER_110_98 VPWR VGND sg13g2_decap_8
XFILLER_21_260 VPWR VGND sg13g2_decap_8
XFILLER_13_1913 VPWR VGND sg13g2_decap_8
XFILLER_21_282 VPWR VGND sg13g2_decap_8
XFILLER_10_967 VPWR VGND sg13g2_decap_8
Xclkbuf_leaf_6_clk_i clkload18/A clkbuf_leaf_6_clk_i/A VPWR VGND sg13g2_buf_16
X_22497_ _22497_/Q clkload9/A _22497_/D fanout2824/X VPWR VGND sg13g2_dfrbpq_1
X_12250_ _12256_/C _12250_/A _12250_/B _12250_/C _12250_/D VPWR VGND sg13g2_nor4_1
X_21448_ _23742_/D _21943_/A1 _21447_/B _21447_/Y VPWR VGND sg13g2_o21ai_1
X_24236_ _24236_/Q clkload15/A _24236_/D fanout2853/X VPWR VGND sg13g2_dfrbpq_1
Xplace3080 _21605_/B _21600_/B VPWR VGND sg13g2_buf_1
Xplace3091 _21447_/B _21441_/B VPWR VGND sg13g2_buf_1
XFILLER_79_23 VPWR VGND sg13g2_decap_8
X_12181_ _12435_/A _12181_/A _19861_/A VPWR VGND sg13g2_xnor2_1
X_24167_ _24167_/Q clkload38/A _24167_/D fanout2630/X VPWR VGND sg13g2_dfrbpq_1
XFILLER_107_365 VPWR VGND sg13g2_decap_8
X_21379_ _23709_/D _21941_/A1 _21380_/B _21378_/Y VPWR VGND sg13g2_o21ai_1
XFILLER_68_1457 VPWR VGND sg13g2_decap_8
XFILLER_46_1700 VPWR VGND sg13g2_decap_8
XFILLER_68_1479 VPWR VGND sg13g2_decap_8
X_23118_ _23118_/Q _23215_/CLK _23118_/D fanout2925/X VPWR VGND sg13g2_dfrbpq_1
XFILLER_1_632 VPWR VGND sg13g2_fill_1
X_24098_ _24098_/Q clkload43/A _24098_/D fanout2733/X VPWR VGND sg13g2_dfrbpq_1
XFILLER_89_750 VPWR VGND sg13g2_decap_8
XFILLER_110_508 VPWR VGND sg13g2_decap_8
XFILLER_81_1635 VPWR VGND sg13g2_fill_2
XFILLER_7_1204 VPWR VGND sg13g2_fill_1
X_23049_ _23049_/Q clkload12/A _23049_/D fanout2912/X VPWR VGND sg13g2_dfrbpq_1
X_15940_ _15941_/D _22778_/Q _15940_/B VPWR VGND sg13g2_nand2_1
XFILLER_49_625 VPWR VGND sg13g2_decap_8
XFILLER_81_1679 VPWR VGND sg13g2_decap_4
XFILLER_7_1248 VPWR VGND sg13g2_decap_8
X_15871_ _15874_/B _22507_/Q _15893_/A2 _15893_/B1 _14205_/A VPWR VGND sg13g2_a22oi_1
XFILLER_0_197 VPWR VGND sg13g2_decap_4
XFILLER_40_1310 VPWR VGND sg13g2_decap_8
XFILLER_62_1089 VPWR VGND sg13g2_fill_2
X_17610_ _17610_/Y _22884_/Q _17652_/B VPWR VGND sg13g2_nor2_1
X_14822_ _14822_/Y _22515_/Q _16244_/B VPWR VGND sg13g2_nand2_1
XFILLER_36_308 VPWR VGND sg13g2_decap_4
XFILLER_40_1343 VPWR VGND sg13g2_fill_1
XFILLER_57_680 VPWR VGND sg13g2_decap_4
XFILLER_91_458 VPWR VGND sg13g2_decap_4
X_14753_ _14854_/B _22910_/Q _22911_/Q VPWR VGND sg13g2_nor2_1
XFILLER_17_544 VPWR VGND sg13g2_fill_1
XFILLER_17_555 VPWR VGND sg13g2_decap_8
XFILLER_44_352 VPWR VGND sg13g2_decap_8
X_13704_ _13704_/X _23312_/Q _23344_/Q _23376_/Q _23408_/Q _13840_/S0 _13707_/S1 VPWR
+ VGND sg13g2_mux4_1
X_17472_ _22853_/D _16109_/A _17507_/S _17471_/Y VPWR VGND sg13g2_o21ai_1
XFILLER_72_672 VPWR VGND sg13g2_fill_2
XFILLER_92_1720 VPWR VGND sg13g2_fill_2
X_14684_ _14684_/X _14681_/X _14683_/Y _14728_/S VPWR VGND sg13g2_mux2_1
XFILLER_32_525 VPWR VGND sg13g2_decap_8
XFILLER_44_385 VPWR VGND sg13g2_decap_8
XFILLER_92_1742 VPWR VGND sg13g2_decap_8
X_19211_ _23168_/D _19211_/A0 _23168_/Q _19221_/S VPWR VGND sg13g2_mux2_1
XFILLER_44_396 VPWR VGND sg13g2_fill_1
X_16423_ _16424_/B _22579_/Q _18623_/A VPWR VGND sg13g2_nand2_1
X_13635_ _13636_/B _23311_/Q _23343_/Q _23375_/Q _23407_/Q _13635_/S0 _13635_/S1 VPWR
+ VGND sg13g2_mux4_1
XFILLER_38_1250 VPWR VGND sg13g2_decap_8
X_19142_ _23118_/D _23118_/Q _18962_/A _19149_/S VPWR VGND sg13g2_mux2_1
XFILLER_53_1748 VPWR VGND sg13g2_fill_2
X_16354_ _16356_/A _16351_/Y _16352_/X _16353_/Y VPWR VGND sg13g2_a21oi_1
X_13566_ _13567_/B _13562_/X _13563_/X _13564_/X _13565_/X _13560_/S _13706_/S VPWR
+ VGND sg13g2_mux4_1
XFILLER_105_1849 VPWR VGND sg13g2_decap_8
XFILLER_40_591 VPWR VGND sg13g2_fill_1
X_12517_ _12542_/A _12352_/A _12352_/B _12515_/Y _12516_/X VPWR VGND sg13g2_a22oi_1
XFILLER_16_1570 VPWR VGND sg13g2_decap_8
X_19073_ _19073_/X _19128_/A1 _23105_/Q _19085_/S VPWR VGND sg13g2_mux2_1
XFILLER_9_776 VPWR VGND sg13g2_decap_8
X_16285_ _16286_/B _16285_/A _16285_/B VPWR VGND sg13g2_nor2_1
X_13497_ _20243_/B _11993_/A _13494_/X _13496_/Y VPWR VGND sg13g2_a21o_2
XFILLER_8_264 VPWR VGND sg13g2_decap_4
X_18024_ _18024_/Y _18029_/S _18024_/B VPWR VGND sg13g2_nand2b_1
XFILLER_51_1483 VPWR VGND sg13g2_fill_2
X_15236_ _15261_/A _15319_/C _15236_/B VPWR VGND sg13g2_nor2_1
XFILLER_12_1445 VPWR VGND sg13g2_decap_8
XFILLER_60_80 VPWR VGND sg13g2_decap_8
X_12448_ _12449_/B _23296_/Q _23328_/Q _23360_/Q _23392_/Q _12819_/S0 _12816_/A VPWR
+ VGND sg13g2_mux4_1
XFILLER_99_503 VPWR VGND sg13g2_decap_8
XFILLER_99_514 VPWR VGND sg13g2_fill_1
X_12379_ _12385_/C _12379_/A _12379_/B _12379_/C _12379_/D VPWR VGND sg13g2_nor4_2
X_14118_ _14119_/C _14118_/A _14118_/B _14118_/C VPWR VGND sg13g2_nand3_1
XFILLER_114_858 VPWR VGND sg13g2_decap_8
XFILLER_99_558 VPWR VGND sg13g2_decap_8
XFILLER_10_1191 VPWR VGND sg13g2_fill_1
X_15098_ _18748_/A _15098_/A _15098_/B VPWR VGND sg13g2_nor2_1
X_19975_ _19975_/Y _23231_/Q _20052_/B VPWR VGND sg13g2_nand2_1
XFILLER_68_912 VPWR VGND sg13g2_decap_8
X_14049_ _14051_/C _14049_/A _14049_/B _14049_/C _14049_/D VPWR VGND sg13g2_nor4_1
XFILLER_84_1292 VPWR VGND sg13g2_fill_1
XFILLER_80_1123 VPWR VGND sg13g2_fill_1
X_18926_ _18926_/Y _18926_/A _23082_/Q _18959_/C VPWR VGND sg13g2_nand3_1
XFILLER_95_742 VPWR VGND sg13g2_decap_4
X_18857_ _18858_/C _18855_/Y _18856_/Y _18857_/S VPWR VGND sg13g2_mux2_1
XFILLER_45_1298 VPWR VGND sg13g2_decap_8
XFILLER_83_904 VPWR VGND sg13g2_decap_8
XFILLER_67_455 VPWR VGND sg13g2_fill_2
XFILLER_7_1771 VPWR VGND sg13g2_decap_8
XFILLER_55_606 VPWR VGND sg13g2_decap_4
XFILLER_94_252 VPWR VGND sg13g2_fill_2
X_17808_ _17808_/Y _23185_/Q _17822_/A2 _17815_/B1 _22993_/Q VPWR VGND sg13g2_a22oi_1
X_18788_ _23032_/D _18788_/A _18788_/B _18788_/C VPWR VGND sg13g2_nand3_1
XFILLER_114_1691 VPWR VGND sg13g2_decap_4
XFILLER_110_1533 VPWR VGND sg13g2_decap_8
XFILLER_97_1642 VPWR VGND sg13g2_fill_1
X_17739_ _17754_/C _17739_/A _17739_/B VPWR VGND sg13g2_nor2_1
XFILLER_110_1555 VPWR VGND sg13g2_decap_8
X_20750_ _23425_/D _21321_/A1 _20751_/B _20749_/Y VPWR VGND sg13g2_o21ai_1
XFILLER_1_1370 VPWR VGND sg13g2_decap_4
XFILLER_50_300 VPWR VGND sg13g2_decap_8
XFILLER_63_694 VPWR VGND sg13g2_fill_1
XFILLER_51_845 VPWR VGND sg13g2_decap_4
X_19409_ _19410_/A _19406_/Y _19408_/Y _19573_/S VPWR VGND sg13g2_mux2_1
XFILLER_23_558 VPWR VGND sg13g2_decap_8
X_20681_ _23393_/D _22416_/A1 _20682_/B _20680_/Y VPWR VGND sg13g2_o21ai_1
XFILLER_91_1241 VPWR VGND sg13g2_fill_2
XFILLER_11_709 VPWR VGND sg13g2_decap_8
XFILLER_51_889 VPWR VGND sg13g2_decap_4
X_22420_ _22420_/Y _24195_/Q _22434_/B VPWR VGND sg13g2_nand2_1
XFILLER_50_366 VPWR VGND sg13g2_decap_8
XFILLER_91_1274 VPWR VGND sg13g2_decap_8
XFILLER_50_377 VPWR VGND sg13g2_fill_1
XFILLER_17_1367 VPWR VGND sg13g2_fill_1
XFILLER_52_1247 VPWR VGND sg13g2_decap_8
XFILLER_109_608 VPWR VGND sg13g2_decap_8
XFILLER_31_591 VPWR VGND sg13g2_decap_8
XFILLER_52_1258 VPWR VGND sg13g2_fill_2
X_22351_ _24162_/D _20049_/Y _22350_/B _22350_/Y VPWR VGND sg13g2_o21ai_1
Xoutput4530 data_wdata_o[5] _14674_/X VPWR VGND sg13g2_buf_1
Xoutput4541 instr_addr_o[15] _14964_/Y VPWR VGND sg13g2_buf_1
X_21302_ _21302_/Y _21302_/A _21313_/B VPWR VGND sg13g2_nand2_1
Xoutput4552 instr_addr_o[26] _15074_/Y VPWR VGND sg13g2_buf_1
XFILLER_34_1692 VPWR VGND sg13g2_decap_8
XFILLER_69_1700 VPWR VGND sg13g2_decap_8
Xoutput4563 instr_addr_o[7] _14878_/X VPWR VGND sg13g2_buf_1
X_22282_ _24128_/D _22282_/A1 _22285_/B _22281_/Y VPWR VGND sg13g2_o21ai_1
X_24021_ _24021_/Q clkload47/A _24021_/D fanout2680/X VPWR VGND sg13g2_dfrbpq_1
X_21233_ _23639_/D _21299_/A1 _21234_/B _21232_/Y VPWR VGND sg13g2_o21ai_1
XFILLER_105_847 VPWR VGND sg13g2_decap_4
XFILLER_105_858 VPWR VGND sg13g2_fill_1
X_21164_ _21164_/Y _21164_/A _21215_/B VPWR VGND sg13g2_nand2_1
X_20115_ _20116_/B _20162_/A _20117_/B _20114_/Y VPWR VGND sg13g2_a21oi_1
X_21095_ _21095_/Y _21095_/A _21108_/B VPWR VGND sg13g2_nand2_1
XFILLER_28_1463 VPWR VGND sg13g2_decap_8
XFILLER_24_1305 VPWR VGND sg13g2_decap_4
XFILLER_28_1474 VPWR VGND sg13g2_fill_2
XFILLER_58_411 VPWR VGND sg13g2_decap_8
XFILLER_98_580 VPWR VGND sg13g2_decap_8
XFILLER_28_1485 VPWR VGND sg13g2_decap_8
XFILLER_63_1365 VPWR VGND sg13g2_decap_8
XFILLER_105_21 VPWR VGND sg13g2_decap_8
XFILLER_58_422 VPWR VGND sg13g2_fill_2
XFILLER_86_742 VPWR VGND sg13g2_decap_8
X_20046_ _20047_/A _20316_/A1 _23210_/Q _23218_/Q _20316_/A2 _20224_/A _20316_/S0
+ VPWR VGND sg13g2_mux4_1
XFILLER_115_1455 VPWR VGND sg13g2_decap_8
XFILLER_73_403 VPWR VGND sg13g2_decap_4
XFILLER_100_574 VPWR VGND sg13g2_decap_8
XFILLER_98_1439 VPWR VGND sg13g2_fill_1
XFILLER_45_105 VPWR VGND sg13g2_decap_8
XFILLER_105_98 VPWR VGND sg13g2_decap_8
X_23805_ _23805_/Q clkload59/A _23805_/D fanout2784/X VPWR VGND sg13g2_dfrbpq_1
XFILLER_27_853 VPWR VGND sg13g2_fill_2
XFILLER_61_609 VPWR VGND sg13g2_decap_8
X_21997_ _21997_/Y _21997_/A _22003_/B VPWR VGND sg13g2_nand2_1
XFILLER_54_650 VPWR VGND sg13g2_decap_8
XFILLER_42_801 VPWR VGND sg13g2_fill_2
XFILLER_27_886 VPWR VGND sg13g2_decap_8
X_23736_ _23736_/Q clkload52/A _23736_/D fanout2688/X VPWR VGND sg13g2_dfrbpq_1
X_11750_ _11750_/Y _11750_/A _11750_/B VPWR VGND sg13g2_nor2_1
X_20948_ _20948_/Y _23519_/Q _20954_/B VPWR VGND sg13g2_nand2_1
XFILLER_57_1136 VPWR VGND sg13g2_decap_4
XFILLER_81_35 VPWR VGND sg13g2_fill_2
XFILLER_14_547 VPWR VGND sg13g2_decap_8
X_23667_ _23667_/Q clkload51/A _23667_/D fanout2664/X VPWR VGND sg13g2_dfrbpq_1
X_11681_ _11681_/Y _11681_/A _11501_/B VPWR VGND sg13g2_nor2b_2
X_20879_ _20879_/Y _20879_/A _20879_/B VPWR VGND sg13g2_nand2_1
XFILLER_39_1581 VPWR VGND sg13g2_decap_8
XFILLER_41_355 VPWR VGND sg13g2_fill_1
XFILLER_41_366 VPWR VGND sg13g2_fill_1
XFILLER_70_1303 VPWR VGND sg13g2_decap_4
X_13420_ _13420_/Y _24140_/Q _13589_/B VPWR VGND sg13g2_nand2b_1
X_22618_ _22618_/Q clkload19/A _22618_/D fanout2870/X VPWR VGND sg13g2_dfrbpq_1
XFILLER_35_1456 VPWR VGND sg13g2_fill_2
X_23598_ _23598_/Q clkload36/A _23598_/D fanout2641/X VPWR VGND sg13g2_dfrbpq_1
XFILLER_70_1347 VPWR VGND sg13g2_fill_2
XFILLER_31_1309 VPWR VGND sg13g2_fill_1
X_13351_ _20208_/B _13383_/A _13345_/Y _13349_/Y _13650_/B VPWR VGND sg13g2_a22oi_1
X_22549_ _22549_/Q clkload17/A _22549_/D fanout2846/X VPWR VGND sg13g2_dfrbpq_1
XFILLER_10_786 VPWR VGND sg13g2_decap_4
X_12302_ _12302_/Y _23165_/Q _12640_/B _13182_/B2 _12301_/X VPWR VGND sg13g2_a22oi_1
XFILLER_100_1702 VPWR VGND sg13g2_decap_4
X_16070_ _22488_/D _16060_/B _16068_/Y _16069_/Y VPWR VGND sg13g2_o21ai_1
XFILLER_33_1191 VPWR VGND sg13g2_fill_1
X_13282_ _13282_/Y _13282_/A1 _13383_/A _13280_/X _12899_/S _13281_/Y VPWR VGND sg13g2_a221oi_1
X_15021_ _15022_/B _22533_/Q _15042_/B VPWR VGND sg13g2_nand2_1
XFILLER_107_140 VPWR VGND sg13g2_decap_8
X_12233_ _12234_/B _23709_/Q _23741_/Q _12235_/S VPWR VGND sg13g2_mux2_1
X_24219_ _24219_/Q clkload27/A _24219_/D fanout2856/X VPWR VGND sg13g2_dfrbpq_1
XFILLER_64_1107 VPWR VGND sg13g2_decap_4
Xfanout2900 fanout2900/X fanout2901/X VPWR VGND sg13g2_buf_1
X_12164_ _12164_/Y _23996_/Q _12166_/B VPWR VGND sg13g2_nand2b_1
Xfanout2911 fanout2911/X fanout2913/X VPWR VGND sg13g2_buf_1
Xfanout2922 fanout2922/X fanout2923/X VPWR VGND sg13g2_buf_1
XFILLER_81_1421 VPWR VGND sg13g2_decap_8
Xfanout2933 fanout2933/X fanout2934/X VPWR VGND sg13g2_buf_1
XFILLER_111_828 VPWR VGND sg13g2_decap_8
XFILLER_68_208 VPWR VGND sg13g2_decap_4
X_19760_ _19760_/Y _19760_/A _19760_/B VPWR VGND sg13g2_nand2_1
X_12095_ _12966_/B _12428_/C _15227_/A VPWR VGND sg13g2_xnor2_1
X_16972_ _16972_/Y _17164_/A _16972_/B VPWR VGND sg13g2_nand2_1
XFILLER_2_996 VPWR VGND sg13g2_decap_8
X_15923_ _15929_/B _15923_/A _15923_/B VPWR VGND sg13g2_nor2_1
X_18711_ _18714_/B _23018_/Q _23019_/Q _23020_/Q _18711_/D VPWR VGND sg13g2_nand4_1
XFILLER_42_1427 VPWR VGND sg13g2_fill_2
X_19691_ _19691_/Y _19691_/A _20190_/S VPWR VGND sg13g2_nand2_1
XFILLER_4_1900 VPWR VGND sg13g2_decap_8
XFILLER_65_904 VPWR VGND sg13g2_decap_8
X_18642_ _18642_/Y _18638_/B _18642_/B VPWR VGND sg13g2_nand2b_1
X_15854_ _15856_/C _22864_/Q _15966_/B1 _15872_/B1 _22829_/Q VPWR VGND sg13g2_a22oi_1
XFILLER_64_414 VPWR VGND sg13g2_decap_4
XFILLER_59_1902 VPWR VGND sg13g2_fill_2
X_14805_ _14805_/Y _14933_/S _16213_/A _14804_/Y VPWR VGND sg13g2_a21oi_1
XFILLER_64_447 VPWR VGND sg13g2_decap_8
XFILLER_111_1864 VPWR VGND sg13g2_decap_8
XFILLER_94_1804 VPWR VGND sg13g2_decap_8
XFILLER_92_767 VPWR VGND sg13g2_fill_1
X_18573_ _18854_/A _18573_/A _24226_/Q VPWR VGND sg13g2_or2_1
XFILLER_40_1173 VPWR VGND sg13g2_fill_2
XFILLER_80_918 VPWR VGND sg13g2_decap_8
XFILLER_40_1184 VPWR VGND sg13g2_decap_8
X_15785_ _16154_/A _15785_/A _15785_/B VPWR VGND sg13g2_nand2_1
X_12997_ _12997_/X _23910_/Q _24006_/Q _12997_/S VPWR VGND sg13g2_mux2_1
XFILLER_33_801 VPWR VGND sg13g2_decap_4
XFILLER_17_363 VPWR VGND sg13g2_decap_8
X_17524_ _17524_/Y _22876_/Q _17528_/B _17523_/Y VPWR VGND sg13g2_a21oi_1
X_14736_ _14736_/X _14707_/Y _14705_/Y _14739_/S VPWR VGND sg13g2_mux2_1
XFILLER_33_823 VPWR VGND sg13g2_decap_4
XFILLER_45_683 VPWR VGND sg13g2_decap_8
XFILLER_55_91 VPWR VGND sg13g2_decap_8
X_11948_ _11951_/B _12126_/A _11948_/B VPWR VGND sg13g2_nand2_1
XFILLER_94_1859 VPWR VGND sg13g2_decap_4
XFILLER_36_1209 VPWR VGND sg13g2_fill_2
X_17455_ _17455_/Y _17455_/A _17467_/B VPWR VGND sg13g2_nand2_1
X_14667_ _14667_/Y _14704_/A _14718_/B VPWR VGND sg13g2_nand2_1
X_11879_ _11879_/Y _19437_/A _19728_/B VPWR VGND sg13g2_nor2_1
XFILLER_53_1512 VPWR VGND sg13g2_fill_1
XFILLER_57_1681 VPWR VGND sg13g2_decap_8
X_13618_ _13618_/Y _13617_/B _24111_/Q _13617_/Y VPWR VGND sg13g2_o21ai_1
XFILLER_105_1613 VPWR VGND sg13g2_fill_2
X_17386_ _17386_/Y _14853_/Y _17386_/B VPWR VGND sg13g2_nand2b_1
X_14598_ _14612_/B _22942_/Q _14598_/B VPWR VGND sg13g2_nor2_1
Xrebuffer5507 rebuffer5507/X rebuffer5508/X VPWR VGND sg13g2_buf_1
Xrebuffer5518 rebuffer5518/X rebuffer5519/X VPWR VGND sg13g2_buf_1
Xrebuffer5529 rebuffer5529/X rebuffer5530/X VPWR VGND sg13g2_buf_1
Xplace3805 _18415_/B _18331_/B VPWR VGND sg13g2_buf_1
X_16337_ _16337_/Y _15187_/C _16336_/Y _17034_/C VPWR VGND sg13g2_a21oi_1
Xplace3816 _20229_/A _14107_/A VPWR VGND sg13g2_buf_1
Xplace3827 _14295_/A _12033_/B VPWR VGND sg13g2_buf_2
X_13549_ _14013_/A _13657_/A _13657_/B VPWR VGND sg13g2_nor2_1
Xplace3838 _19956_/A _14399_/B VPWR VGND sg13g2_buf_1
Xplace3849 _19946_/C1 _20100_/C1 VPWR VGND sg13g2_buf_1
X_19056_ _19056_/X _19119_/A1 _23097_/Q _19077_/S VPWR VGND sg13g2_mux2_1
X_16268_ _16269_/B _16320_/A _16320_/B _16273_/C _16273_/D VPWR VGND sg13g2_and4_1
XFILLER_12_1242 VPWR VGND sg13g2_decap_8
Xhold5208 _20784_/A _23444_/Q VPWR VGND sg13g2_dlygate4sd3_1
X_18007_ _18007_/Y _18517_/B _18302_/B VPWR VGND sg13g2_nor2_1
X_15219_ _15221_/A _15218_/A _15335_/B _19612_/A _15218_/Y VPWR VGND sg13g2_a22oi_1
X_16199_ _16199_/Y _16199_/A _16199_/B VPWR VGND sg13g2_nand2_1
XFILLER_99_322 VPWR VGND sg13g2_decap_8
XFILLER_114_655 VPWR VGND sg13g2_decap_8
XFILLER_113_154 VPWR VGND sg13g2_decap_8
XFILLER_99_377 VPWR VGND sg13g2_decap_4
XFILLER_9_1822 VPWR VGND sg13g2_decap_8
XFILLER_101_316 VPWR VGND sg13g2_decap_8
X_19958_ _19959_/B _19824_/A _19642_/B _19957_/Y VPWR VGND sg13g2_o21ai_1
XFILLER_87_539 VPWR VGND sg13g2_fill_1
XFILLER_101_327 VPWR VGND sg13g2_fill_1
X_18909_ _18909_/Y _18953_/A _18909_/B _18909_/C VPWR VGND sg13g2_nand3_1
XFILLER_68_753 VPWR VGND sg13g2_fill_2
XFILLER_112_1606 VPWR VGND sg13g2_fill_2
XFILLER_110_850 VPWR VGND sg13g2_decap_8
XFILLER_9_1899 VPWR VGND sg13g2_decap_8
X_19889_ _19889_/Y _20222_/B _20098_/A3 _19885_/Y VPWR VGND sg13g2_o21ai_1
XFILLER_56_915 VPWR VGND sg13g2_fill_2
XFILLER_67_252 VPWR VGND sg13g2_decap_8
XFILLER_28_617 VPWR VGND sg13g2_decap_8
XFILLER_83_723 VPWR VGND sg13g2_decap_8
XFILLER_95_594 VPWR VGND sg13g2_decap_8
XFILLER_83_734 VPWR VGND sg13g2_fill_2
XFILLER_67_285 VPWR VGND sg13g2_decap_8
XFILLER_82_222 VPWR VGND sg13g2_fill_1
X_21851_ _23924_/D _22317_/A1 _21850_/B _21850_/Y VPWR VGND sg13g2_o21ai_1
XFILLER_82_266 VPWR VGND sg13g2_decap_4
XFILLER_3_1476 VPWR VGND sg13g2_decap_8
X_20802_ _23450_/D _21305_/A1 _20801_/B _20801_/Y VPWR VGND sg13g2_o21ai_1
Xinput4406 _20343_/A2 data_rdata_i[6] VPWR VGND sg13g2_buf_1
Xinput4417 _19128_/A1 instr_rdata_i[11] VPWR VGND sg13g2_buf_1
XFILLER_23_311 VPWR VGND sg13g2_fill_1
XFILLER_24_834 VPWR VGND sg13g2_decap_8
Xinput4428 _18929_/A instr_rdata_i[21] VPWR VGND sg13g2_buf_1
Xinput4439 _19039_/A instr_rdata_i[31] VPWR VGND sg13g2_buf_1
X_23521_ _23521_/Q _23682_/CLK _23521_/D fanout2726/X VPWR VGND sg13g2_dfrbpq_1
X_20733_ _23417_/D _21237_/A1 _20742_/B _20732_/Y VPWR VGND sg13g2_o21ai_1
Xclkbuf_leaf_71_clk_i clkload11/A clkbuf_leaf_4_clk_i/A VPWR VGND sg13g2_buf_16
XFILLER_75_1781 VPWR VGND sg13g2_fill_2
XFILLER_50_152 VPWR VGND sg13g2_decap_8
X_23452_ _23452_/Q clkload53/A _23452_/D fanout2782/X VPWR VGND sg13g2_dfrbpq_1
X_20664_ _20664_/Y _23386_/Q _20666_/B VPWR VGND sg13g2_nand2_1
XFILLER_17_1131 VPWR VGND sg13g2_decap_8
XFILLER_52_1044 VPWR VGND sg13g2_decap_8
X_22403_ _24187_/D _22403_/A1 _22402_/B _22402_/Y VPWR VGND sg13g2_o21ai_1
X_23383_ _23383_/Q clkload57/A _23383_/D fanout2761/X VPWR VGND sg13g2_dfrbpq_1
X_20595_ _23352_/D _21301_/A1 _20646_/S _20594_/Y VPWR VGND sg13g2_o21ai_1
XFILLER_104_1145 VPWR VGND sg13g2_decap_8
X_22334_ _24154_/D _22401_/A1 _22328_/B _22333_/Y VPWR VGND sg13g2_o21ai_1
XFILLER_87_1118 VPWR VGND sg13g2_decap_8
XFILLER_105_600 VPWR VGND sg13g2_decap_8
X_22265_ _22265_/Y _24121_/Q _22276_/B VPWR VGND sg13g2_nand2_1
XFILLER_10_1949 VPWR VGND sg13g2_decap_4
XFILLER_3_716 VPWR VGND sg13g2_fill_2
XFILLER_3_749 VPWR VGND sg13g2_fill_1
X_24004_ _24004_/Q clkload45/A _24004_/D fanout2715/X VPWR VGND sg13g2_dfrbpq_1
X_21216_ _23632_/D _21616_/A1 _21221_/B _21215_/Y VPWR VGND sg13g2_o21ai_1
X_22196_ _24087_/D _22262_/A1 _22203_/B _22195_/Y VPWR VGND sg13g2_o21ai_1
XFILLER_105_666 VPWR VGND sg13g2_fill_1
XFILLER_104_143 VPWR VGND sg13g2_decap_8
XFILLER_82_1730 VPWR VGND sg13g2_fill_2
XFILLER_47_1850 VPWR VGND sg13g2_decap_4
X_21147_ _23599_/D _23599_/Q _21346_/A0 _21153_/S VPWR VGND sg13g2_mux2_1
XFILLER_82_1741 VPWR VGND sg13g2_decap_8
XFILLER_78_539 VPWR VGND sg13g2_fill_1
XFILLER_115_1241 VPWR VGND sg13g2_decap_8
XFILLER_43_1747 VPWR VGND sg13g2_decap_8
XFILLER_76_46 VPWR VGND sg13g2_decap_8
XFILLER_101_850 VPWR VGND sg13g2_fill_2
XFILLER_58_241 VPWR VGND sg13g2_decap_8
XFILLER_58_252 VPWR VGND sg13g2_fill_1
XFILLER_111_1105 VPWR VGND sg13g2_decap_8
X_20029_ _20029_/Y _19932_/A _19581_/Y _20028_/X VPWR VGND sg13g2_a21oi_1
X_12920_ _12920_/Y _13678_/A1 _12917_/Y _12919_/Y _13595_/B2 _12042_/B VPWR VGND sg13g2_a221oi_1
XFILLER_19_628 VPWR VGND sg13g2_fill_1
Xclkbuf_leaf_24_clk_i clkload46/A clkbuf_leaf_43_clk_i/A VPWR VGND sg13g2_buf_16
XFILLER_98_1247 VPWR VGND sg13g2_decap_8
XFILLER_98_1258 VPWR VGND sg13g2_fill_1
XFILLER_59_1209 VPWR VGND sg13g2_decap_8
X_12851_ _13081_/B _12853_/A _12853_/B _14056_/A VPWR VGND sg13g2_and3_1
XFILLER_46_469 VPWR VGND sg13g2_decap_8
X_11802_ _11803_/D _12318_/A _11801_/X _12316_/A VPWR VGND sg13g2_o21ai_1
XFILLER_15_812 VPWR VGND sg13g2_fill_2
XFILLER_73_277 VPWR VGND sg13g2_decap_8
XFILLER_33_119 VPWR VGND sg13g2_decap_8
X_15570_ _15570_/Y _22559_/Q _15633_/S VPWR VGND sg13g2_nand2_1
X_12782_ _12782_/X _12782_/A _13028_/A VPWR VGND sg13g2_and2_1
X_14521_ _14522_/B _14521_/A VPWR VGND sg13g2_inv_1
X_11733_ _11734_/B _14441_/A _11681_/Y _11732_/Y VPWR VGND sg13g2_a21oi_2
X_23719_ _23719_/Q clkload36/A _23719_/D fanout2707/X VPWR VGND sg13g2_dfrbpq_1
Xclkbuf_leaf_39_clk_i clkload43/A clkload2/A VPWR VGND sg13g2_buf_16
X_17240_ _17240_/Y _22751_/Q _17252_/B VPWR VGND sg13g2_nand2_1
Xclkbuf_3_1_0_clk_i clkbuf_3_1_0_clk_i/X clkbuf_0_clk_i/X VPWR VGND sg13g2_buf_16
X_14452_ _14453_/D _17042_/C VPWR VGND sg13g2_inv_1
XFILLER_42_697 VPWR VGND sg13g2_fill_1
X_11664_ _11664_/Y _14019_/B _14028_/B VPWR VGND sg13g2_nor2_1
XFILLER_54_1854 VPWR VGND sg13g2_decap_8
XFILLER_74_1280 VPWR VGND sg13g2_decap_8
XFILLER_41_185 VPWR VGND sg13g2_decap_8
XFILLER_106_1944 VPWR VGND sg13g2_decap_8
X_13403_ _13403_/Y _13403_/A _13403_/B _13403_/C _13403_/D VPWR VGND sg13g2_nor4_2
X_17171_ _17178_/D _17171_/A _17171_/B VPWR VGND sg13g2_nor2_1
X_14383_ _15179_/A _17034_/A _16786_/A _14383_/C VPWR VGND sg13g2_and3_1
X_11595_ _11596_/D _11595_/A _22978_/Q VPWR VGND sg13g2_nand2_1
X_16122_ _22497_/D _16132_/B _16120_/Y _16121_/Y VPWR VGND sg13g2_o21ai_1
X_13334_ _13334_/X _23307_/Q _23339_/Q _23371_/Q _23403_/Q _13840_/S0 _13707_/S1 VPWR
+ VGND sg13g2_mux4_1
XFILLER_41_82 VPWR VGND sg13g2_fill_1
XFILLER_13_1573 VPWR VGND sg13g2_decap_8
XFILLER_13_1584 VPWR VGND sg13g2_fill_1
X_16053_ _22484_/D _16073_/B _16051_/Y _16052_/Y VPWR VGND sg13g2_o21ai_1
XFILLER_6_576 VPWR VGND sg13g2_fill_2
XFILLER_48_1603 VPWR VGND sg13g2_decap_8
X_13265_ _13265_/Y _13264_/B _23626_/Q _13264_/Y VPWR VGND sg13g2_o21ai_1
XFILLER_68_1040 VPWR VGND sg13g2_fill_1
X_15004_ _15004_/Y _14953_/A _16292_/A _15003_/Y VPWR VGND sg13g2_o21ai_1
X_12216_ _12216_/X _23613_/Q _23677_/Q _12216_/S VPWR VGND sg13g2_mux2_1
XFILLER_100_1587 VPWR VGND sg13g2_decap_4
XFILLER_44_7 VPWR VGND sg13g2_fill_1
X_13196_ _13196_/Y _13794_/S _13196_/B VPWR VGND sg13g2_nand2_1
XFILLER_48_1658 VPWR VGND sg13g2_decap_8
XFILLER_29_1046 VPWR VGND sg13g2_decap_8
X_19812_ _19813_/B _19886_/A1 _20316_/A0 _19509_/Y _23218_/Q VPWR VGND sg13g2_a22oi_1
Xfanout2730 fanout2730/X fanout2731/X VPWR VGND sg13g2_buf_1
X_12147_ _12148_/D _13889_/B _12146_/X _13801_/A1 VPWR VGND sg13g2_o21ai_1
XFILLER_96_314 VPWR VGND sg13g2_decap_8
XFILLER_111_625 VPWR VGND sg13g2_decap_8
XFILLER_97_848 VPWR VGND sg13g2_fill_1
Xfanout2741 fanout2741/X fanout2742/X VPWR VGND sg13g2_buf_1
XFILLER_69_539 VPWR VGND sg13g2_fill_1
Xfanout2752 fanout2752/X fanout2753/X VPWR VGND sg13g2_buf_1
Xfanout2763 fanout2763/X fanout2766/X VPWR VGND sg13g2_buf_1
XFILLER_2_21 VPWR VGND sg13g2_decap_8
Xfanout2774 fanout2774/X fanout2776/X VPWR VGND sg13g2_buf_1
Xfanout2785 fanout2785/X fanout2786/X VPWR VGND sg13g2_buf_1
X_19743_ _19743_/Y _20284_/A3 _19781_/A2 _19781_/B1 _20284_/A1 _19782_/A1 VPWR VGND
+ sg13g2_a221oi_1
XFILLER_96_369 VPWR VGND sg13g2_decap_8
X_12078_ _12082_/C _12959_/A _19804_/A VPWR VGND sg13g2_nand2_1
X_16955_ _16956_/B _17019_/A _16980_/C VPWR VGND sg13g2_nand2b_1
Xfanout2796 fanout2796/X fanout2810/X VPWR VGND sg13g2_buf_1
XFILLER_110_168 VPWR VGND sg13g2_decap_8
XFILLER_38_926 VPWR VGND sg13g2_fill_2
XFILLER_49_263 VPWR VGND sg13g2_decap_4
XFILLER_113_1948 VPWR VGND sg13g2_decap_8
XFILLER_37_414 VPWR VGND sg13g2_decap_8
XFILLER_49_274 VPWR VGND sg13g2_fill_1
X_15906_ _15906_/Y _15906_/A _15963_/B VPWR VGND sg13g2_nor2_1
X_16886_ _22687_/D _16895_/S _16884_/Y _16885_/Y VPWR VGND sg13g2_o21ai_1
X_19674_ _19674_/Y _19671_/Y _19673_/Y _20038_/A VPWR VGND sg13g2_a21oi_1
XFILLER_77_594 VPWR VGND sg13g2_fill_2
XFILLER_37_447 VPWR VGND sg13g2_decap_8
X_18625_ _23003_/D _14828_/A _18624_/Y _14858_/Y VPWR VGND sg13g2_a21oi_1
X_15837_ _20234_/A _15837_/A _15837_/B _15837_/C _15837_/D VPWR VGND sg13g2_and4_1
XFILLER_92_553 VPWR VGND sg13g2_decap_4
XFILLER_4_1774 VPWR VGND sg13g2_decap_8
XFILLER_111_1694 VPWR VGND sg13g2_decap_8
XFILLER_52_428 VPWR VGND sg13g2_decap_4
XFILLER_79_1180 VPWR VGND sg13g2_decap_8
X_15768_ _15771_/B _22898_/Q _15937_/B _15359_/Y _22825_/Q VPWR VGND sg13g2_a22oi_1
X_18556_ _18556_/Y _18564_/A1 _18549_/X _18555_/X _18514_/A VPWR VGND sg13g2_a22oi_1
XFILLER_52_439 VPWR VGND sg13g2_decap_8
XFILLER_75_1022 VPWR VGND sg13g2_decap_4
XFILLER_17_193 VPWR VGND sg13g2_decap_8
X_14719_ _14719_/Y _13967_/Y _14642_/B _14718_/Y VPWR VGND sg13g2_o21ai_1
XFILLER_36_1006 VPWR VGND sg13g2_fill_1
X_17507_ _22871_/D _17228_/B _22871_/Q _17507_/S VPWR VGND sg13g2_mux2_1
X_18487_ _18487_/Y _18564_/A1 _18473_/X _18514_/A _18483_/Y _18486_/Y VPWR VGND sg13g2_a221oi_1
XFILLER_107_1708 VPWR VGND sg13g2_decap_8
X_15699_ _15712_/A _15699_/A _15699_/B VPWR VGND sg13g2_nand2_1
XFILLER_72_1932 VPWR VGND sg13g2_decap_8
X_17438_ _22839_/D _16054_/A _17437_/B _17437_/Y VPWR VGND sg13g2_o21ai_1
XFILLER_75_1099 VPWR VGND sg13g2_decap_8
Xplace4303 _12909_/B _12921_/S VPWR VGND sg13g2_buf_4
XFILLER_53_1331 VPWR VGND sg13g2_fill_1
Xplace4314 _11904_/B _11836_/B VPWR VGND sg13g2_buf_1
Xplace4325 _11752_/B _12293_/A VPWR VGND sg13g2_buf_4
Xrebuffer5304 place3729/A _11444_/Y VPWR VGND sg13g2_buf_2
XFILLER_33_1916 VPWR VGND sg13g2_decap_8
Xplace4336 _11634_/A _22977_/Q VPWR VGND sg13g2_buf_1
Xrebuffer5315 _12722_/A1 _11407_/A VPWR VGND sg13g2_buf_1
Xplace3602 _16776_/C _15238_/B VPWR VGND sg13g2_buf_1
Xrebuffer5326 _12098_/A1 _11990_/Y VPWR VGND sg13g2_buf_2
X_17369_ _17369_/Y _17369_/A _17369_/B VPWR VGND sg13g2_nand2_1
Xplace4347 _17697_/A _17573_/A VPWR VGND sg13g2_buf_1
Xplace3613 _15117_/A _18602_/A VPWR VGND sg13g2_buf_1
Xrebuffer5337 _13880_/C _13932_/D VPWR VGND sg13g2_buf_1
Xplace3624 _19712_/B _19634_/B VPWR VGND sg13g2_buf_1
Xrebuffer5348 _19456_/A _13864_/A VPWR VGND sg13g2_buf_1
Xrebuffer4603 _14014_/S _13743_/A VPWR VGND sg13g2_buf_1
XFILLER_70_0 VPWR VGND sg13g2_decap_8
Xrebuffer5359 _16285_/A _14973_/A1 VPWR VGND sg13g2_buf_1
Xplace3635 _14912_/B _14848_/B VPWR VGND sg13g2_buf_1
Xrebuffer4614 place3844/A _11317_/Y VPWR VGND sg13g2_buf_2
XFILLER_105_1476 VPWR VGND sg13g2_fill_2
Xplace3646 _14699_/B _19195_/B VPWR VGND sg13g2_buf_1
X_19108_ _19108_/X _19006_/A _23122_/Q _19114_/S VPWR VGND sg13g2_mux2_1
Xrebuffer4625 _12748_/B _12746_/Y VPWR VGND sg13g2_buf_2
X_20380_ _20380_/Y _23255_/Q _20380_/B VPWR VGND sg13g2_nand2_1
Xplace3657 _16073_/B _16060_/B VPWR VGND sg13g2_buf_1
Xplace3668 _16013_/A2 _15662_/A2 VPWR VGND sg13g2_buf_1
XFILLER_88_1438 VPWR VGND sg13g2_decap_8
XFILLER_31_1662 VPWR VGND sg13g2_decap_8
Xhold5005 _21904_/A _23948_/Q VPWR VGND sg13g2_dlygate4sd3_1
Xhold5016 _21298_/A _23671_/Q VPWR VGND sg13g2_dlygate4sd3_1
Xplace3679 _15114_/A2 _14947_/B VPWR VGND sg13g2_buf_1
Xplace2945 _18825_/B _18793_/B VPWR VGND sg13g2_buf_1
X_19039_ _19041_/B _19039_/A _19039_/B VPWR VGND sg13g2_nand2_1
XFILLER_31_1673 VPWR VGND sg13g2_fill_1
Xplace2956 _18959_/C _18880_/C VPWR VGND sg13g2_buf_1
Xhold5027 _22227_/A _24102_/Q VPWR VGND sg13g2_dlygate4sd3_1
Xplace2967 _18657_/B place2967/A VPWR VGND sg13g2_buf_1
Xhold5038 _22287_/A _24131_/Q VPWR VGND sg13g2_dlygate4sd3_1
XFILLER_86_1140 VPWR VGND sg13g2_fill_1
Xhold5049 _20127_/A _23237_/Q VPWR VGND sg13g2_dlygate4sd3_1
Xplace2978 _18524_/B _18535_/B VPWR VGND sg13g2_buf_1
XFILLER_115_942 VPWR VGND sg13g2_decap_8
Xplace2989 _18924_/C _18889_/B VPWR VGND sg13g2_buf_1
X_22050_ _22252_/B _22050_/A _22050_/B _22050_/C VPWR VGND sg13g2_nor3_1
XFILLER_82_1004 VPWR VGND sg13g2_fill_2
XFILLER_114_452 VPWR VGND sg13g2_decap_8
X_21001_ _23542_/D _22260_/A1 _21013_/B _21000_/Y VPWR VGND sg13g2_o21ai_1
XFILLER_82_1026 VPWR VGND sg13g2_decap_8
XFILLER_102_603 VPWR VGND sg13g2_decap_8
XFILLER_101_124 VPWR VGND sg13g2_fill_1
XFILLER_9_1652 VPWR VGND sg13g2_fill_2
XFILLER_102_669 VPWR VGND sg13g2_decap_4
XFILLER_29_904 VPWR VGND sg13g2_decap_8
XFILLER_64_1493 VPWR VGND sg13g2_fill_1
XFILLER_25_1466 VPWR VGND sg13g2_fill_2
XFILLER_28_403 VPWR VGND sg13g2_fill_2
XFILLER_96_881 VPWR VGND sg13g2_fill_1
X_22952_ _22952_/Q _23187_/CLK _22952_/D fanout2915/X VPWR VGND sg13g2_dfrbpq_1
XFILLER_28_436 VPWR VGND sg13g2_fill_1
XFILLER_56_745 VPWR VGND sg13g2_decap_4
X_21903_ _23947_/D _21969_/A1 _21910_/B _21902_/Y VPWR VGND sg13g2_o21ai_1
X_22883_ _22883_/Q _22917_/CLK _22883_/D fanout2895/X VPWR VGND sg13g2_dfrbpq_1
XFILLER_23_1190 VPWR VGND sg13g2_fill_1
XFILLER_93_1111 VPWR VGND sg13g2_fill_2
X_21834_ _23914_/D _22033_/A1 _21833_/B _21833_/Y VPWR VGND sg13g2_o21ai_1
XFILLER_38_1805 VPWR VGND sg13g2_decap_4
XFILLER_58_1231 VPWR VGND sg13g2_fill_1
XFILLER_36_491 VPWR VGND sg13g2_fill_2
XFILLER_58_1253 VPWR VGND sg13g2_fill_2
XFILLER_93_1144 VPWR VGND sg13g2_decap_8
XFILLER_73_1718 VPWR VGND sg13g2_decap_8
XFILLER_102_77 VPWR VGND sg13g2_decap_8
XFILLER_24_653 VPWR VGND sg13g2_fill_2
XFILLER_70_258 VPWR VGND sg13g2_decap_8
X_21765_ _23883_/D _21969_/A1 _21771_/B _21764_/Y VPWR VGND sg13g2_o21ai_1
XFILLER_12_815 VPWR VGND sg13g2_fill_1
XFILLER_52_984 VPWR VGND sg13g2_decap_8
XFILLER_12_826 VPWR VGND sg13g2_fill_1
XFILLER_54_1128 VPWR VGND sg13g2_decap_8
XFILLER_24_686 VPWR VGND sg13g2_decap_8
X_23504_ _23504_/Q clkload38/A _23504_/D fanout2638/X VPWR VGND sg13g2_dfrbpq_1
XFILLER_62_59 VPWR VGND sg13g2_fill_2
X_23435_ _23435_/Q clkload38/A _23435_/D fanout2629/X VPWR VGND sg13g2_dfrbpq_1
XFILLER_36_1584 VPWR VGND sg13g2_decap_8
XFILLER_11_369 VPWR VGND sg13g2_decap_4
X_20647_ _20647_/Y _23380_/Q _20647_/B VPWR VGND sg13g2_nand2_1
XFILLER_109_224 VPWR VGND sg13g2_decap_8
XFILLER_20_892 VPWR VGND sg13g2_fill_1
X_23366_ _23366_/Q clkload33/A _23366_/D fanout2699/X VPWR VGND sg13g2_dfrbpq_1
X_20578_ _20578_/Y _23346_/Q _20578_/B VPWR VGND sg13g2_nand2_1
XFILLER_14_1893 VPWR VGND sg13g2_decap_8
X_22317_ _24148_/D _22317_/A1 _22316_/B _22316_/Y VPWR VGND sg13g2_o21ai_1
XFILLER_101_1852 VPWR VGND sg13g2_decap_8
XFILLER_3_513 VPWR VGND sg13g2_fill_2
X_23297_ _23297_/Q _23682_/CLK _23297_/D fanout2723/X VPWR VGND sg13g2_dfrbpq_1
XFILLER_69_1360 VPWR VGND sg13g2_fill_1
XFILLER_11_74 VPWR VGND sg13g2_fill_1
X_13050_ _13050_/X _13048_/X _13049_/X _13244_/S VPWR VGND sg13g2_mux2_1
X_22248_ _24114_/D _22314_/A1 _22247_/B _22247_/Y VPWR VGND sg13g2_o21ai_1
X_12001_ _12003_/C _12002_/C _12084_/C _12001_/C _12001_/D VPWR VGND sg13g2_and4_1
XFILLER_105_474 VPWR VGND sg13g2_fill_1
Xhold4860 _21999_/A _23994_/Q VPWR VGND sg13g2_dlygate4sd3_1
XFILLER_26_1208 VPWR VGND sg13g2_decap_4
Xhold4871 _20594_/A _23352_/Q VPWR VGND sg13g2_dlygate4sd3_1
X_22179_ _24080_/D _22311_/A1 _22184_/B _22178_/Y VPWR VGND sg13g2_o21ai_1
XFILLER_79_848 VPWR VGND sg13g2_fill_2
Xhold4882 _22073_/A _24029_/Q VPWR VGND sg13g2_dlygate4sd3_1
XFILLER_87_78 VPWR VGND sg13g2_fill_2
Xhold4893 _20801_/A _23450_/Q VPWR VGND sg13g2_dlygate4sd3_1
XFILLER_43_1511 VPWR VGND sg13g2_decap_4
XFILLER_82_1571 VPWR VGND sg13g2_decap_8
XFILLER_43_1544 VPWR VGND sg13g2_fill_1
X_16740_ _16741_/B _22663_/Q _16740_/B VPWR VGND sg13g2_xnor2_1
XFILLER_87_881 VPWR VGND sg13g2_decap_8
XFILLER_87_892 VPWR VGND sg13g2_fill_2
X_13952_ _14105_/S _13952_/A _13952_/B _13952_/C _13952_/D VPWR VGND sg13g2_or4_1
XFILLER_19_425 VPWR VGND sg13g2_fill_2
XFILLER_8_1195 VPWR VGND sg13g2_fill_1
XFILLER_19_436 VPWR VGND sg13g2_fill_2
XFILLER_98_1044 VPWR VGND sg13g2_fill_2
X_12903_ _12903_/X _23429_/Q _23461_/Q _23493_/Q _23525_/Q _13004_/S0 _13004_/S1 VPWR
+ VGND sg13g2_mux4_1
X_16671_ _16672_/B _22649_/Q _22648_/Q _22647_/Q _16671_/D VPWR VGND sg13g2_nand4_1
XFILLER_78_1629 VPWR VGND sg13g2_decap_8
XFILLER_35_918 VPWR VGND sg13g2_decap_8
X_13883_ _13886_/D _14061_/S _13883_/B _13946_/A _13883_/D VPWR VGND sg13g2_nor4_1
XFILLER_95_1932 VPWR VGND sg13g2_decap_8
X_18410_ _18410_/Y _18443_/A _18410_/B _18410_/C VPWR VGND sg13g2_nor3_1
X_15622_ _15623_/B _15984_/A _15620_/Y _15621_/Y VPWR VGND sg13g2_o21ai_1
X_19390_ _19390_/Y _19456_/A _19463_/S VPWR VGND sg13g2_nor2_1
XFILLER_46_288 VPWR VGND sg13g2_decap_4
XFILLER_61_214 VPWR VGND sg13g2_decap_4
X_12834_ _12834_/Y _12843_/A _12845_/B VPWR VGND sg13g2_nand2_1
XFILLER_36_82 VPWR VGND sg13g2_decap_4
XFILLER_62_759 VPWR VGND sg13g2_decap_8
X_18341_ _18341_/Y _18297_/B _18458_/B _18363_/A VPWR VGND sg13g2_o21ai_1
X_15553_ _15553_/Y _22792_/Q _15945_/B1 _15698_/A2 _22492_/Q _15552_/X VPWR VGND sg13g2_a221oi_1
XFILLER_43_973 VPWR VGND sg13g2_fill_2
X_12765_ _12766_/B _12852_/A _12843_/A _12757_/B _20009_/B VPWR VGND sg13g2_a22oi_1
X_14504_ _14507_/B _22598_/Q _23009_/Q VPWR VGND sg13g2_xor2_1
X_11716_ _11731_/B _11716_/A _11716_/B _11716_/C _11716_/D VPWR VGND sg13g2_nor4_2
X_18272_ _18272_/Y _18297_/B _18517_/B VPWR VGND sg13g2_nor2_1
X_15484_ _15486_/B _22458_/Q _15575_/B _17303_/A _22789_/Q VPWR VGND sg13g2_a22oi_1
X_17223_ _17224_/B _22738_/Q _22737_/Q _22746_/Q VPWR VGND sg13g2_nand3_1
XFILLER_50_1504 VPWR VGND sg13g2_fill_2
X_14435_ _14435_/Y _14435_/A _14435_/B VPWR VGND sg13g2_nand2_1
XFILLER_106_1752 VPWR VGND sg13g2_fill_1
XFILLER_15_1646 VPWR VGND sg13g2_decap_4
XFILLER_106_1785 VPWR VGND sg13g2_fill_2
X_17154_ _22734_/D _17209_/B _17152_/Y _17153_/Y VPWR VGND sg13g2_a21oi_1
X_14366_ _16779_/B _15307_/A _14365_/Y _15165_/C VPWR VGND sg13g2_a21oi_1
X_11578_ _11633_/C _22991_/Q _11608_/B VPWR VGND sg13g2_nand2b_1
X_16105_ _16105_/Y _16105_/A _16205_/B VPWR VGND sg13g2_nand2_1
X_13317_ _13317_/X _23851_/Q _23883_/Q _23947_/Q _23979_/Q _13671_/B _13983_/S1 VPWR
+ VGND sg13g2_mux4_1
X_17085_ _17085_/Y _22722_/Q _17085_/B VPWR VGND sg13g2_xnor2_1
XFILLER_6_384 VPWR VGND sg13g2_fill_2
XFILLER_115_238 VPWR VGND sg13g2_decap_8
X_16036_ _17439_/B _16036_/A _17391_/B VPWR VGND sg13g2_nor2_1
XFILLER_112_901 VPWR VGND sg13g2_decap_8
XFILLER_63_1909 VPWR VGND sg13g2_decap_8
XFILLER_69_314 VPWR VGND sg13g2_fill_1
X_13179_ _13373_/C _13692_/A _13179_/B _13179_/C _13179_/D VPWR VGND sg13g2_and4_2
XFILLER_96_111 VPWR VGND sg13g2_decap_8
XFILLER_83_1379 VPWR VGND sg13g2_fill_2
XFILLER_61_1600 VPWR VGND sg13g2_fill_1
XFILLER_2_590 VPWR VGND sg13g2_fill_1
XFILLER_111_455 VPWR VGND sg13g2_fill_2
XFILLER_85_818 VPWR VGND sg13g2_decap_4
X_17987_ _17987_/Y _23043_/Q _17987_/B VPWR VGND sg13g2_nand2_1
XFILLER_84_306 VPWR VGND sg13g2_fill_2
XFILLER_6_1847 VPWR VGND sg13g2_decap_8
XFILLER_42_1043 VPWR VGND sg13g2_fill_2
XFILLER_61_1666 VPWR VGND sg13g2_decap_4
XFILLER_111_499 VPWR VGND sg13g2_decap_8
X_16938_ _16939_/A _22697_/Q VPWR VGND sg13g2_inv_1
XFILLER_37_222 VPWR VGND sg13g2_decap_8
XFILLER_96_1718 VPWR VGND sg13g2_decap_8
XFILLER_37_244 VPWR VGND sg13g2_decap_8
X_19657_ _19658_/B _20058_/A _19649_/Y _19656_/Y VPWR VGND sg13g2_o21ai_1
XFILLER_42_1098 VPWR VGND sg13g2_fill_2
X_16869_ _16870_/B _16877_/B _16893_/A VPWR VGND sg13g2_nor2_1
XFILLER_25_406 VPWR VGND sg13g2_fill_2
XFILLER_80_512 VPWR VGND sg13g2_fill_2
XFILLER_0_1413 VPWR VGND sg13g2_decap_4
X_18608_ _23000_/D _15279_/Y _18605_/Y _18607_/Y VPWR VGND sg13g2_a21oi_1
XFILLER_111_1491 VPWR VGND sg13g2_decap_8
X_19588_ _19704_/B _19587_/A _19447_/Y _19587_/Y VPWR VGND sg13g2_a21oi_1
XFILLER_18_480 VPWR VGND sg13g2_fill_2
XFILLER_34_940 VPWR VGND sg13g2_fill_1
XFILLER_20_1396 VPWR VGND sg13g2_fill_2
X_18539_ _18539_/Y _18539_/A _18539_/B VPWR VGND sg13g2_nand2_1
XFILLER_90_1339 VPWR VGND sg13g2_decap_8
XFILLER_33_472 VPWR VGND sg13g2_decap_8
X_21550_ _23792_/D _21616_/A1 _21549_/B _21549_/Y VPWR VGND sg13g2_o21ai_1
Xplace4100 _18358_/S _18549_/S VPWR VGND sg13g2_buf_1
XFILLER_21_645 VPWR VGND sg13g2_fill_2
Xplace4111 _14143_/C _22989_/Q VPWR VGND sg13g2_buf_1
X_20501_ _23310_/D _22442_/A1 _20504_/B _20500_/Y VPWR VGND sg13g2_o21ai_1
Xplace4122 _12778_/A _22987_/Q VPWR VGND sg13g2_buf_1
Xplace4133 _12982_/S1 _13702_/A VPWR VGND sg13g2_buf_4
X_21481_ _23758_/D _21974_/A1 _21483_/B _21480_/Y VPWR VGND sg13g2_o21ai_1
Xplace4144 _11792_/S _11456_/B VPWR VGND sg13g2_buf_2
Xplace3410 _17252_/B _17246_/B VPWR VGND sg13g2_buf_1
Xplace4155 _13707_/S1 _13955_/S VPWR VGND sg13g2_buf_2
Xplace3421 _16472_/B _16517_/S VPWR VGND sg13g2_buf_1
Xplace4166 _11960_/S _11508_/S0 VPWR VGND sg13g2_buf_1
X_23220_ _23220_/Q clkload33/A _23220_/D fanout2932/X VPWR VGND sg13g2_dfrbpq_1
X_20432_ _20432_/Y _20432_/A _20434_/S VPWR VGND sg13g2_nand2_1
Xplace3432 _16063_/A _17394_/A VPWR VGND sg13g2_buf_1
Xplace4177 _12733_/S _11815_/S1 VPWR VGND sg13g2_buf_4
XFILLER_88_1213 VPWR VGND sg13g2_decap_8
Xplace3443 _17702_/B _17652_/B VPWR VGND sg13g2_buf_1
Xplace4188 _12203_/S _11449_/B VPWR VGND sg13g2_buf_1
Xplace4199 _13707_/S0 _13962_/S0 VPWR VGND sg13g2_buf_1
Xplace3454 _17197_/B _17182_/B VPWR VGND sg13g2_buf_1
Xplace3465 _16707_/A _16711_/A VPWR VGND sg13g2_buf_1
Xplace3476 _16637_/S _16673_/A VPWR VGND sg13g2_buf_1
X_23151_ _23151_/Q clkload14/A _23151_/D fanout2840/X VPWR VGND sg13g2_dfrbpq_1
Xplace3487 _15980_/S _16020_/B VPWR VGND sg13g2_buf_1
Xplace3498 _16895_/S _16927_/S VPWR VGND sg13g2_buf_1
X_22102_ _24042_/D _20202_/X _22101_/B _22101_/Y VPWR VGND sg13g2_o21ai_1
X_23082_ _23082_/Q clkload12/A _23082_/D fanout2909/X VPWR VGND sg13g2_dfrbpq_1
X_20294_ _20294_/Y _20294_/A _20294_/B VPWR VGND sg13g2_nor2_1
XFILLER_115_761 VPWR VGND sg13g2_decap_8
XFILLER_0_505 VPWR VGND sg13g2_fill_2
X_22033_ _24010_/D _22033_/A1 _22039_/B _22032_/Y VPWR VGND sg13g2_o21ai_1
XFILLER_66_1555 VPWR VGND sg13g2_fill_1
XFILLER_88_623 VPWR VGND sg13g2_fill_2
XFILLER_66_1588 VPWR VGND sg13g2_decap_4
XFILLER_44_1831 VPWR VGND sg13g2_decap_8
XFILLER_76_807 VPWR VGND sg13g2_fill_2
XFILLER_112_1200 VPWR VGND sg13g2_decap_4
X_23984_ _23984_/Q clkload49/A _23984_/D fanout2673/X VPWR VGND sg13g2_dfrbpq_1
XFILLER_84_840 VPWR VGND sg13g2_fill_1
XFILLER_29_745 VPWR VGND sg13g2_decap_8
XFILLER_113_21 VPWR VGND sg13g2_decap_8
XFILLER_5_1379 VPWR VGND sg13g2_fill_1
X_22935_ _22935_/Q _22941_/CLK _22935_/D fanout2801/X VPWR VGND sg13g2_dfrbpq_1
XFILLER_84_873 VPWR VGND sg13g2_decap_8
XFILLER_21_1149 VPWR VGND sg13g2_decap_8
XFILLER_28_255 VPWR VGND sg13g2_decap_4
XFILLER_84_884 VPWR VGND sg13g2_fill_1
XFILLER_112_1288 VPWR VGND sg13g2_fill_1
XFILLER_113_98 VPWR VGND sg13g2_decap_8
X_22866_ _22866_/Q clkload7/A _22866_/D fanout2794/X VPWR VGND sg13g2_dfrbpq_1
XFILLER_3_1081 VPWR VGND sg13g2_decap_4
XFILLER_71_534 VPWR VGND sg13g2_decap_8
XFILLER_25_940 VPWR VGND sg13g2_decap_4
XFILLER_77_1662 VPWR VGND sg13g2_decap_8
XFILLER_71_556 VPWR VGND sg13g2_fill_2
XFILLER_19_1001 VPWR VGND sg13g2_decap_8
XFILLER_25_962 VPWR VGND sg13g2_decap_8
X_21817_ _23905_/D _22284_/A1 _21826_/B _21816_/Y VPWR VGND sg13g2_o21ai_1
XFILLER_77_1695 VPWR VGND sg13g2_fill_2
XFILLER_24_450 VPWR VGND sg13g2_fill_1
X_22797_ _22797_/Q clkload18/A _22797_/D fanout2821/X VPWR VGND sg13g2_dfrbpq_1
XFILLER_58_1094 VPWR VGND sg13g2_decap_8
X_12550_ _12550_/Y _12550_/A _12668_/B VPWR VGND sg13g2_nand2_1
X_21748_ _21748_/Y _21748_/A _21754_/B VPWR VGND sg13g2_nand2_1
XFILLER_16_1933 VPWR VGND sg13g2_decap_8
X_11501_ _11501_/X _12471_/B _11501_/B VPWR VGND sg13g2_and2_1
XFILLER_12_678 VPWR VGND sg13g2_fill_1
X_12481_ _12482_/B _23712_/Q _23840_/Q _12485_/S VPWR VGND sg13g2_mux2_1
XFILLER_103_1903 VPWR VGND sg13g2_decap_8
XFILLER_8_638 VPWR VGND sg13g2_decap_8
XFILLER_40_998 VPWR VGND sg13g2_decap_8
X_21679_ _23852_/D _21971_/A1 _21690_/B _21678_/Y VPWR VGND sg13g2_o21ai_1
XFILLER_8_649 VPWR VGND sg13g2_fill_1
X_14220_ _14228_/A _14220_/A _14220_/B VPWR VGND sg13g2_and2_1
X_11432_ _11433_/D _11407_/A _11431_/X _12048_/A VPWR VGND sg13g2_o21ai_1
X_23418_ _23418_/Q clkload54/A _23418_/D fanout2771/X VPWR VGND sg13g2_dfrbpq_1
XFILLER_22_62 VPWR VGND sg13g2_decap_8
X_14151_ _14151_/X _14445_/B _14151_/B _14772_/A VPWR VGND sg13g2_and3_1
X_23349_ _23349_/Q clkload57/A _23349_/D fanout2754/X VPWR VGND sg13g2_dfrbpq_1
X_11363_ _11363_/Y _11363_/A _11363_/B VPWR VGND sg13g2_nand2_1
XFILLER_14_1690 VPWR VGND sg13g2_fill_2
X_11294_ _11295_/B _23575_/Q _23607_/Q _23639_/Q _23671_/Q _12028_/A _11960_/S VPWR
+ VGND sg13g2_mux4_1
XFILLER_3_343 VPWR VGND sg13g2_decap_8
XFILLER_65_1010 VPWR VGND sg13g2_fill_2
XFILLER_98_77 VPWR VGND sg13g2_decap_8
XFILLER_98_88 VPWR VGND sg13g2_fill_2
XFILLER_0_0 VPWR VGND sg13g2_decap_8
X_17910_ _22934_/D _17910_/A _17910_/B VPWR VGND sg13g2_nand2_1
X_13033_ _14653_/D _13276_/A _13030_/X _13032_/X VPWR VGND sg13g2_o21ai_1
XFILLER_49_1775 VPWR VGND sg13g2_fill_1
X_18890_ _18891_/C _23047_/Q _18890_/B _18957_/C VPWR VGND sg13g2_or3_1
Xhold4690 _18125_/A _22956_/Q VPWR VGND sg13g2_dlygate4sd3_1
X_17841_ _22911_/D _16043_/A _17849_/C _17840_/Y VPWR VGND sg13g2_o21ai_1
XFILLER_26_1049 VPWR VGND sg13g2_decap_8
XFILLER_62_1953 VPWR VGND sg13g2_fill_2
XFILLER_23_1926 VPWR VGND sg13g2_decap_8
X_17772_ _17772_/Y _17809_/A1 _17770_/X _17771_/Y VPWR VGND sg13g2_o21ai_1
XFILLER_47_531 VPWR VGND sg13g2_fill_1
X_19511_ _19512_/B _19886_/A1 _20249_/A0 _19509_/Y _23213_/Q VPWR VGND sg13g2_a22oi_1
X_16723_ _16724_/B _22660_/Q _16723_/B VPWR VGND sg13g2_xnor2_1
X_13935_ _13935_/Y _13935_/A _13946_/C VPWR VGND sg13g2_xnor2_1
XFILLER_110_1929 VPWR VGND sg13g2_decap_8
XFILLER_81_309 VPWR VGND sg13g2_fill_1
XFILLER_78_1448 VPWR VGND sg13g2_decap_8
XFILLER_35_726 VPWR VGND sg13g2_fill_2
X_19442_ _19582_/B _19777_/B _19443_/B _19441_/X VPWR VGND sg13g2_a21oi_1
X_16654_ _16655_/B _22645_/Q _16654_/B _16658_/C VPWR VGND sg13g2_nand3_1
X_13866_ _13866_/Y _13864_/B _13864_/C _13861_/A VPWR VGND sg13g2_a21oi_1
XFILLER_1_1755 VPWR VGND sg13g2_decap_8
XFILLER_90_865 VPWR VGND sg13g2_fill_1
X_15605_ _15606_/D _22463_/Q _15639_/B _15463_/Y VPWR VGND sg13g2_a21oi_1
X_12817_ _12817_/Y _12816_/A _12814_/Y _12816_/Y VPWR VGND sg13g2_o21ai_1
X_19373_ _19373_/Y _19373_/A _19412_/B VPWR VGND sg13g2_nand2_1
X_16585_ _16586_/B _22631_/Q _16589_/C VPWR VGND sg13g2_nand2_1
XFILLER_90_887 VPWR VGND sg13g2_fill_2
XFILLER_50_718 VPWR VGND sg13g2_fill_1
X_13797_ _13797_/X _23569_/Q _24017_/Q _13797_/S VPWR VGND sg13g2_mux2_1
XFILLER_16_984 VPWR VGND sg13g2_decap_8
XFILLER_15_461 VPWR VGND sg13g2_decap_8
XFILLER_72_1014 VPWR VGND sg13g2_decap_4
X_15536_ _15539_/C _22849_/Q _15561_/B VPWR VGND sg13g2_and2_1
XFILLER_31_943 VPWR VGND sg13g2_decap_8
X_12748_ _14056_/A _20066_/A _12748_/B VPWR VGND sg13g2_xnor2_1
XFILLER_108_1869 VPWR VGND sg13g2_decap_8
XFILLER_37_1178 VPWR VGND sg13g2_fill_1
X_18255_ _18260_/A _18451_/A _18253_/Y _18254_/Y _18427_/A VPWR VGND sg13g2_a22oi_1
X_15467_ _15467_/Y _19373_/A _15690_/B _15467_/C VPWR VGND sg13g2_nor3_1
XFILLER_31_987 VPWR VGND sg13g2_fill_1
XFILLER_30_464 VPWR VGND sg13g2_decap_8
X_12679_ _12692_/D _13271_/A _12679_/B VPWR VGND sg13g2_or2_1
X_17206_ _17207_/C _17211_/B VPWR VGND sg13g2_inv_1
XFILLER_8_64 VPWR VGND sg13g2_fill_1
XFILLER_54_1492 VPWR VGND sg13g2_decap_8
XFILLER_15_1454 VPWR VGND sg13g2_decap_8
X_14418_ _14418_/Y _19116_/A1 _18024_/B _18595_/A1 VPWR VGND sg13g2_a21oi_1
X_15398_ _15399_/B _22914_/Q _15194_/Y _17439_/A _22844_/Q VPWR VGND sg13g2_a22oi_1
XFILLER_11_1329 VPWR VGND sg13g2_decap_8
XFILLER_50_1378 VPWR VGND sg13g2_fill_2
X_17137_ _17149_/B _22731_/Q _22730_/Q _22729_/Q _22728_/Q VPWR VGND sg13g2_nand4_1
X_14349_ _14378_/A _15424_/A _15424_/B _14383_/C _14348_/Y VPWR VGND sg13g2_a22oi_1
XFILLER_104_709 VPWR VGND sg13g2_decap_4
X_17068_ _17069_/B _17090_/A _17083_/B _17073_/D VPWR VGND sg13g2_nor3_1
XFILLER_28_1804 VPWR VGND sg13g2_decap_4
XFILLER_8_1909 VPWR VGND sg13g2_decap_8
XFILLER_28_1848 VPWR VGND sg13g2_fill_2
XFILLER_44_1138 VPWR VGND sg13g2_fill_1
XFILLER_69_144 VPWR VGND sg13g2_fill_1
XFILLER_112_775 VPWR VGND sg13g2_decap_8
XFILLER_97_464 VPWR VGND sg13g2_decap_8
XFILLER_58_829 VPWR VGND sg13g2_decap_8
XFILLER_111_252 VPWR VGND sg13g2_fill_1
XFILLER_69_166 VPWR VGND sg13g2_fill_1
XFILLER_100_937 VPWR VGND sg13g2_fill_2
XFILLER_57_317 VPWR VGND sg13g2_fill_1
XFILLER_111_285 VPWR VGND sg13g2_fill_2
XFILLER_111_296 VPWR VGND sg13g2_decap_8
XFILLER_6_1666 VPWR VGND sg13g2_fill_2
XFILLER_84_147 VPWR VGND sg13g2_decap_8
XFILLER_66_851 VPWR VGND sg13g2_decap_8
X_19709_ _19710_/B _19704_/A _19536_/B _19557_/X VPWR VGND sg13g2_a21oi_1
XFILLER_96_1504 VPWR VGND sg13g2_fill_1
XFILLER_22_1458 VPWR VGND sg13g2_decap_4
XFILLER_26_704 VPWR VGND sg13g2_fill_1
XFILLER_72_309 VPWR VGND sg13g2_decap_8
XFILLER_26_715 VPWR VGND sg13g2_decap_8
XFILLER_81_821 VPWR VGND sg13g2_decap_8
XFILLER_26_726 VPWR VGND sg13g2_fill_2
XFILLER_53_512 VPWR VGND sg13g2_decap_4
XFILLER_65_372 VPWR VGND sg13g2_decap_8
X_22720_ _22720_/Q clkload23/A _22720_/D fanout2887/X VPWR VGND sg13g2_dfrbpq_1
XFILLER_26_759 VPWR VGND sg13g2_decap_4
XFILLER_53_545 VPWR VGND sg13g2_decap_8
XFILLER_81_865 VPWR VGND sg13g2_decap_8
XFILLER_74_1813 VPWR VGND sg13g2_decap_4
X_22651_ _22651_/Q clkload23/A _22651_/D fanout2887/X VPWR VGND sg13g2_dfrbpq_1
XFILLER_80_353 VPWR VGND sg13g2_decap_8
XFILLER_25_269 VPWR VGND sg13g2_decap_4
XFILLER_90_1103 VPWR VGND sg13g2_decap_8
XFILLER_81_898 VPWR VGND sg13g2_decap_8
XFILLER_43_28 VPWR VGND sg13g2_decap_4
XFILLER_90_1114 VPWR VGND sg13g2_decap_4
XFILLER_90_1136 VPWR VGND sg13g2_decap_8
X_22582_ _22582_/Q clkload20/A _22582_/D fanout2873/X VPWR VGND sg13g2_dfrbpq_1
XFILLER_21_442 VPWR VGND sg13g2_decap_8
X_21533_ _23782_/D _21960_/A1 _21534_/B _21532_/Y VPWR VGND sg13g2_o21ai_1
XFILLER_55_1289 VPWR VGND sg13g2_decap_8
X_24252_ _24252_/X _24252_/A VPWR VGND sg13g2_buf_1
X_21464_ _23749_/D _21958_/A1 _21467_/B _21463_/Y VPWR VGND sg13g2_o21ai_1
Xplace3240 _21179_/B _21175_/B VPWR VGND sg13g2_buf_1
XFILLER_105_1092 VPWR VGND sg13g2_fill_2
X_23203_ _23203_/Q clkload33/A _23203_/D fanout2930/X VPWR VGND sg13g2_dfrbpq_1
Xplace3251 _21130_/B _21138_/B VPWR VGND sg13g2_buf_1
X_20415_ _23271_/D _22429_/A1 _20426_/B _20414_/Y VPWR VGND sg13g2_o21ai_1
Xplace3262 _21980_/A1 _22448_/A1 VPWR VGND sg13g2_buf_1
XFILLER_111_7 VPWR VGND sg13g2_decap_8
X_24183_ _24183_/Q clkload54/A _24183_/D fanout2748/X VPWR VGND sg13g2_dfrbpq_1
Xplace3273 _22433_/A1 _20187_/Y VPWR VGND sg13g2_buf_1
X_21395_ _23716_/D _21956_/A1 _21398_/B _21394_/Y VPWR VGND sg13g2_o21ai_1
Xplace3284 _21962_/A1 _20156_/Y VPWR VGND sg13g2_buf_1
XFILLER_49_1005 VPWR VGND sg13g2_decap_4
XFILLER_108_21 VPWR VGND sg13g2_decap_8
Xplace3295 _21321_/A1 _22416_/A1 VPWR VGND sg13g2_buf_1
XFILLER_11_1874 VPWR VGND sg13g2_decap_8
X_23134_ _23134_/Q clkload6/A _23134_/D fanout2833/X VPWR VGND sg13g2_dfrbpq_1
XFILLER_107_569 VPWR VGND sg13g2_decap_8
X_23065_ _23065_/Q clkload14/A _23065_/D fanout2844/X VPWR VGND sg13g2_dfrbpq_1
X_20277_ _20277_/Y _14399_/B _15905_/B _20275_/Y _20276_/Y _20345_/A1 VPWR VGND sg13g2_a221oi_1
XFILLER_108_98 VPWR VGND sg13g2_decap_8
XFILLER_103_742 VPWR VGND sg13g2_fill_2
X_22016_ _24001_/D _22284_/A1 _22025_/B _22015_/Y VPWR VGND sg13g2_o21ai_1
XFILLER_49_829 VPWR VGND sg13g2_fill_2
XFILLER_0_368 VPWR VGND sg13g2_fill_1
XFILLER_114_1328 VPWR VGND sg13g2_fill_1
XFILLER_102_263 VPWR VGND sg13g2_decap_8
XFILLER_75_103 VPWR VGND sg13g2_decap_8
XFILLER_102_274 VPWR VGND sg13g2_fill_2
XFILLER_25_1060 VPWR VGND sg13g2_decap_4
XFILLER_84_24 VPWR VGND sg13g2_fill_1
X_11981_ _11981_/Y _11981_/A _11981_/B _19777_/B VPWR VGND sg13g2_nand3_1
X_23967_ _23967_/Q clkload43/A _23967_/D fanout2741/X VPWR VGND sg13g2_dfrbpq_1
XFILLER_72_810 VPWR VGND sg13g2_fill_2
XFILLER_99_1172 VPWR VGND sg13g2_decap_4
XFILLER_90_117 VPWR VGND sg13g2_decap_8
XFILLER_29_586 VPWR VGND sg13g2_decap_4
XFILLER_79_1757 VPWR VGND sg13g2_decap_4
XFILLER_44_512 VPWR VGND sg13g2_fill_2
X_13720_ _13721_/B _13861_/A _20290_/B VPWR VGND sg13g2_xnor2_1
XFILLER_90_128 VPWR VGND sg13g2_fill_2
X_22918_ _22918_/Q clkload26/A _22918_/D fanout2825/X VPWR VGND sg13g2_dfrbpq_1
X_23898_ _23898_/Q clkload48/A _23898_/D fanout2686/X VPWR VGND sg13g2_dfrbpq_1
XFILLER_16_236 VPWR VGND sg13g2_fill_2
XFILLER_72_854 VPWR VGND sg13g2_decap_8
X_13651_ _20271_/B _13651_/A _13651_/B _13651_/C VPWR VGND sg13g2_nand3_1
X_22849_ _22849_/Q clkload21/A _22849_/D fanout2874/X VPWR VGND sg13g2_dfrbpq_1
XFILLER_44_578 VPWR VGND sg13g2_fill_1
XFILLER_72_887 VPWR VGND sg13g2_decap_8
X_12602_ _12607_/C _13624_/A _12602_/B VPWR VGND sg13g2_nor2_1
XFILLER_71_386 VPWR VGND sg13g2_fill_2
X_16370_ _16371_/A _15133_/A _14521_/A _16029_/B _22548_/Q VPWR VGND sg13g2_a22oi_1
X_13582_ _13582_/X _13582_/A _13582_/B VPWR VGND sg13g2_or2_1
X_15321_ _15322_/D _22589_/Q _15317_/Y _15986_/C1 _22585_/Q VPWR VGND sg13g2_a22oi_1
X_12533_ _19351_/A _12533_/A _12533_/B VPWR VGND sg13g2_nand2_1
XFILLER_12_453 VPWR VGND sg13g2_decap_8
XFILLER_51_1621 VPWR VGND sg13g2_decap_4
XFILLER_40_784 VPWR VGND sg13g2_decap_8
X_18040_ _18040_/X _19124_/A1 _23038_/Q _18053_/S VPWR VGND sg13g2_mux2_1
X_15252_ _15972_/B _15448_/B _15252_/B VPWR VGND sg13g2_and2_1
XFILLER_12_497 VPWR VGND sg13g2_decap_8
XFILLER_32_1031 VPWR VGND sg13g2_decap_8
X_12464_ _12464_/Y _12628_/A2 _12628_/A1 _12463_/Y VPWR VGND sg13g2_a21oi_2
X_14203_ _14809_/A _15920_/A1 _22832_/Q _14202_/X VPWR VGND sg13g2_a21oi_1
X_11415_ _11415_/Y _11384_/Y _11410_/Y _11412_/Y _11393_/Y _11414_/Y VPWR VGND sg13g2_a221oi_1
XFILLER_51_1698 VPWR VGND sg13g2_fill_2
X_12395_ _12395_/X _24159_/Q _24191_/Q _23231_/Q _23263_/Q _12819_/S0 _13983_/S1 VPWR
+ VGND sg13g2_mux4_1
XFILLER_103_1788 VPWR VGND sg13g2_decap_8
XFILLER_86_1728 VPWR VGND sg13g2_fill_2
XFILLER_86_1739 VPWR VGND sg13g2_decap_8
X_14134_ _14445_/B _18432_/A _14146_/B _14134_/C _14134_/D VPWR VGND sg13g2_or4_1
X_11346_ _11346_/Y _11346_/A _11755_/B VPWR VGND sg13g2_nor2b_2
X_19991_ _19991_/Y _19991_/A _19991_/B _19991_/C VPWR VGND sg13g2_nand3_1
XFILLER_84_1430 VPWR VGND sg13g2_decap_8
XFILLER_4_685 VPWR VGND sg13g2_fill_2
X_18942_ _18942_/Y _19041_/A _18942_/B _18942_/C VPWR VGND sg13g2_nand3_1
X_14065_ _14430_/C _14065_/A _14065_/B _14065_/C VPWR VGND sg13g2_nand3_1
XFILLER_106_580 VPWR VGND sg13g2_decap_8
XFILLER_45_1414 VPWR VGND sg13g2_decap_8
X_13016_ _13016_/X _23559_/Q _24007_/Q _13016_/S VPWR VGND sg13g2_mux2_1
X_18873_ _18873_/Y _18886_/A _18873_/B _18873_/C VPWR VGND sg13g2_nand3_1
XFILLER_39_317 VPWR VGND sg13g2_fill_2
XFILLER_27_1870 VPWR VGND sg13g2_fill_2
XFILLER_95_946 VPWR VGND sg13g2_decap_4
XFILLER_79_497 VPWR VGND sg13g2_decap_8
XFILLER_7_1953 VPWR VGND sg13g2_fill_2
X_17824_ _17824_/Y _17929_/B2 _17824_/A2 _17824_/B1 _17823_/Y VPWR VGND sg13g2_a22oi_1
XFILLER_23_1734 VPWR VGND sg13g2_decap_8
XFILLER_95_979 VPWR VGND sg13g2_fill_1
XFILLER_3_1806 VPWR VGND sg13g2_decap_8
XFILLER_48_851 VPWR VGND sg13g2_fill_2
XFILLER_23_1756 VPWR VGND sg13g2_decap_4
X_14967_ _14969_/C _22498_/Q _14998_/B VPWR VGND sg13g2_nand2_1
X_17755_ _17755_/Y _17762_/A _17762_/B VPWR VGND sg13g2_xnor2_1
XFILLER_48_873 VPWR VGND sg13g2_decap_8
XFILLER_114_1895 VPWR VGND sg13g2_decap_8
XFILLER_78_1212 VPWR VGND sg13g2_decap_8
X_16706_ _16707_/B _16709_/A _16706_/B VPWR VGND sg13g2_xnor2_1
X_13918_ _13918_/X _23859_/Q _23891_/Q _23955_/Q _23987_/Q _13919_/S0 _13919_/S1 VPWR
+ VGND sg13g2_mux4_1
XFILLER_63_843 VPWR VGND sg13g2_decap_8
X_14898_ _14899_/B _22521_/Q _14918_/B VPWR VGND sg13g2_nor2_1
X_17686_ _17686_/X _22562_/Q _17686_/B VPWR VGND sg13g2_xor2_1
XFILLER_74_191 VPWR VGND sg13g2_fill_2
XFILLER_63_865 VPWR VGND sg13g2_fill_1
X_19425_ _19425_/Y _19572_/A _19572_/B VPWR VGND sg13g2_nand2_1
XFILLER_35_567 VPWR VGND sg13g2_decap_8
X_16637_ _22642_/D _16636_/Y _17175_/A _16637_/S VPWR VGND sg13g2_mux2_1
XFILLER_63_898 VPWR VGND sg13g2_decap_8
XFILLER_50_526 VPWR VGND sg13g2_decap_4
XFILLER_91_1434 VPWR VGND sg13g2_decap_4
X_19356_ _19356_/Y _19953_/B _19448_/B VPWR VGND sg13g2_nor2_1
X_16568_ _16568_/Y _16591_/A _16568_/B VPWR VGND sg13g2_nor2_1
XFILLER_15_280 VPWR VGND sg13g2_decap_8
X_18307_ _18308_/B _18476_/A _18297_/B _18539_/B VPWR VGND sg13g2_a21oi_1
XFILLER_52_1429 VPWR VGND sg13g2_decap_8
X_15519_ _15519_/Y _15718_/S _16078_/A VPWR VGND sg13g2_nor2_1
X_19287_ _23205_/D _23205_/Q _20249_/A3 _19298_/S VPWR VGND sg13g2_mux2_1
X_16499_ _22611_/D _16175_/A _16506_/B _16498_/Y VPWR VGND sg13g2_o21ai_1
X_18238_ _18239_/C _18238_/A _18421_/A _18363_/B VPWR VGND sg13g2_nand3_1
X_18169_ _22965_/D _22965_/Q _18221_/S _18168_/Y VPWR VGND sg13g2_a21o_1
XFILLER_50_1186 VPWR VGND sg13g2_decap_8
XFILLER_11_1148 VPWR VGND sg13g2_fill_1
XFILLER_89_1374 VPWR VGND sg13g2_decap_8
X_20200_ _20200_/Y _24266_/A _20091_/B _19960_/Y _20177_/A _20199_/Y VPWR VGND sg13g2_a221oi_1
X_21180_ _23614_/D _21314_/A1 _21179_/B _21179_/Y VPWR VGND sg13g2_o21ai_1
X_20131_ _20140_/B _24262_/A _20286_/B VPWR VGND sg13g2_nand2_1
XFILLER_86_902 VPWR VGND sg13g2_decap_4
X_20062_ _20069_/C _20137_/B _20062_/B VPWR VGND sg13g2_nand2b_1
XFILLER_48_1082 VPWR VGND sg13g2_fill_1
XFILLER_112_572 VPWR VGND sg13g2_decap_8
XFILLER_115_1648 VPWR VGND sg13g2_decap_8
XFILLER_57_125 VPWR VGND sg13g2_decap_8
X_23821_ _23821_/Q clkload30/A _23821_/D fanout2657/X VPWR VGND sg13g2_dfrbpq_1
XFILLER_6_1485 VPWR VGND sg13g2_decap_4
XFILLER_22_1244 VPWR VGND sg13g2_decap_4
XFILLER_61_1293 VPWR VGND sg13g2_fill_1
XFILLER_2_1327 VPWR VGND sg13g2_decap_8
XFILLER_22_1266 VPWR VGND sg13g2_decap_8
XFILLER_72_128 VPWR VGND sg13g2_decap_8
X_23752_ _23752_/Q clkload31/A _23752_/D fanout2653/X VPWR VGND sg13g2_dfrbpq_1
X_20964_ _20964_/Y _20964_/A _20971_/B VPWR VGND sg13g2_nand2_1
XFILLER_26_545 VPWR VGND sg13g2_fill_2
XFILLER_57_1307 VPWR VGND sg13g2_fill_2
XFILLER_53_342 VPWR VGND sg13g2_decap_8
XFILLER_57_1318 VPWR VGND sg13g2_decap_8
XFILLER_54_876 VPWR VGND sg13g2_decap_8
X_22703_ _22703_/Q clkload19/A _22703_/D fanout2864/X VPWR VGND sg13g2_dfrbpq_1
XFILLER_54_887 VPWR VGND sg13g2_fill_2
XFILLER_109_1408 VPWR VGND sg13g2_decap_8
X_23683_ _23683_/Q clkload42/A _23683_/D fanout2718/X VPWR VGND sg13g2_dfrbpq_1
X_20895_ _23493_/D _21329_/A1 _20896_/B _20894_/Y VPWR VGND sg13g2_o21ai_1
XFILLER_13_217 VPWR VGND sg13g2_decap_8
XFILLER_55_1020 VPWR VGND sg13g2_decap_8
X_22634_ _22634_/Q _22733_/CLK _22634_/D fanout2879/X VPWR VGND sg13g2_dfrbpq_1
XFILLER_80_183 VPWR VGND sg13g2_decap_4
XFILLER_55_1031 VPWR VGND sg13g2_fill_2
XFILLER_74_1687 VPWR VGND sg13g2_decap_8
XFILLER_110_77 VPWR VGND sg13g2_decap_8
X_22565_ _22565_/Q clkload9/A _22565_/D fanout2825/X VPWR VGND sg13g2_dfrbpq_1
XFILLER_10_924 VPWR VGND sg13g2_decap_4
XFILLER_103_1007 VPWR VGND sg13g2_decap_8
XFILLER_10_946 VPWR VGND sg13g2_decap_8
XFILLER_52_1952 VPWR VGND sg13g2_fill_2
XFILLER_107_1187 VPWR VGND sg13g2_fill_2
X_21516_ _23774_/D _21943_/A1 _21515_/B _21515_/Y VPWR VGND sg13g2_o21ai_1
X_22496_ _22496_/Q clkload9/A _22496_/D fanout2824/X VPWR VGND sg13g2_dfrbpq_1
XFILLER_6_939 VPWR VGND sg13g2_decap_8
X_24235_ _24235_/Q clkload17/A _24235_/D fanout2848/X VPWR VGND sg13g2_dfrbpq_1
X_21447_ _21447_/Y _23742_/Q _21447_/B VPWR VGND sg13g2_nand2_1
XFILLER_107_311 VPWR VGND sg13g2_fill_1
XFILLER_100_1939 VPWR VGND sg13g2_decap_8
Xplace3070 _21850_/B _21832_/S VPWR VGND sg13g2_buf_1
XFILLER_108_867 VPWR VGND sg13g2_fill_1
Xplace3081 _21590_/B _21600_/B VPWR VGND sg13g2_buf_1
X_11200_ _11614_/A _14120_/C _11316_/B _14120_/B _11200_/D VPWR VGND sg13g2_nand4_1
Xplace3092 _21441_/B _21430_/B VPWR VGND sg13g2_buf_1
X_24166_ _24166_/Q clkload34/A _24166_/D fanout2694/X VPWR VGND sg13g2_dfrbpq_1
X_21378_ _21378_/Y _21378_/A _21380_/B VPWR VGND sg13g2_nand2_1
XFILLER_11_1671 VPWR VGND sg13g2_decap_8
XFILLER_107_388 VPWR VGND sg13g2_decap_8
X_23117_ _23117_/Q clkload12/A _23117_/D fanout2911/X VPWR VGND sg13g2_dfrbpq_1
X_20329_ _20329_/Y _20362_/A1 _20317_/Y _20328_/Y _20329_/B2 VPWR VGND sg13g2_a22oi_1
X_24097_ _24097_/Q clkload39/A _24097_/D fanout2733/X VPWR VGND sg13g2_dfrbpq_1
XFILLER_27_1111 VPWR VGND sg13g2_decap_8
X_23048_ _23048_/Q _23114_/CLK _23048_/D fanout2909/X VPWR VGND sg13g2_dfrbpq_1
XFILLER_27_1133 VPWR VGND sg13g2_decap_4
XFILLER_81_1658 VPWR VGND sg13g2_fill_2
XFILLER_0_165 VPWR VGND sg13g2_decap_4
XFILLER_103_583 VPWR VGND sg13g2_decap_8
XFILLER_77_957 VPWR VGND sg13g2_decap_8
X_15870_ _15874_/A _22903_/Q _15937_/B VPWR VGND sg13g2_nand2_1
XFILLER_48_114 VPWR VGND sg13g2_decap_8
XFILLER_76_445 VPWR VGND sg13g2_decap_4
XFILLER_92_905 VPWR VGND sg13g2_decap_8
XFILLER_114_1169 VPWR VGND sg13g2_fill_1
XFILLER_48_158 VPWR VGND sg13g2_fill_2
XFILLER_40_1333 VPWR VGND sg13g2_decap_4
XFILLER_48_169 VPWR VGND sg13g2_decap_8
XFILLER_63_106 VPWR VGND sg13g2_decap_4
XFILLER_45_821 VPWR VGND sg13g2_fill_2
XFILLER_91_437 VPWR VGND sg13g2_decap_4
X_17540_ _17583_/A _17540_/A _17540_/B _17540_/C VPWR VGND sg13g2_nor3_1
X_14752_ _17372_/A _16029_/A _14752_/B VPWR VGND sg13g2_nor2_1
XFILLER_44_320 VPWR VGND sg13g2_fill_1
X_11964_ _12686_/B _12577_/B _12778_/A VPWR VGND sg13g2_or2_1
X_13703_ _13703_/Y _13131_/A _13700_/X _13702_/X VPWR VGND sg13g2_a21oi_1
XFILLER_79_1598 VPWR VGND sg13g2_fill_2
XFILLER_2_1883 VPWR VGND sg13g2_decap_8
X_17471_ _17471_/Y _17471_/A _17475_/B VPWR VGND sg13g2_nand2_1
X_14683_ _14683_/Y _14295_/B _14642_/B _14682_/Y VPWR VGND sg13g2_o21ai_1
XFILLER_32_504 VPWR VGND sg13g2_decap_8
XFILLER_45_898 VPWR VGND sg13g2_decap_8
X_19210_ _23167_/D _24256_/A _23167_/Q _19221_/S VPWR VGND sg13g2_mux2_1
X_16422_ _16424_/A _23029_/Q _18742_/A _18742_/B VPWR VGND sg13g2_nand3_1
XFILLER_57_1863 VPWR VGND sg13g2_decap_8
X_13634_ _13634_/X _24175_/Q _24207_/Q _23247_/Q _23279_/Q _13133_/A _13635_/S1 VPWR
+ VGND sg13g2_mux4_1
XFILLER_71_183 VPWR VGND sg13g2_decap_4
XFILLER_57_1874 VPWR VGND sg13g2_fill_1
XFILLER_60_868 VPWR VGND sg13g2_decap_8
XFILLER_109_1953 VPWR VGND sg13g2_fill_2
XFILLER_57_1896 VPWR VGND sg13g2_decap_8
X_16353_ _16353_/Y _19494_/A _16353_/B VPWR VGND sg13g2_nor2_1
X_19141_ _23117_/D _23117_/Q _18951_/B _19141_/S VPWR VGND sg13g2_mux2_1
XFILLER_53_1738 VPWR VGND sg13g2_fill_1
X_13565_ _13565_/X _13565_/A _23918_/Q VPWR VGND sg13g2_and2_1
XFILLER_13_784 VPWR VGND sg13g2_fill_1
X_15304_ _15306_/B _15312_/A _15482_/A VPWR VGND sg13g2_nor2_1
X_12516_ _12516_/X _12535_/A _12516_/B _12516_/C VPWR VGND sg13g2_or3_1
X_19072_ _23072_/D _23072_/Q _19071_/X _19086_/S VPWR VGND sg13g2_mux2_1
X_16284_ _16286_/A _18685_/A _16284_/B VPWR VGND sg13g2_and2_1
XFILLER_8_243 VPWR VGND sg13g2_decap_8
X_13496_ _13496_/Y _23180_/Q _13924_/A2 _13495_/X _13924_/B1 VPWR VGND sg13g2_a22oi_1
XFILLER_74_7 VPWR VGND sg13g2_fill_1
X_15235_ _15236_/B _15319_/A _16779_/A _16779_/B VPWR VGND sg13g2_nor3_1
X_18023_ _18023_/Y _18029_/S _23031_/Q VPWR VGND sg13g2_nand2_1
X_12447_ _12450_/C _12707_/S _12606_/A _12447_/C VPWR VGND sg13g2_nor3_1
XFILLER_103_1563 VPWR VGND sg13g2_decap_8
XFILLER_86_1525 VPWR VGND sg13g2_fill_1
XFILLER_86_1536 VPWR VGND sg13g2_decap_8
XFILLER_5_21 VPWR VGND sg13g2_decap_8
X_12378_ _12379_/D _12486_/A _12377_/X _12575_/A VPWR VGND sg13g2_o21ai_1
XFILLER_47_1509 VPWR VGND sg13g2_decap_8
XFILLER_99_526 VPWR VGND sg13g2_decap_8
XFILLER_29_1910 VPWR VGND sg13g2_decap_4
XFILLER_114_837 VPWR VGND sg13g2_decap_8
XFILLER_99_537 VPWR VGND sg13g2_fill_2
X_14117_ _14117_/Y _14117_/A _14117_/B _14117_/C VPWR VGND sg13g2_nand3_1
X_11329_ _13179_/B _11329_/A _11329_/B VPWR VGND sg13g2_and2_2
X_15097_ _15098_/B _17924_/A1 _15107_/A2 _14918_/B VPWR VGND sg13g2_o21ai_1
XFILLER_113_336 VPWR VGND sg13g2_decap_4
XFILLER_113_347 VPWR VGND sg13g2_fill_1
XFILLER_84_1271 VPWR VGND sg13g2_decap_8
XFILLER_101_509 VPWR VGND sg13g2_decap_8
X_18925_ _18925_/Y _18922_/A _18925_/B _18925_/C VPWR VGND sg13g2_nand3b_1
X_14048_ _14049_/D _14046_/X _14047_/Y _14060_/A VPWR VGND sg13g2_mux2_1
XFILLER_45_1255 VPWR VGND sg13g2_fill_1
XFILLER_64_1889 VPWR VGND sg13g2_decap_8
X_18856_ _18856_/Y _18856_/A _18856_/B VPWR VGND sg13g2_nand2_1
XFILLER_41_1119 VPWR VGND sg13g2_decap_8
XFILLER_45_1288 VPWR VGND sg13g2_fill_2
XFILLER_7_1750 VPWR VGND sg13g2_decap_8
XFILLER_94_231 VPWR VGND sg13g2_decap_4
XFILLER_95_765 VPWR VGND sg13g2_decap_4
X_17807_ _17807_/Y _22577_/Q _17820_/C VPWR VGND sg13g2_xnor2_1
XFILLER_67_478 VPWR VGND sg13g2_fill_1
X_18787_ _18788_/C _23064_/Q _18825_/B VPWR VGND sg13g2_nand2_1
XFILLER_23_1586 VPWR VGND sg13g2_decap_8
XFILLER_3_1669 VPWR VGND sg13g2_fill_1
X_17738_ _22897_/D _17796_/B _17736_/Y _17737_/Y VPWR VGND sg13g2_a21oi_1
XFILLER_58_1605 VPWR VGND sg13g2_decap_8
XFILLER_35_353 VPWR VGND sg13g2_decap_8
XFILLER_39_1015 VPWR VGND sg13g2_decap_8
XFILLER_23_504 VPWR VGND sg13g2_fill_1
XFILLER_35_364 VPWR VGND sg13g2_fill_2
XFILLER_51_813 VPWR VGND sg13g2_fill_1
X_17669_ _17669_/Y _17710_/A1 _17664_/Y _17668_/Y VPWR VGND sg13g2_o21ai_1
X_19408_ _19408_/Y _20117_/B _19412_/B _19407_/Y VPWR VGND sg13g2_a21oi_1
XFILLER_51_857 VPWR VGND sg13g2_fill_1
X_20680_ _20680_/Y _23393_/Q _20682_/B VPWR VGND sg13g2_nand2_1
XFILLER_50_334 VPWR VGND sg13g2_decap_4
XFILLER_36_1936 VPWR VGND sg13g2_decap_8
X_19339_ _19339_/Y _13070_/B _19430_/B _19338_/Y VPWR VGND sg13g2_a21oi_1
XFILLER_17_1346 VPWR VGND sg13g2_fill_2
XFILLER_91_1297 VPWR VGND sg13g2_decap_8
XFILLER_104_1327 VPWR VGND sg13g2_fill_1
X_22350_ _22350_/Y _22350_/A _22350_/B VPWR VGND sg13g2_nand2_1
Xoutput4520 data_wdata_o[25] _14733_/X VPWR VGND sg13g2_buf_1
Xoutput4531 data_wdata_o[6] _14680_/X VPWR VGND sg13g2_buf_1
XFILLER_40_18 VPWR VGND sg13g2_decap_4
Xoutput4542 instr_addr_o[16] _14973_/Y VPWR VGND sg13g2_buf_1
XFILLER_108_119 VPWR VGND sg13g2_decap_8
X_21301_ _23672_/D _21301_/A1 _21308_/B _21300_/Y VPWR VGND sg13g2_o21ai_1
Xoutput4553 instr_addr_o[27] _15083_/Y VPWR VGND sg13g2_buf_1
Xoutput4564 instr_addr_o[8] _14893_/Y VPWR VGND sg13g2_buf_1
X_22281_ _22281_/Y _22281_/A _22285_/B VPWR VGND sg13g2_nand2_1
X_24020_ _24020_/Q clkload16/A _24020_/D fanout2623/X VPWR VGND sg13g2_dfrbpq_1
X_21232_ _21232_/Y _21232_/A _21234_/B VPWR VGND sg13g2_nand2_1
XFILLER_105_826 VPWR VGND sg13g2_decap_8
XFILLER_104_303 VPWR VGND sg13g2_fill_2
X_21163_ _23606_/D _21297_/A1 _21175_/B _21162_/Y VPWR VGND sg13g2_o21ai_1
XFILLER_49_49 VPWR VGND sg13g2_decap_8
X_20114_ _20114_/Y _20117_/B _20117_/C VPWR VGND sg13g2_nor2_1
X_21094_ _23573_/D _21295_/A1 _21099_/B _21093_/Y VPWR VGND sg13g2_o21ai_1
XFILLER_86_721 VPWR VGND sg13g2_decap_8
XFILLER_115_1434 VPWR VGND sg13g2_decap_8
X_20045_ _20045_/Y _20071_/A _20045_/B VPWR VGND sg13g2_nand2_1
XFILLER_8_1558 VPWR VGND sg13g2_decap_4
XFILLER_59_946 VPWR VGND sg13g2_fill_1
XFILLER_100_553 VPWR VGND sg13g2_decap_8
XFILLER_98_1418 VPWR VGND sg13g2_decap_8
XFILLER_58_467 VPWR VGND sg13g2_decap_8
XFILLER_105_77 VPWR VGND sg13g2_decap_8
XFILLER_86_798 VPWR VGND sg13g2_decap_4
XFILLER_6_1271 VPWR VGND sg13g2_fill_2
XFILLER_39_681 VPWR VGND sg13g2_decap_8
X_23804_ _23804_/Q _23966_/CLK _23804_/D fanout2765/X VPWR VGND sg13g2_dfrbpq_1
X_21996_ _23992_/D _22264_/A1 _22031_/S _21995_/Y VPWR VGND sg13g2_o21ai_1
XFILLER_26_342 VPWR VGND sg13g2_decap_8
XFILLER_57_1104 VPWR VGND sg13g2_decap_8
X_23735_ _23735_/Q clkload52/A _23735_/D fanout2689/X VPWR VGND sg13g2_dfrbpq_1
XFILLER_57_1115 VPWR VGND sg13g2_fill_1
XFILLER_82_993 VPWR VGND sg13g2_decap_8
XFILLER_81_481 VPWR VGND sg13g2_decap_8
X_23666_ _23666_/Q clkload32/A _23666_/D fanout2671/X VPWR VGND sg13g2_dfrbpq_1
XFILLER_109_1249 VPWR VGND sg13g2_decap_8
X_20878_ _23485_/D _21312_/A1 _20879_/B _20877_/Y VPWR VGND sg13g2_o21ai_1
XFILLER_74_1462 VPWR VGND sg13g2_decap_8
X_22617_ _22617_/Q clkload10/A _22617_/D fanout2817/X VPWR VGND sg13g2_dfrbpq_1
XFILLER_35_1435 VPWR VGND sg13g2_decap_8
X_23597_ _23597_/Q clkload30/A _23597_/D fanout2659/X VPWR VGND sg13g2_dfrbpq_1
XFILLER_41_389 VPWR VGND sg13g2_fill_2
XFILLER_35_1468 VPWR VGND sg13g2_decap_8
X_13350_ _13650_/B _13350_/A VPWR VGND sg13g2_inv_1
X_22548_ _22548_/Q clkload28/A _22548_/D fanout2856/X VPWR VGND sg13g2_dfrbpq_1
X_12301_ _12301_/X _22557_/Q _12413_/B VPWR VGND sg13g2_or2_1
XFILLER_5_202 VPWR VGND sg13g2_fill_1
X_13281_ _13281_/Y _13383_/A _14342_/C _13383_/C VPWR VGND sg13g2_nor3_1
X_22479_ _22479_/Q _23029_/CLK _22479_/D fanout2808/X VPWR VGND sg13g2_dfrbpq_1
XFILLER_87_1823 VPWR VGND sg13g2_fill_2
XFILLER_104_1894 VPWR VGND sg13g2_decap_8
X_12232_ _12256_/D _12232_/A _12232_/B _12232_/C _12232_/D VPWR VGND sg13g2_nor4_1
X_24218_ _24218_/Q clkload15/A _24218_/D fanout2852/X VPWR VGND sg13g2_dfrbpq_1
XFILLER_108_664 VPWR VGND sg13g2_decap_8
XFILLER_30_62 VPWR VGND sg13g2_fill_1
XFILLER_100_0 VPWR VGND sg13g2_decap_8
XFILLER_29_1217 VPWR VGND sg13g2_fill_2
X_24149_ _24149_/Q clkload56/A _24149_/D fanout2747/X VPWR VGND sg13g2_dfrbpq_1
X_12163_ _12163_/Y _13120_/A _12163_/B VPWR VGND sg13g2_nand2_1
XFILLER_11_1490 VPWR VGND sg13g2_decap_8
XFILLER_107_196 VPWR VGND sg13g2_decap_8
Xfanout2901 fanout2901/X fanout2902/X VPWR VGND sg13g2_buf_1
Xfanout2912 fanout2912/X fanout2913/X VPWR VGND sg13g2_buf_1
XFILLER_111_807 VPWR VGND sg13g2_decap_8
Xfanout2923 fanout2923/X fanout2935/X VPWR VGND sg13g2_buf_1
XFILLER_96_507 VPWR VGND sg13g2_decap_8
Xfanout2934 fanout2934/X fanout2935/X VPWR VGND sg13g2_buf_1
XFILLER_96_518 VPWR VGND sg13g2_fill_2
X_16971_ _16971_/Y _22704_/Q _16971_/B VPWR VGND sg13g2_xnor2_1
XFILLER_89_570 VPWR VGND sg13g2_fill_2
XFILLER_7_1002 VPWR VGND sg13g2_decap_8
XFILLER_42_1406 VPWR VGND sg13g2_decap_8
X_18710_ _23020_/D _18708_/A _18707_/Y _18709_/Y VPWR VGND sg13g2_a21oi_1
XFILLER_110_339 VPWR VGND sg13g2_decap_8
X_15922_ _15923_/B _22679_/Q _16774_/D _17056_/C _22743_/Q VPWR VGND sg13g2_a22oi_1
XFILLER_81_1466 VPWR VGND sg13g2_decap_4
XFILLER_42_1417 VPWR VGND sg13g2_fill_2
XFILLER_77_732 VPWR VGND sg13g2_decap_8
XFILLER_103_380 VPWR VGND sg13g2_fill_2
XFILLER_76_231 VPWR VGND sg13g2_decap_8
XFILLER_81_1499 VPWR VGND sg13g2_fill_1
X_18641_ _18641_/Y _18667_/A _18661_/B _18651_/B VPWR VGND sg13g2_o21ai_1
X_15853_ _15856_/B _22506_/Q _15893_/A2 _15893_/B1 _14204_/A VPWR VGND sg13g2_a22oi_1
XFILLER_76_264 VPWR VGND sg13g2_decap_8
XFILLER_64_426 VPWR VGND sg13g2_decap_4
XFILLER_111_1843 VPWR VGND sg13g2_decap_8
XFILLER_98_1952 VPWR VGND sg13g2_fill_2
X_14804_ _14804_/Y _14933_/S _23126_/Q VPWR VGND sg13g2_nor2_1
X_18572_ _18585_/A _18780_/S _18570_/Y _18571_/Y VPWR VGND sg13g2_o21ai_1
X_15784_ _16158_/A _23019_/Q _22569_/Q _15982_/S VPWR VGND sg13g2_mux2_1
X_12996_ _12996_/X _24038_/Q _24070_/Q _24102_/Q _24134_/Q _13243_/S0 _13243_/S1 VPWR
+ VGND sg13g2_mux4_1
XFILLER_92_779 VPWR VGND sg13g2_decap_8
XFILLER_17_342 VPWR VGND sg13g2_decap_8
X_17523_ _17523_/Y _17523_/A _17528_/B VPWR VGND sg13g2_nor2_1
XFILLER_91_278 VPWR VGND sg13g2_decap_8
X_14735_ _14735_/X _14702_/Y _14700_/Y _14737_/S VPWR VGND sg13g2_mux2_1
XFILLER_75_1215 VPWR VGND sg13g2_decap_4
X_11947_ _11948_/B _24154_/Q _23226_/Q _23290_/Q _23354_/Q _11797_/S _12567_/A VPWR
+ VGND sg13g2_mux4_1
XFILLER_18_898 VPWR VGND sg13g2_decap_8
XFILLER_2_1680 VPWR VGND sg13g2_decap_8
XFILLER_60_610 VPWR VGND sg13g2_fill_1
XFILLER_44_161 VPWR VGND sg13g2_fill_2
XFILLER_75_1259 VPWR VGND sg13g2_fill_2
X_17454_ _22845_/D _16063_/A _17453_/B _17453_/Y VPWR VGND sg13g2_o21ai_1
X_14666_ _14666_/Y _13217_/B _14720_/B _14665_/Y VPWR VGND sg13g2_o21ai_1
X_13617_ _13617_/Y _24143_/Q _13617_/B VPWR VGND sg13g2_nand2b_1
X_16405_ _22570_/D _16405_/A _16405_/B VPWR VGND sg13g2_nand2_1
XFILLER_32_389 VPWR VGND sg13g2_fill_1
X_14597_ _14598_/B _24217_/Q _14597_/B VPWR VGND sg13g2_nor2_1
X_17385_ _17385_/X _17384_/Y _16054_/A _17385_/S VPWR VGND sg13g2_mux2_1
Xrebuffer5508 rebuffer5508/X rebuffer5509/X VPWR VGND sg13g2_buf_1
Xrebuffer5519 rebuffer5519/X rebuffer5520/X VPWR VGND sg13g2_buf_1
X_19124_ _23102_/D _23102_/Q _19124_/A1 _19124_/S VPWR VGND sg13g2_mux2_1
X_16336_ _16336_/Y _22587_/Q _16518_/C VPWR VGND sg13g2_nand2_1
Xplace3806 _15963_/B _16353_/B VPWR VGND sg13g2_buf_1
Xplace3817 _14704_/A _13801_/Y VPWR VGND sg13g2_buf_2
Xplace3828 _20162_/A _20355_/A VPWR VGND sg13g2_buf_1
Xplace3839 _14399_/B _14279_/A VPWR VGND sg13g2_buf_1
X_16267_ _22525_/D _16320_/B _16267_/B VPWR VGND sg13g2_xnor2_1
X_19055_ _23064_/D _23064_/Q _19054_/X _19061_/S VPWR VGND sg13g2_mux2_1
XFILLER_51_1270 VPWR VGND sg13g2_fill_1
X_13479_ _13480_/B _23309_/Q _23341_/Q _23373_/Q _23405_/Q _13610_/S0 _13111_/A VPWR
+ VGND sg13g2_mux4_1
Xhold5209 _17789_/A _22904_/Q VPWR VGND sg13g2_dlygate4sd3_1
X_15218_ _15218_/Y _15218_/A _15690_/B VPWR VGND sg13g2_nor2_1
X_18006_ _18302_/B _18425_/B _18451_/C VPWR VGND sg13g2_nand2_1
XFILLER_31_1888 VPWR VGND sg13g2_fill_1
X_16198_ _16198_/Y _22511_/Q _16197_/B _16197_/Y VPWR VGND sg13g2_a21oi_1
XFILLER_66_1918 VPWR VGND sg13g2_fill_1
XFILLER_114_634 VPWR VGND sg13g2_decap_8
XFILLER_5_780 VPWR VGND sg13g2_decap_8
XFILLER_5_791 VPWR VGND sg13g2_fill_2
XFILLER_113_133 VPWR VGND sg13g2_decap_8
XFILLER_9_1801 VPWR VGND sg13g2_decap_8
XFILLER_4_290 VPWR VGND sg13g2_decap_8
X_19957_ _19957_/Y _20080_/A _19957_/B VPWR VGND sg13g2_nand2_1
XFILLER_59_209 VPWR VGND sg13g2_fill_2
XFILLER_29_1784 VPWR VGND sg13g2_decap_8
XFILLER_45_1052 VPWR VGND sg13g2_fill_1
X_18908_ _18909_/C _19023_/B _23081_/Q VPWR VGND sg13g2_nand2_1
XFILLER_9_1878 VPWR VGND sg13g2_decap_8
XFILLER_67_220 VPWR VGND sg13g2_decap_8
XFILLER_68_743 VPWR VGND sg13g2_decap_4
X_19888_ _19888_/Y _19885_/Y _19887_/Y _20350_/A VPWR VGND sg13g2_o21ai_1
XFILLER_99_1716 VPWR VGND sg13g2_decap_8
XFILLER_67_231 VPWR VGND sg13g2_fill_2
X_18839_ _18844_/A _23041_/Q _18865_/B _18865_/C VPWR VGND sg13g2_nand3_1
XFILLER_67_264 VPWR VGND sg13g2_fill_2
XFILLER_7_1580 VPWR VGND sg13g2_decap_8
Xclkbuf_leaf_5_clk_i _22893_/CLK clkbuf_leaf_6_clk_i/A VPWR VGND sg13g2_buf_16
X_21850_ _21850_/Y _21850_/A _21850_/B VPWR VGND sg13g2_nand2_1
XFILLER_83_779 VPWR VGND sg13g2_decap_4
XFILLER_82_245 VPWR VGND sg13g2_decap_8
XFILLER_36_651 VPWR VGND sg13g2_fill_2
X_20801_ _20801_/Y _20801_/A _20801_/B VPWR VGND sg13g2_nand2_1
XFILLER_70_407 VPWR VGND sg13g2_decap_4
X_21781_ _23891_/D _23891_/Q _21781_/A1 _21781_/S VPWR VGND sg13g2_mux2_1
Xinput4407 _20098_/A3 data_rdata_i[7] VPWR VGND sg13g2_buf_1
XFILLER_35_150 VPWR VGND sg13g2_fill_1
Xinput4418 _17941_/B instr_rdata_i[12] VPWR VGND sg13g2_buf_1
XFILLER_35_161 VPWR VGND sg13g2_fill_2
XFILLER_58_1446 VPWR VGND sg13g2_decap_4
XFILLER_93_1337 VPWR VGND sg13g2_decap_8
XFILLER_91_790 VPWR VGND sg13g2_decap_8
Xinput4429 _18940_/A instr_rdata_i[22] VPWR VGND sg13g2_buf_1
XFILLER_93_1348 VPWR VGND sg13g2_fill_1
XFILLER_19_1419 VPWR VGND sg13g2_fill_1
XFILLER_24_846 VPWR VGND sg13g2_decap_8
X_23520_ _23520_/Q clkload40/A _23520_/D fanout2736/X VPWR VGND sg13g2_dfrbpq_1
X_20732_ _20732_/Y _20732_/A _20742_/B VPWR VGND sg13g2_nand2_1
XFILLER_23_334 VPWR VGND sg13g2_decap_4
XFILLER_35_194 VPWR VGND sg13g2_fill_2
XFILLER_17_1110 VPWR VGND sg13g2_decap_8
XFILLER_51_676 VPWR VGND sg13g2_decap_8
X_23451_ _23451_/Q clkload53/A _23451_/D fanout2787/X VPWR VGND sg13g2_dfrbpq_1
XFILLER_23_378 VPWR VGND sg13g2_fill_1
X_20663_ _23385_/D _21303_/A1 _20673_/B _20662_/Y VPWR VGND sg13g2_o21ai_1
XFILLER_91_1072 VPWR VGND sg13g2_decap_8
XFILLER_71_1646 VPWR VGND sg13g2_fill_1
XFILLER_51_28 VPWR VGND sg13g2_fill_2
XFILLER_91_1083 VPWR VGND sg13g2_fill_1
XFILLER_32_1608 VPWR VGND sg13g2_fill_1
XFILLER_36_1777 VPWR VGND sg13g2_fill_2
X_22402_ _22402_/Y _22402_/A _22402_/B VPWR VGND sg13g2_nand2_1
XFILLER_104_1124 VPWR VGND sg13g2_decap_8
X_23382_ _23382_/Q clkload54/A _23382_/D fanout2753/X VPWR VGND sg13g2_dfrbpq_1
XFILLER_13_1007 VPWR VGND sg13g2_fill_2
X_20594_ _20594_/Y _20594_/A _20600_/B VPWR VGND sg13g2_nand2_1
XFILLER_13_1018 VPWR VGND sg13g2_decap_4
X_22333_ _22333_/Y _24154_/Q _22335_/B VPWR VGND sg13g2_nand2_1
XFILLER_87_1108 VPWR VGND sg13g2_decap_4
XFILLER_10_1928 VPWR VGND sg13g2_decap_8
X_22264_ _24120_/D _22264_/A1 _22263_/B _22263_/Y VPWR VGND sg13g2_o21ai_1
XFILLER_69_1553 VPWR VGND sg13g2_fill_1
XFILLER_2_205 VPWR VGND sg13g2_fill_1
XFILLER_3_728 VPWR VGND sg13g2_decap_8
X_24003_ _24003_/Q _24131_/CLK _24003_/D fanout2745/X VPWR VGND sg13g2_dfrbpq_1
X_21215_ _21215_/Y _21215_/A _21215_/B VPWR VGND sg13g2_nand2_1
X_22195_ _22195_/Y _22195_/A _22203_/B VPWR VGND sg13g2_nand2_1
XFILLER_4_7 VPWR VGND sg13g2_decap_8
XFILLER_105_656 VPWR VGND sg13g2_fill_2
X_21146_ _23598_/D _21345_/A1 _21154_/B _21145_/Y VPWR VGND sg13g2_o21ai_1
XFILLER_63_1130 VPWR VGND sg13g2_fill_1
XFILLER_76_14 VPWR VGND sg13g2_decap_8
XFILLER_115_1220 VPWR VGND sg13g2_decap_8
XFILLER_104_199 VPWR VGND sg13g2_decap_8
XFILLER_59_743 VPWR VGND sg13g2_decap_8
X_21077_ _23569_/D _23569_/Q _20312_/Y _21082_/B VPWR VGND sg13g2_mux2_1
XFILLER_82_1786 VPWR VGND sg13g2_decap_8
XFILLER_43_1737 VPWR VGND sg13g2_decap_4
XFILLER_8_1366 VPWR VGND sg13g2_fill_1
XFILLER_28_1294 VPWR VGND sg13g2_fill_1
XFILLER_47_905 VPWR VGND sg13g2_fill_2
X_20028_ _20028_/X _20028_/A _20028_/B VPWR VGND sg13g2_and2_1
XFILLER_100_350 VPWR VGND sg13g2_decap_8
XFILLER_24_1158 VPWR VGND sg13g2_decap_8
XFILLER_8_1399 VPWR VGND sg13g2_decap_4
XFILLER_24_1169 VPWR VGND sg13g2_decap_8
XFILLER_58_264 VPWR VGND sg13g2_fill_1
XFILLER_59_798 VPWR VGND sg13g2_decap_4
XFILLER_46_415 VPWR VGND sg13g2_fill_1
XFILLER_115_1297 VPWR VGND sg13g2_decap_8
XFILLER_46_426 VPWR VGND sg13g2_decap_8
XFILLER_74_735 VPWR VGND sg13g2_decap_8
XFILLER_74_746 VPWR VGND sg13g2_fill_1
X_12850_ _13081_/A _12852_/A _12852_/B VPWR VGND sg13g2_and2_1
XFILLER_41_1494 VPWR VGND sg13g2_decap_8
XFILLER_62_919 VPWR VGND sg13g2_decap_4
XFILLER_55_960 VPWR VGND sg13g2_decap_8
X_11801_ _11801_/X _23609_/Q _23673_/Q _12191_/S VPWR VGND sg13g2_mux2_1
X_12781_ _12781_/X _23748_/Q _23812_/Q _23876_/Q _23972_/Q _12877_/B _12498_/S VPWR
+ VGND sg13g2_mux4_1
X_21979_ _21979_/Y _23986_/Q _21982_/B VPWR VGND sg13g2_nand2_1
XFILLER_70_930 VPWR VGND sg13g2_fill_1
XFILLER_26_172 VPWR VGND sg13g2_decap_8
X_14520_ _14521_/A _16365_/A _14520_/B VPWR VGND sg13g2_nor2_1
X_11732_ _11732_/Y _12266_/A _11732_/B VPWR VGND sg13g2_nor2_1
X_23718_ _23718_/Q clkload40/A _23718_/D fanout2735/X VPWR VGND sg13g2_dfrbpq_1
XFILLER_70_941 VPWR VGND sg13g2_fill_1
X_11663_ _11867_/B _13296_/A _14618_/B VPWR VGND sg13g2_xnor2_1
X_23649_ _23649_/Q _23682_/CLK _23649_/D fanout2728/X VPWR VGND sg13g2_dfrbpq_1
XFILLER_41_164 VPWR VGND sg13g2_decap_8
XFILLER_106_1923 VPWR VGND sg13g2_decap_8
X_13402_ _13403_/B _14134_/D _13402_/B VPWR VGND sg13g2_nor2_1
X_17170_ _22737_/D _17220_/B _17168_/Y _17169_/Y VPWR VGND sg13g2_a21oi_1
X_14382_ _16786_/A _14382_/A VPWR VGND sg13g2_inv_1
X_11594_ _11594_/X _11861_/B _11594_/B VPWR VGND sg13g2_and2_1
X_16121_ _16121_/Y _16121_/A _16132_/B VPWR VGND sg13g2_nand2_1
X_13333_ _13333_/Y _13333_/A VPWR VGND sg13g2_inv_1
XFILLER_13_1552 VPWR VGND sg13g2_decap_8
XFILLER_41_94 VPWR VGND sg13g2_decap_8
X_16052_ _16052_/Y _16052_/A _17386_/B VPWR VGND sg13g2_nand2_1
X_13264_ _13264_/Y _23690_/Q _13264_/B VPWR VGND sg13g2_nand2b_1
X_15003_ _15003_/Y _15073_/A _23143_/Q VPWR VGND sg13g2_nand2_1
X_12215_ _12218_/C _12473_/A _12215_/B VPWR VGND sg13g2_nor2_1
XFILLER_29_1003 VPWR VGND sg13g2_decap_8
X_13195_ _13196_/B _23433_/Q _23465_/Q _23497_/Q _23529_/Q _13961_/S0 _13797_/S VPWR
+ VGND sg13g2_mux4_1
XFILLER_29_1025 VPWR VGND sg13g2_decap_8
XFILLER_100_1599 VPWR VGND sg13g2_fill_1
XFILLER_83_1539 VPWR VGND sg13g2_fill_2
X_19811_ _19811_/Y _19996_/B2 _19809_/Y _19810_/Y VPWR VGND sg13g2_a21oi_1
XFILLER_68_1096 VPWR VGND sg13g2_decap_8
XFILLER_111_604 VPWR VGND sg13g2_decap_8
X_12146_ _12146_/X _23804_/Q _23964_/Q _12146_/S VPWR VGND sg13g2_mux2_1
XFILLER_97_827 VPWR VGND sg13g2_fill_1
Xfanout2720 fanout2720/X fanout2721/X VPWR VGND sg13g2_buf_1
XFILLER_9_1119 VPWR VGND sg13g2_fill_1
XFILLER_26_1902 VPWR VGND sg13g2_decap_8
Xfanout2731 fanout2731/X fanout2742/X VPWR VGND sg13g2_buf_1
XFILLER_26_1913 VPWR VGND sg13g2_fill_1
Xfanout2742 fanout2742/X fanout2743/X VPWR VGND sg13g2_buf_1
XFILLER_81_1230 VPWR VGND sg13g2_decap_8
XFILLER_61_1804 VPWR VGND sg13g2_decap_8
Xfanout2753 fanout2753/X fanout2768/X VPWR VGND sg13g2_buf_1
XFILLER_81_1241 VPWR VGND sg13g2_fill_1
Xfanout2764 fanout2764/X fanout2766/X VPWR VGND sg13g2_buf_1
X_19742_ _19742_/Y _23208_/Q _19781_/A2 _19781_/B1 _23200_/Q VPWR VGND sg13g2_a22oi_1
X_16954_ _16980_/C _16954_/A _16954_/B _16954_/C _16954_/D VPWR VGND sg13g2_nor4_1
X_12077_ _19804_/A _12088_/A _14304_/C VPWR VGND sg13g2_nand2_1
Xfanout2775 fanout2775/X fanout2776/X VPWR VGND sg13g2_buf_1
Xfanout2786 fanout2786/X fanout2790/X VPWR VGND sg13g2_buf_1
XFILLER_81_1274 VPWR VGND sg13g2_fill_1
XFILLER_110_147 VPWR VGND sg13g2_decap_8
Xfanout2797 fanout2797/X fanout2799/X VPWR VGND sg13g2_buf_1
XFILLER_113_1927 VPWR VGND sg13g2_decap_8
XFILLER_42_1247 VPWR VGND sg13g2_decap_8
X_15905_ _15905_/Y _15905_/A _15905_/B VPWR VGND sg13g2_nor2_1
XFILLER_77_562 VPWR VGND sg13g2_fill_1
X_19673_ _19673_/Y _19673_/A _19673_/B _19930_/B VPWR VGND sg13g2_nand3_1
XFILLER_42_1258 VPWR VGND sg13g2_fill_1
X_16885_ _16885_/Y _15375_/Y _17032_/B VPWR VGND sg13g2_nand2b_1
XFILLER_92_510 VPWR VGND sg13g2_decap_8
XFILLER_2_77 VPWR VGND sg13g2_fill_2
XFILLER_42_1269 VPWR VGND sg13g2_decap_8
XFILLER_20_1501 VPWR VGND sg13g2_decap_8
XFILLER_38_949 VPWR VGND sg13g2_fill_1
XFILLER_49_286 VPWR VGND sg13g2_decap_8
XFILLER_92_532 VPWR VGND sg13g2_decap_8
XFILLER_4_1753 VPWR VGND sg13g2_decap_8
X_18624_ _18624_/Y _23003_/Q _18624_/B VPWR VGND sg13g2_xnor2_1
X_15836_ _15837_/D _22610_/Q _15964_/A2 _15835_/Y VPWR VGND sg13g2_a21oi_1
XFILLER_65_757 VPWR VGND sg13g2_decap_8
XFILLER_37_459 VPWR VGND sg13g2_decap_8
XFILLER_64_245 VPWR VGND sg13g2_decap_8
XFILLER_65_768 VPWR VGND sg13g2_fill_1
XFILLER_59_1711 VPWR VGND sg13g2_decap_8
XFILLER_52_407 VPWR VGND sg13g2_decap_8
XFILLER_111_1684 VPWR VGND sg13g2_fill_1
XFILLER_18_673 VPWR VGND sg13g2_fill_1
X_18555_ _18555_/X _18555_/A _18555_/B VPWR VGND sg13g2_or2_1
XFILLER_64_278 VPWR VGND sg13g2_fill_1
X_15767_ _15771_/A _22502_/Q _15767_/B VPWR VGND sg13g2_nand2_1
X_12979_ _12979_/X _13276_/A _12979_/B VPWR VGND sg13g2_or2_1
XFILLER_61_930 VPWR VGND sg13g2_fill_1
XFILLER_73_790 VPWR VGND sg13g2_decap_8
X_17506_ _22870_/D _16203_/A _17507_/S _17505_/Y VPWR VGND sg13g2_o21ai_1
XFILLER_61_941 VPWR VGND sg13g2_decap_8
X_14718_ _14718_/Y _14718_/A _14718_/B VPWR VGND sg13g2_nand2_1
XFILLER_59_1788 VPWR VGND sg13g2_fill_1
XFILLER_75_1045 VPWR VGND sg13g2_decap_8
X_18486_ _18486_/Y _18245_/B _18484_/Y _18485_/Y VPWR VGND sg13g2_a21oi_1
XFILLER_32_131 VPWR VGND sg13g2_decap_4
X_15698_ _15699_/B _22499_/Q _15698_/A2 _15347_/Y _22873_/Q VPWR VGND sg13g2_a22oi_1
XFILLER_72_1911 VPWR VGND sg13g2_decap_8
XFILLER_33_676 VPWR VGND sg13g2_decap_8
XFILLER_33_687 VPWR VGND sg13g2_fill_2
X_17437_ _17437_/Y _17437_/A _17437_/B VPWR VGND sg13g2_nand2_1
X_14649_ _14649_/Y _14649_/A _14694_/B VPWR VGND sg13g2_nand2_1
XFILLER_20_315 VPWR VGND sg13g2_decap_8
Xplace4304 _12921_/S _12997_/S VPWR VGND sg13g2_buf_4
XFILLER_57_1490 VPWR VGND sg13g2_decap_8
XFILLER_21_849 VPWR VGND sg13g2_decap_8
XFILLER_60_484 VPWR VGND sg13g2_decap_4
Xplace4315 _12246_/S _12248_/S VPWR VGND sg13g2_buf_2
XFILLER_20_326 VPWR VGND sg13g2_decap_8
Xrebuffer5305 _11875_/B _11776_/B1 VPWR VGND sg13g2_buf_1
Xplace4326 _12293_/A _12453_/S VPWR VGND sg13g2_buf_4
Xplace4337 _14434_/A _14117_/A VPWR VGND sg13g2_buf_1
Xrebuffer5316 _13757_/B _13932_/B VPWR VGND sg13g2_buf_1
Xrebuffer5327 _11819_/B _11818_/Y VPWR VGND sg13g2_buf_8
XFILLER_18_1485 VPWR VGND sg13g2_decap_4
Xplace3603 _14825_/A place3603/A VPWR VGND sg13g2_buf_1
X_17368_ _22811_/D _16197_/A _17367_/B _17367_/Y VPWR VGND sg13g2_o21ai_1
Xplace4348 _17687_/A _17622_/A VPWR VGND sg13g2_buf_1
Xplace3614 _16244_/B _14828_/A VPWR VGND sg13g2_buf_1
Xrebuffer5338 _18599_/A1 _19611_/A VPWR VGND sg13g2_buf_1
Xplace3625 _15487_/B1 _16681_/B VPWR VGND sg13g2_buf_1
Xrebuffer4604 _14019_/B place3794/A VPWR VGND sg13g2_buf_1
X_19107_ _23089_/D _23089_/Q _19106_/X _19115_/S VPWR VGND sg13g2_mux2_1
Xrebuffer5349 _21981_/S place3057/A VPWR VGND sg13g2_buf_2
Xplace3636 _18679_/A2 _15025_/B VPWR VGND sg13g2_buf_1
X_16319_ _22539_/D _16324_/A _16319_/B VPWR VGND sg13g2_xnor2_1
Xrebuffer4615 _11441_/S _11317_/Y VPWR VGND sg13g2_buf_1
XFILLER_88_1417 VPWR VGND sg13g2_decap_8
Xplace3647 _14714_/A2 _14694_/B VPWR VGND sg13g2_buf_1
Xrebuffer4626 _14696_/A _12387_/B VPWR VGND sg13g2_buf_1
XFILLER_9_393 VPWR VGND sg13g2_decap_8
X_17299_ _22779_/D _16197_/A _17298_/B _17298_/Y VPWR VGND sg13g2_o21ai_1
Xplace3658 _16205_/B _16209_/B VPWR VGND sg13g2_buf_1
Xplace3669 _15898_/A2 _15901_/A2 VPWR VGND sg13g2_buf_1
Xhold5006 _21949_/A _23969_/Q VPWR VGND sg13g2_dlygate4sd3_1
XFILLER_63_0 VPWR VGND sg13g2_decap_8
X_19038_ _23060_/D _19032_/Y _19035_/Y _19036_/Y _19037_/Y VPWR VGND sg13g2_a22oi_1
Xhold5017 _21820_/A _23907_/Q VPWR VGND sg13g2_dlygate4sd3_1
Xhold5028 _21160_/A _23605_/Q VPWR VGND sg13g2_dlygate4sd3_1
Xplace2946 _18869_/B _18793_/B VPWR VGND sg13g2_buf_1
XFILLER_12_1073 VPWR VGND sg13g2_fill_1
Xplace2957 _17004_/B _17019_/A VPWR VGND sg13g2_buf_1
Xhold5039 _21653_/A _23840_/Q VPWR VGND sg13g2_dlygate4sd3_1
Xplace2968 _18623_/A _16417_/B VPWR VGND sg13g2_buf_1
Xplace2979 _18119_/S _18535_/B VPWR VGND sg13g2_buf_1
XFILLER_66_1726 VPWR VGND sg13g2_decap_8
XFILLER_47_1114 VPWR VGND sg13g2_fill_2
XFILLER_114_431 VPWR VGND sg13g2_decap_8
X_21000_ _21000_/Y _21000_/A _21013_/B VPWR VGND sg13g2_nand2_1
XFILLER_86_1185 VPWR VGND sg13g2_decap_8
XFILLER_0_709 VPWR VGND sg13g2_fill_2
XFILLER_86_1196 VPWR VGND sg13g2_fill_2
XFILLER_47_1147 VPWR VGND sg13g2_fill_1
XFILLER_99_175 VPWR VGND sg13g2_decap_8
XFILLER_47_1169 VPWR VGND sg13g2_decap_8
XFILLER_68_540 VPWR VGND sg13g2_fill_1
X_22951_ _22951_/Q _24212_/CLK _22951_/D fanout2919/X VPWR VGND sg13g2_dfrbpq_1
XFILLER_68_573 VPWR VGND sg13g2_decap_4
XFILLER_21_1309 VPWR VGND sg13g2_decap_4
XFILLER_56_724 VPWR VGND sg13g2_decap_8
XFILLER_95_370 VPWR VGND sg13g2_decap_8
XFILLER_25_1489 VPWR VGND sg13g2_decap_4
XFILLER_60_1369 VPWR VGND sg13g2_fill_2
XFILLER_95_381 VPWR VGND sg13g2_fill_1
XFILLER_99_1557 VPWR VGND sg13g2_fill_1
X_21902_ _21902_/Y _21902_/A _21910_/B VPWR VGND sg13g2_nand2_1
XFILLER_28_448 VPWR VGND sg13g2_decap_8
XFILLER_56_757 VPWR VGND sg13g2_fill_2
X_22882_ _22882_/Q _22917_/CLK _22882_/D fanout2892/X VPWR VGND sg13g2_dfrbpq_1
XFILLER_3_1263 VPWR VGND sg13g2_decap_8
X_21833_ _21833_/Y _21833_/A _21833_/B VPWR VGND sg13g2_nand2_1
XFILLER_71_727 VPWR VGND sg13g2_fill_1
XFILLER_93_1101 VPWR VGND sg13g2_decap_4
XFILLER_93_1123 VPWR VGND sg13g2_decap_8
XFILLER_24_621 VPWR VGND sg13g2_decap_4
XFILLER_102_56 VPWR VGND sg13g2_decap_8
XFILLER_19_1216 VPWR VGND sg13g2_fill_1
X_21764_ _21764_/Y _21764_/A _21771_/B VPWR VGND sg13g2_nand2_1
XFILLER_54_1107 VPWR VGND sg13g2_decap_8
XFILLER_51_451 VPWR VGND sg13g2_fill_2
X_23503_ _23503_/Q clkload50/A _23503_/D fanout2654/X VPWR VGND sg13g2_dfrbpq_1
X_20715_ _21289_/C _22050_/B _22050_/C VPWR VGND sg13g2_nor2b_1
XFILLER_12_849 VPWR VGND sg13g2_decap_8
XFILLER_23_197 VPWR VGND sg13g2_decap_8
X_23434_ _23434_/Q _24196_/CLK _23434_/D fanout2704/X VPWR VGND sg13g2_dfrbpq_1
X_20646_ _23379_/D _22315_/A0 _23379_/Q _20646_/S VPWR VGND sg13g2_mux2_1
XFILLER_109_203 VPWR VGND sg13g2_decap_8
X_23365_ _23365_/Q clkload33/A _23365_/D fanout2701/X VPWR VGND sg13g2_dfrbpq_1
X_20577_ _23345_/D _23345_/Q _22446_/A1 _20580_/S VPWR VGND sg13g2_mux2_1
XFILLER_14_1872 VPWR VGND sg13g2_decap_8
X_22316_ _22316_/Y _24148_/Q _22316_/B VPWR VGND sg13g2_nand2_1
XFILLER_3_503 VPWR VGND sg13g2_fill_2
X_23296_ _23296_/Q _23682_/CLK _23296_/D fanout2722/X VPWR VGND sg13g2_dfrbpq_1
XFILLER_3_525 VPWR VGND sg13g2_decap_8
XFILLER_10_1769 VPWR VGND sg13g2_fill_1
XFILLER_3_536 VPWR VGND sg13g2_fill_1
XFILLER_30_1195 VPWR VGND sg13g2_decap_8
X_22247_ _22247_/Y _24114_/Q _22247_/B VPWR VGND sg13g2_nand2_1
XFILLER_69_1372 VPWR VGND sg13g2_decap_4
X_12000_ _12003_/B _12002_/C _12084_/C VPWR VGND sg13g2_nor2_1
XFILLER_3_569 VPWR VGND sg13g2_decap_8
Xhold4850 _20395_/A _23262_/Q VPWR VGND sg13g2_dlygate4sd3_1
Xhold4861 _21504_/A _23769_/Q VPWR VGND sg13g2_dlygate4sd3_1
X_22178_ _22178_/Y _22178_/A _22184_/B VPWR VGND sg13g2_nand2_1
Xhold4872 _22013_/A _24000_/Q VPWR VGND sg13g2_dlygate4sd3_1
XFILLER_78_326 VPWR VGND sg13g2_decap_8
Xhold4883 _22450_/A _24212_/Q VPWR VGND sg13g2_dlygate4sd3_1
Xhold4894 _21038_/A _23554_/Q VPWR VGND sg13g2_dlygate4sd3_1
X_21129_ _23589_/D _21329_/A1 _21130_/B _21128_/Y VPWR VGND sg13g2_o21ai_1
XFILLER_87_871 VPWR VGND sg13g2_fill_2
XFILLER_47_702 VPWR VGND sg13g2_decap_8
XFILLER_19_404 VPWR VGND sg13g2_decap_8
XFILLER_47_713 VPWR VGND sg13g2_fill_2
X_13951_ _13952_/D _13951_/A _13951_/B _13951_/C VPWR VGND sg13g2_nor3_1
XFILLER_115_1072 VPWR VGND sg13g2_decap_8
XFILLER_101_670 VPWR VGND sg13g2_decap_4
XFILLER_4_1027 VPWR VGND sg13g2_fill_1
XFILLER_74_521 VPWR VGND sg13g2_decap_8
X_12902_ _12902_/X _23589_/Q _23621_/Q _23653_/Q _23685_/Q _13004_/S0 _13004_/S1 VPWR
+ VGND sg13g2_mux4_1
XFILLER_21_1832 VPWR VGND sg13g2_decap_8
X_16670_ _22649_/D _16197_/A _16673_/A _16669_/Y VPWR VGND sg13g2_a21oi_1
X_13882_ _13946_/A _20322_/A _13931_/B VPWR VGND sg13g2_xnor2_1
XFILLER_59_1007 VPWR VGND sg13g2_decap_8
XFILLER_28_960 VPWR VGND sg13g2_decap_8
XFILLER_59_1018 VPWR VGND sg13g2_fill_2
XFILLER_1_1937 VPWR VGND sg13g2_decap_8
X_15621_ _15621_/Y _22582_/Q _15306_/B _15986_/C1 VPWR VGND sg13g2_a21oi_1
X_12833_ _12845_/B _12837_/A _20064_/B VPWR VGND sg13g2_xnor2_1
XFILLER_27_470 VPWR VGND sg13g2_decap_8
XFILLER_15_621 VPWR VGND sg13g2_fill_1
XFILLER_36_72 VPWR VGND sg13g2_decap_4
XFILLER_55_790 VPWR VGND sg13g2_decap_4
XFILLER_15_632 VPWR VGND sg13g2_decap_8
XFILLER_43_941 VPWR VGND sg13g2_decap_8
XFILLER_91_1808 VPWR VGND sg13g2_decap_8
X_18340_ _18350_/A _18491_/A _18028_/Y _18339_/Y VPWR VGND sg13g2_a21oi_1
XFILLER_15_643 VPWR VGND sg13g2_fill_2
X_15552_ _15552_/X _22920_/Q _15552_/B VPWR VGND sg13g2_and2_1
X_12764_ _12764_/X _12852_/A _12764_/B VPWR VGND sg13g2_or2_1
XFILLER_91_1819 VPWR VGND sg13g2_fill_1
XFILLER_15_676 VPWR VGND sg13g2_decap_4
XFILLER_42_451 VPWR VGND sg13g2_decap_8
X_11715_ _11716_/D _12318_/A _11714_/X _12316_/A VPWR VGND sg13g2_o21ai_1
XFILLER_37_1349 VPWR VGND sg13g2_fill_2
X_14503_ _14507_/A _22600_/Q _23011_/Q VPWR VGND sg13g2_xor2_1
XFILLER_15_687 VPWR VGND sg13g2_decap_8
X_15483_ _15486_/A _22876_/Q _17517_/B VPWR VGND sg13g2_nand2_1
X_12695_ _12695_/Y _14629_/A _13035_/A2 _12668_/Y _12551_/X _12694_/Y VPWR VGND sg13g2_a221oi_1
XFILLER_19_1761 VPWR VGND sg13g2_decap_8
XFILLER_14_186 VPWR VGND sg13g2_fill_2
XFILLER_54_1652 VPWR VGND sg13g2_fill_2
X_17222_ _17229_/A _17226_/B _22747_/Q _17222_/C VPWR VGND sg13g2_nand3b_1
XFILLER_15_1614 VPWR VGND sg13g2_decap_8
XFILLER_19_1794 VPWR VGND sg13g2_fill_1
XFILLER_35_1051 VPWR VGND sg13g2_fill_2
X_14434_ _14434_/Y _14434_/A _14434_/B VPWR VGND sg13g2_nand2_1
XFILLER_54_1674 VPWR VGND sg13g2_decap_8
X_11646_ _11646_/X _19320_/B _13538_/B _11636_/Y VPWR VGND sg13g2_a21o_2
XFILLER_54_1685 VPWR VGND sg13g2_fill_1
X_14365_ _14365_/Y _15283_/C VPWR VGND sg13g2_inv_1
XFILLER_11_882 VPWR VGND sg13g2_decap_8
X_17153_ _17153_/Y _17153_/A _17182_/B VPWR VGND sg13g2_nor2_1
XFILLER_106_1797 VPWR VGND sg13g2_decap_8
XFILLER_32_1950 VPWR VGND sg13g2_decap_4
X_11577_ _11608_/B _22992_/Q _22993_/Q _14436_/A VPWR VGND sg13g2_nor3_1
X_13316_ _13316_/X _23435_/Q _23467_/Q _23499_/Q _23531_/Q _13676_/B _13686_/A VPWR
+ VGND sg13g2_mux4_1
X_16104_ _16104_/Y _22494_/Q _16119_/B _16103_/Y VPWR VGND sg13g2_a21oi_1
X_17084_ _17085_/B _17090_/A _17089_/B VPWR VGND sg13g2_nor2b_1
XFILLER_13_1360 VPWR VGND sg13g2_fill_1
XFILLER_6_352 VPWR VGND sg13g2_decap_8
XFILLER_109_770 VPWR VGND sg13g2_fill_1
X_14296_ _15233_/B _14138_/B _14296_/A2 _14295_/Y _14342_/A VPWR VGND sg13g2_a22oi_1
XFILLER_7_886 VPWR VGND sg13g2_decap_8
XFILLER_115_217 VPWR VGND sg13g2_decap_8
X_16035_ _17391_/B _16681_/A VPWR VGND sg13g2_inv_1
X_13247_ _13247_/Y _13227_/Y _13247_/B VPWR VGND sg13g2_nand2b_2
X_13178_ _13179_/D _11363_/B _13172_/X _13177_/Y VPWR VGND sg13g2_a21oi_1
XFILLER_111_401 VPWR VGND sg13g2_fill_2
XFILLER_48_1478 VPWR VGND sg13g2_fill_2
X_12129_ _12129_/Y _12788_/A _12129_/B _12129_/C VPWR VGND sg13g2_nand3_1
XFILLER_61_1612 VPWR VGND sg13g2_decap_8
XFILLER_112_968 VPWR VGND sg13g2_fill_2
Xclkbuf_leaf_70_clk_i clkload5/A clkbuf_leaf_0_clk_i/A VPWR VGND sg13g2_buf_16
X_17986_ _17986_/X _19017_/A _23059_/Q _17992_/S VPWR VGND sg13g2_mux2_1
XFILLER_61_1623 VPWR VGND sg13g2_fill_2
XFILLER_6_1826 VPWR VGND sg13g2_decap_8
X_16937_ _22697_/D _16927_/S _16935_/Y _16936_/Y VPWR VGND sg13g2_o21ai_1
XFILLER_81_1093 VPWR VGND sg13g2_decap_8
XFILLER_26_1776 VPWR VGND sg13g2_fill_2
XFILLER_77_370 VPWR VGND sg13g2_fill_2
XFILLER_38_746 VPWR VGND sg13g2_fill_1
X_19656_ _19656_/Y _20058_/A _19957_/B VPWR VGND sg13g2_nand2_1
XFILLER_93_874 VPWR VGND sg13g2_decap_8
XFILLER_53_716 VPWR VGND sg13g2_fill_2
XFILLER_92_362 VPWR VGND sg13g2_decap_8
XFILLER_20_1342 VPWR VGND sg13g2_decap_4
X_18607_ _18607_/Y _18607_/A _18606_/Y VPWR VGND sg13g2_nor2b_1
XFILLER_52_204 VPWR VGND sg13g2_decap_4
X_19587_ _19587_/Y _19587_/A _19587_/B VPWR VGND sg13g2_nor2_1
XFILLER_92_384 VPWR VGND sg13g2_fill_1
XFILLER_65_598 VPWR VGND sg13g2_decap_4
XFILLER_80_535 VPWR VGND sg13g2_fill_1
X_16799_ _16799_/Y _16830_/A _16799_/B VPWR VGND sg13g2_nand2_1
XFILLER_94_1432 VPWR VGND sg13g2_decap_8
XFILLER_94_1454 VPWR VGND sg13g2_decap_8
X_18538_ _18538_/X _17986_/X _18537_/X _18538_/S VPWR VGND sg13g2_mux2_1
XFILLER_0_1469 VPWR VGND sg13g2_fill_1
XFILLER_94_1465 VPWR VGND sg13g2_fill_1
XFILLER_33_451 VPWR VGND sg13g2_decap_8
XFILLER_61_760 VPWR VGND sg13g2_fill_1
XFILLER_94_1487 VPWR VGND sg13g2_decap_8
XFILLER_107_1517 VPWR VGND sg13g2_decap_4
XFILLER_21_624 VPWR VGND sg13g2_decap_4
X_18469_ _18469_/Y _18564_/A1 _18465_/C _18464_/Y _18385_/B _18468_/Y VPWR VGND sg13g2_a221oi_1
Xplace4101 _18473_/S _18549_/S VPWR VGND sg13g2_buf_1
XFILLER_20_112 VPWR VGND sg13g2_fill_1
XFILLER_60_281 VPWR VGND sg13g2_fill_2
X_20500_ _20500_/Y _23310_/Q _20500_/B VPWR VGND sg13g2_nand2_1
Xplace4112 _14144_/C _22988_/Q VPWR VGND sg13g2_buf_1
XFILLER_20_134 VPWR VGND sg13g2_fill_2
Xplace4123 _14146_/B _11712_/B VPWR VGND sg13g2_buf_1
X_21480_ _21480_/Y _23758_/Q _21483_/B VPWR VGND sg13g2_nand2_1
XFILLER_21_679 VPWR VGND sg13g2_decap_8
Xplace4134 _13702_/A _11456_/B VPWR VGND sg13g2_buf_2
Xplace3400 _17432_/S _17437_/B VPWR VGND sg13g2_buf_1
XFILLER_20_156 VPWR VGND sg13g2_decap_8
XFILLER_72_1796 VPWR VGND sg13g2_fill_1
Xplace4145 _11456_/B _22986_/Q VPWR VGND sg13g2_buf_8
Xplace3411 _17262_/B _17246_/B VPWR VGND sg13g2_buf_1
XFILLER_20_167 VPWR VGND sg13g2_fill_1
Xplace4156 _13955_/S _13565_/A VPWR VGND sg13g2_buf_2
Xplace4167 _11714_/S _11508_/S0 VPWR VGND sg13g2_buf_1
X_20431_ _23281_/D _20312_/Y _23281_/Q _20434_/S VPWR VGND sg13g2_mux2_1
XFILLER_20_178 VPWR VGND sg13g2_fill_1
Xplace3422 _16514_/B _16517_/S VPWR VGND sg13g2_buf_1
XFILLER_105_1263 VPWR VGND sg13g2_fill_2
Xplace3433 _17316_/A1 _16058_/A VPWR VGND sg13g2_buf_1
XFILLER_14_1146 VPWR VGND sg13g2_decap_8
Xplace4178 _12321_/S _12789_/S VPWR VGND sg13g2_buf_1
Xplace4189 _11797_/S _11449_/B VPWR VGND sg13g2_buf_1
Xplace3444 _17825_/B _17721_/B VPWR VGND sg13g2_buf_1
Xplace3455 _17182_/B _17226_/A VPWR VGND sg13g2_buf_1
Xplace3466 _16755_/A _16760_/A VPWR VGND sg13g2_buf_1
XFILLER_88_1236 VPWR VGND sg13g2_fill_1
Xclkbuf_leaf_23_clk_i _24205_/CLK clkbuf_leaf_43_clk_i/A VPWR VGND sg13g2_buf_16
X_23150_ _23150_/Q clkload14/A _23150_/D fanout2842/X VPWR VGND sg13g2_dfrbpq_1
Xplace3477 _16610_/A _16673_/A VPWR VGND sg13g2_buf_1
X_20362_ _20362_/Y _20362_/A1 _20352_/Y _20361_/Y VPWR VGND sg13g2_a21oi_1
Xplace3488 _16020_/B _16000_/S VPWR VGND sg13g2_buf_1
Xplace3499 _16927_/S _16921_/S VPWR VGND sg13g2_buf_1
X_22101_ _22101_/Y _22101_/A _22101_/B VPWR VGND sg13g2_nand2_1
X_23081_ _23081_/Q clkload12/A _23081_/D fanout2909/X VPWR VGND sg13g2_dfrbpq_1
XFILLER_115_740 VPWR VGND sg13g2_decap_8
X_20293_ _20296_/C _19597_/X _20291_/Y _20292_/Y _20290_/B VPWR VGND sg13g2_a22oi_1
XFILLER_27_1507 VPWR VGND sg13g2_fill_1
X_22032_ _22032_/Y _22032_/A _22039_/B VPWR VGND sg13g2_nand2_1
XFILLER_0_539 VPWR VGND sg13g2_fill_2
Xclkbuf_leaf_38_clk_i _24190_/CLK clkbuf_leaf_42_clk_i/A VPWR VGND sg13g2_buf_16
XFILLER_60_1100 VPWR VGND sg13g2_fill_1
XFILLER_9_1461 VPWR VGND sg13g2_decap_4
XFILLER_29_702 VPWR VGND sg13g2_decap_8
XFILLER_57_49 VPWR VGND sg13g2_decap_8
XFILLER_9_1483 VPWR VGND sg13g2_decap_8
X_23983_ _23983_/Q clkload31/A _23983_/D fanout2655/X VPWR VGND sg13g2_dfrbpq_1
XFILLER_29_724 VPWR VGND sg13g2_decap_8
XFILLER_40_1718 VPWR VGND sg13g2_decap_8
XFILLER_69_893 VPWR VGND sg13g2_decap_8
XFILLER_5_1336 VPWR VGND sg13g2_decap_8
XFILLER_99_1332 VPWR VGND sg13g2_fill_2
XFILLER_84_852 VPWR VGND sg13g2_decap_4
X_22934_ _22934_/Q _22941_/CLK _22934_/D fanout2795/X VPWR VGND sg13g2_dfrbpq_1
XFILLER_28_234 VPWR VGND sg13g2_decap_8
XFILLER_112_1267 VPWR VGND sg13g2_decap_8
XFILLER_17_919 VPWR VGND sg13g2_decap_8
XFILLER_56_565 VPWR VGND sg13g2_decap_8
XFILLER_112_1278 VPWR VGND sg13g2_decap_4
XFILLER_95_1229 VPWR VGND sg13g2_decap_4
XFILLER_28_278 VPWR VGND sg13g2_decap_8
XFILLER_43_204 VPWR VGND sg13g2_decap_8
XFILLER_113_77 VPWR VGND sg13g2_decap_8
X_22865_ _22865_/Q clkload7/A _22865_/D fanout2794/X VPWR VGND sg13g2_dfrbpq_1
XFILLER_43_215 VPWR VGND sg13g2_fill_2
XFILLER_77_1641 VPWR VGND sg13g2_decap_8
XFILLER_43_237 VPWR VGND sg13g2_decap_8
X_21816_ _21816_/Y _21816_/A _21826_/B VPWR VGND sg13g2_nand2_1
XFILLER_58_1051 VPWR VGND sg13g2_decap_8
XFILLER_71_568 VPWR VGND sg13g2_decap_8
XFILLER_19_1013 VPWR VGND sg13g2_fill_2
X_22796_ _22796_/Q clkload19/A _22796_/D fanout2862/X VPWR VGND sg13g2_dfrbpq_1
XFILLER_73_1527 VPWR VGND sg13g2_decap_8
XFILLER_19_1035 VPWR VGND sg13g2_fill_1
XFILLER_25_996 VPWR VGND sg13g2_decap_8
XFILLER_73_1538 VPWR VGND sg13g2_fill_2
XFILLER_52_782 VPWR VGND sg13g2_decap_8
XFILLER_19_1057 VPWR VGND sg13g2_decap_8
XFILLER_90_1841 VPWR VGND sg13g2_fill_2
XFILLER_16_1912 VPWR VGND sg13g2_decap_8
XFILLER_11_112 VPWR VGND sg13g2_fill_2
X_11500_ _11500_/X _14852_/A _22971_/Q _11500_/S VPWR VGND sg13g2_mux2_1
XFILLER_12_657 VPWR VGND sg13g2_decap_8
X_12480_ _12505_/A _12480_/A _12480_/B _12480_/C _12480_/D VPWR VGND sg13g2_nor4_1
X_21678_ _21678_/Y _23852_/Q _21687_/B VPWR VGND sg13g2_nand2_1
XFILLER_90_1885 VPWR VGND sg13g2_decap_8
XFILLER_36_1382 VPWR VGND sg13g2_decap_8
XFILLER_7_116 VPWR VGND sg13g2_decap_4
X_23417_ _23417_/Q clkload53/A _23417_/D fanout2779/X VPWR VGND sg13g2_dfrbpq_1
X_11431_ _11431_/X _23350_/Q _23382_/Q _11749_/S VPWR VGND sg13g2_mux2_1
XFILLER_11_178 VPWR VGND sg13g2_decap_8
X_20629_ _23368_/D _21964_/A0 _23368_/Q _20640_/S VPWR VGND sg13g2_mux2_1
XFILLER_7_149 VPWR VGND sg13g2_decap_8
XFILLER_22_74 VPWR VGND sg13g2_decap_8
XFILLER_22_85 VPWR VGND sg13g2_fill_1
X_23348_ _23348_/Q _24214_/CLK _23348_/D fanout2628/X VPWR VGND sg13g2_dfrbpq_1
X_13101_ _13101_/Y _12942_/X _13748_/C _13086_/X _13085_/Y _14060_/A VPWR VGND sg13g2_a221oi_1
X_14081_ _14107_/A _14081_/A _14081_/B VPWR VGND sg13g2_nand2_1
X_11293_ _11293_/X _23415_/Q _23447_/Q _23479_/Q _23511_/Q _11477_/A _11714_/S VPWR
+ VGND sg13g2_mux4_1
XFILLER_98_56 VPWR VGND sg13g2_decap_8
X_23279_ _23279_/Q clkload32/A _23279_/D fanout2648/X VPWR VGND sg13g2_dfrbpq_1
XFILLER_79_602 VPWR VGND sg13g2_decap_4
X_13032_ _13032_/X _13552_/A _13032_/B VPWR VGND sg13g2_or2_1
XFILLER_3_366 VPWR VGND sg13g2_fill_1
XFILLER_49_1787 VPWR VGND sg13g2_decap_8
XFILLER_79_646 VPWR VGND sg13g2_fill_2
Xhold4680 _16519_/A _22619_/Q VPWR VGND sg13g2_dlygate4sd3_1
X_17840_ _17840_/Y _22911_/Q _17853_/B _17849_/C VPWR VGND sg13g2_nand3_1
Xhold4691 _17264_/A _22762_/Q VPWR VGND sg13g2_dlygate4sd3_1
XFILLER_79_679 VPWR VGND sg13g2_fill_1
XFILLER_78_145 VPWR VGND sg13g2_decap_8
XFILLER_66_318 VPWR VGND sg13g2_fill_2
X_17771_ _17771_/Y _23180_/Q _17801_/A2 _17822_/B1 _14144_/C VPWR VGND sg13g2_a22oi_1
X_14983_ _14983_/X _14065_/A _13075_/B _14880_/B VPWR VGND sg13g2_a21o_2
XFILLER_110_1908 VPWR VGND sg13g2_decap_8
X_16722_ _16723_/B _22659_/Q _16726_/C VPWR VGND sg13g2_nand2_1
XFILLER_47_60 VPWR VGND sg13g2_fill_1
X_13934_ _13935_/A _13934_/A _13934_/B VPWR VGND sg13g2_nor2_1
XFILLER_78_1427 VPWR VGND sg13g2_decap_8
X_19441_ _19441_/X _20290_/A _19460_/B VPWR VGND sg13g2_and2_1
XFILLER_74_362 VPWR VGND sg13g2_decap_8
XFILLER_1_1734 VPWR VGND sg13g2_decap_8
X_16653_ _22645_/D _16500_/Y _16656_/A _16652_/Y VPWR VGND sg13g2_a21oi_1
XFILLER_47_598 VPWR VGND sg13g2_decap_8
X_13865_ _13876_/A _13857_/Y _13860_/Y _13861_/Y _13864_/Y VPWR VGND sg13g2_a22oi_1
XFILLER_35_749 VPWR VGND sg13g2_fill_1
XFILLER_56_1703 VPWR VGND sg13g2_decap_8
X_15604_ _15606_/C _22599_/Q _15317_/Y _15306_/B _22581_/Q VPWR VGND sg13g2_a22oi_1
X_19372_ _19372_/Y _15491_/A _19463_/S _19371_/Y VPWR VGND sg13g2_a21oi_1
X_12816_ _12816_/Y _12816_/A _12816_/B VPWR VGND sg13g2_nand2_1
X_16584_ _22631_/D _17869_/A _16591_/A _16583_/Y VPWR VGND sg13g2_a21oi_1
XFILLER_15_440 VPWR VGND sg13g2_fill_2
X_13796_ _13796_/Y _13795_/X _13796_/B VPWR VGND sg13g2_nand2b_1
XFILLER_62_579 VPWR VGND sg13g2_decap_8
X_18323_ _18370_/B _18479_/D _18385_/D VPWR VGND sg13g2_and2_1
XFILLER_63_70 VPWR VGND sg13g2_decap_4
XFILLER_31_922 VPWR VGND sg13g2_decap_8
XFILLER_43_782 VPWR VGND sg13g2_decap_8
X_15535_ _15539_/B _15535_/A _15535_/B VPWR VGND sg13g2_nand2_1
XFILLER_37_1146 VPWR VGND sg13g2_decap_8
XFILLER_108_1848 VPWR VGND sg13g2_decap_8
XFILLER_30_421 VPWR VGND sg13g2_decap_8
XFILLER_63_92 VPWR VGND sg13g2_decap_4
XFILLER_42_281 VPWR VGND sg13g2_fill_2
X_18254_ _18254_/Y _18254_/A _18254_/B VPWR VGND sg13g2_nand2_1
XFILLER_31_966 VPWR VGND sg13g2_decap_8
XFILLER_19_1580 VPWR VGND sg13g2_decap_8
X_12678_ _12679_/B _24162_/Q _24194_/Q _23234_/Q _23266_/Q _13028_/A _13260_/A1 VPWR
+ VGND sg13g2_mux4_1
X_15466_ _15467_/C _15466_/A _15466_/B _15466_/C VPWR VGND sg13g2_nor3_1
XFILLER_15_1433 VPWR VGND sg13g2_decap_8
XFILLER_31_999 VPWR VGND sg13g2_decap_8
X_17205_ _17211_/B _17205_/A _17205_/B VPWR VGND sg13g2_nor2_1
XFILLER_30_476 VPWR VGND sg13g2_decap_8
X_14417_ _14471_/A _18030_/A VPWR VGND sg13g2_inv_1
X_11629_ _14154_/B _14122_/B _11309_/Y _11626_/X _11247_/B _11628_/Y VPWR VGND sg13g2_a221oi_1
X_18185_ _18194_/B _18172_/Y _18359_/B _18184_/Y VPWR VGND sg13g2_o21ai_1
X_15397_ _15399_/A _22882_/Q _15182_/X _17373_/A _22818_/Q VPWR VGND sg13g2_a22oi_1
XFILLER_89_1534 VPWR VGND sg13g2_decap_4
XFILLER_89_1545 VPWR VGND sg13g2_fill_1
XFILLER_11_1319 VPWR VGND sg13g2_decap_4
X_17136_ _22731_/D _17141_/B _17134_/Y _17135_/Y VPWR VGND sg13g2_a21oi_1
X_14348_ _14348_/Y _15393_/A _14340_/Y _14347_/Y VPWR VGND sg13g2_o21ai_1
XFILLER_89_1567 VPWR VGND sg13g2_fill_1
X_17067_ _17073_/D _22718_/Q _22717_/Q VPWR VGND sg13g2_nand2_1
X_14279_ _15140_/A _14279_/A _14290_/B _14290_/C VPWR VGND sg13g2_nand3_1
X_16018_ _17228_/B _16017_/A _15407_/Y _16017_/Y VPWR VGND sg13g2_o21ai_1
XFILLER_69_123 VPWR VGND sg13g2_decap_8
XFILLER_115_1819 VPWR VGND sg13g2_decap_8
XFILLER_112_754 VPWR VGND sg13g2_decap_8
XFILLER_97_443 VPWR VGND sg13g2_decap_8
XFILLER_111_231 VPWR VGND sg13g2_decap_8
XFILLER_85_605 VPWR VGND sg13g2_fill_2
XFILLER_6_1601 VPWR VGND sg13g2_decap_8
XFILLER_58_819 VPWR VGND sg13g2_fill_2
XFILLER_85_627 VPWR VGND sg13g2_fill_1
XFILLER_22_1404 VPWR VGND sg13g2_decap_4
X_17969_ _18530_/A _18393_/S _17966_/Y _17968_/Y VPWR VGND sg13g2_o21ai_1
XFILLER_69_189 VPWR VGND sg13g2_fill_1
XFILLER_113_1532 VPWR VGND sg13g2_decap_4
XFILLER_84_126 VPWR VGND sg13g2_decap_8
XFILLER_22_1415 VPWR VGND sg13g2_fill_1
XFILLER_113_1543 VPWR VGND sg13g2_fill_1
XFILLER_61_1475 VPWR VGND sg13g2_decap_8
X_19708_ _19708_/X _19562_/Y _19559_/X _19708_/S VPWR VGND sg13g2_mux2_1
X_20980_ _23534_/D _21345_/A1 _20983_/B _20979_/Y VPWR VGND sg13g2_o21ai_1
XFILLER_113_1576 VPWR VGND sg13g2_decap_4
XFILLER_81_800 VPWR VGND sg13g2_decap_8
XFILLER_66_874 VPWR VGND sg13g2_decap_8
XFILLER_38_576 VPWR VGND sg13g2_decap_8
X_19639_ _19639_/Y _19714_/S _19639_/B VPWR VGND sg13g2_nor2_1
XFILLER_38_587 VPWR VGND sg13g2_fill_2
XFILLER_66_896 VPWR VGND sg13g2_fill_2
XFILLER_26_738 VPWR VGND sg13g2_decap_8
XFILLER_65_384 VPWR VGND sg13g2_decap_8
XFILLER_39_1901 VPWR VGND sg13g2_fill_2
XFILLER_0_1244 VPWR VGND sg13g2_fill_2
X_22650_ _22650_/Q _22733_/CLK _22650_/D fanout2880/X VPWR VGND sg13g2_dfrbpq_1
XFILLER_25_248 VPWR VGND sg13g2_decap_8
XFILLER_20_1194 VPWR VGND sg13g2_decap_8
XFILLER_59_1360 VPWR VGND sg13g2_fill_1
XFILLER_94_1251 VPWR VGND sg13g2_decap_4
X_21601_ _23815_/D _21962_/A1 _21612_/B _21600_/Y VPWR VGND sg13g2_o21ai_1
XFILLER_59_1393 VPWR VGND sg13g2_decap_8
XFILLER_80_398 VPWR VGND sg13g2_fill_1
X_22581_ _22581_/Q clkload28/A _22581_/D fanout2870/X VPWR VGND sg13g2_dfrbpq_1
XFILLER_74_1869 VPWR VGND sg13g2_fill_1
XFILLER_33_1500 VPWR VGND sg13g2_fill_2
X_21532_ _21532_/Y _21532_/A _21534_/B VPWR VGND sg13g2_nand2_1
XFILLER_22_988 VPWR VGND sg13g2_decap_8
XFILLER_37_1691 VPWR VGND sg13g2_decap_8
X_24251_ _24251_/X _24251_/A VPWR VGND sg13g2_buf_1
X_21463_ _21463_/Y _21463_/A _21467_/B VPWR VGND sg13g2_nand2_1
Xplace3230 _21751_/B _21754_/B VPWR VGND sg13g2_buf_1
Xplace3241 _21175_/B _21215_/B VPWR VGND sg13g2_buf_1
X_23202_ _23202_/Q clkload33/A _23202_/D fanout2932/X VPWR VGND sg13g2_dfrbpq_1
X_20414_ _20414_/Y _20414_/A _20426_/B VPWR VGND sg13g2_nand2_1
Xplace3252 _21121_/B _21138_/B VPWR VGND sg13g2_buf_1
X_24182_ _24182_/Q clkload54/A _24182_/D fanout2752/X VPWR VGND sg13g2_dfrbpq_1
Xplace3263 _22314_/A1 _22448_/A1 VPWR VGND sg13g2_buf_1
X_21394_ _21394_/Y _23716_/Q _21398_/B VPWR VGND sg13g2_nand2_1
Xplace3274 _21965_/A0 _21336_/A0 VPWR VGND sg13g2_buf_1
Xplace3285 _22425_/A1 _20124_/Y VPWR VGND sg13g2_buf_1
XFILLER_107_548 VPWR VGND sg13g2_decap_8
XFILLER_11_1853 VPWR VGND sg13g2_decap_8
X_23133_ _23133_/Q clkload6/A _23133_/D fanout2833/X VPWR VGND sg13g2_dfrbpq_1
Xplace3296 _22416_/A1 _20022_/Y VPWR VGND sg13g2_buf_1
X_20345_ _21848_/A _20345_/A1 _20342_/Y _20344_/Y VPWR VGND sg13g2_o21ai_1
XFILLER_104_7 VPWR VGND sg13g2_decap_8
XFILLER_88_1088 VPWR VGND sg13g2_decap_8
XFILLER_85_1943 VPWR VGND sg13g2_decap_8
XFILLER_85_1954 VPWR VGND sg13g2_fill_1
X_23064_ _23064_/Q clkload14/A _23064_/D fanout2844/X VPWR VGND sg13g2_dfrbpq_1
XFILLER_108_77 VPWR VGND sg13g2_decap_8
X_20276_ _20276_/Y _24271_/A _20318_/B VPWR VGND sg13g2_nand2_1
XFILLER_0_325 VPWR VGND sg13g2_decap_4
X_22015_ _22015_/Y _22015_/A _22025_/B VPWR VGND sg13g2_nand2_1
XFILLER_49_808 VPWR VGND sg13g2_decap_8
XFILLER_103_765 VPWR VGND sg13g2_fill_2
XFILLER_102_242 VPWR VGND sg13g2_decap_8
XFILLER_44_1640 VPWR VGND sg13g2_decap_8
XFILLER_88_476 VPWR VGND sg13g2_decap_8
XFILLER_103_798 VPWR VGND sg13g2_fill_2
XFILLER_88_487 VPWR VGND sg13g2_fill_1
XFILLER_102_286 VPWR VGND sg13g2_decap_4
XFILLER_44_1673 VPWR VGND sg13g2_decap_8
XFILLER_40_1515 VPWR VGND sg13g2_decap_8
XFILLER_40_1526 VPWR VGND sg13g2_fill_1
XFILLER_75_148 VPWR VGND sg13g2_fill_2
X_11980_ _12003_/D _12002_/A _12002_/B _12001_/C _12001_/D _12002_/C VPWR VGND sg13g2_a221oi_1
XFILLER_91_608 VPWR VGND sg13g2_decap_4
XFILLER_79_1714 VPWR VGND sg13g2_decap_8
X_23966_ _23966_/Q _23966_/CLK _23966_/D fanout2785/X VPWR VGND sg13g2_dfrbpq_1
XFILLER_84_47 VPWR VGND sg13g2_fill_1
XFILLER_5_1166 VPWR VGND sg13g2_fill_2
XFILLER_25_1094 VPWR VGND sg13g2_fill_2
XFILLER_84_660 VPWR VGND sg13g2_decap_8
XFILLER_29_565 VPWR VGND sg13g2_fill_2
XFILLER_40_1559 VPWR VGND sg13g2_fill_1
XFILLER_29_576 VPWR VGND sg13g2_fill_1
XFILLER_72_822 VPWR VGND sg13g2_fill_2
XFILLER_16_215 VPWR VGND sg13g2_decap_8
X_22917_ _22917_/Q _22917_/CLK _22917_/D fanout2872/X VPWR VGND sg13g2_dfrbpq_1
X_23897_ _23897_/Q clkload46/A _23897_/D fanout2755/X VPWR VGND sg13g2_dfrbpq_1
XFILLER_17_749 VPWR VGND sg13g2_fill_1
XFILLER_71_310 VPWR VGND sg13g2_fill_1
XFILLER_17_52 VPWR VGND sg13g2_fill_1
XFILLER_71_332 VPWR VGND sg13g2_decap_4
X_22848_ _22848_/Q clkload21/A _22848_/D fanout2875/X VPWR VGND sg13g2_dfrbpq_1
X_13650_ _13651_/B _14438_/C _13650_/B _13904_/B VPWR VGND sg13g2_nand3_1
XFILLER_25_760 VPWR VGND sg13g2_decap_8
XFILLER_71_365 VPWR VGND sg13g2_decap_8
XFILLER_77_1493 VPWR VGND sg13g2_decap_4
X_12601_ _12602_/B _13595_/B2 _12596_/Y _12598_/Y _13678_/A1 _12600_/Y VPWR VGND sg13g2_a221oi_1
X_13581_ _13582_/B _23438_/Q _23470_/Q _23502_/Q _23534_/Q _13676_/B _13686_/A VPWR
+ VGND sg13g2_mux4_1
X_22779_ _22779_/Q _22869_/CLK _22779_/D fanout2797/X VPWR VGND sg13g2_dfrbpq_1
XFILLER_13_944 VPWR VGND sg13g2_fill_1
XFILLER_24_281 VPWR VGND sg13g2_decap_4
XFILLER_40_730 VPWR VGND sg13g2_decap_4
XFILLER_40_741 VPWR VGND sg13g2_fill_2
X_12532_ _12532_/Y _12535_/A _12532_/B _12532_/C _12535_/D VPWR VGND sg13g2_nor4_2
XFILLER_33_40 VPWR VGND sg13g2_decap_8
XFILLER_40_763 VPWR VGND sg13g2_decap_8
XFILLER_12_476 VPWR VGND sg13g2_decap_8
XFILLER_107_1881 VPWR VGND sg13g2_decap_8
X_15251_ _15448_/B _15287_/A _15238_/B _15245_/D VPWR VGND sg13g2_o21ai_1
XFILLER_36_1190 VPWR VGND sg13g2_decap_4
X_12463_ _12463_/Y _23167_/Q _12640_/B _13182_/B2 _12462_/X VPWR VGND sg13g2_a22oi_1
X_11414_ _11414_/Y _11414_/A _11414_/B VPWR VGND sg13g2_nor2_1
X_14202_ _14202_/X _14202_/A _22831_/Q VPWR VGND sg13g2_and2_1
X_15182_ _15182_/X _15182_/A _15210_/B VPWR VGND sg13g2_and2_1
XFILLER_32_1065 VPWR VGND sg13g2_decap_8
X_12394_ _12445_/A _12406_/A _12394_/B VPWR VGND sg13g2_nand2_2
X_14133_ _14134_/C _14133_/A _14133_/B VPWR VGND sg13g2_nand2_1
X_11345_ _11345_/X _23895_/Q _23991_/Q _11919_/S VPWR VGND sg13g2_mux2_1
XFILLER_67_1128 VPWR VGND sg13g2_fill_1
X_19990_ _19991_/C _20177_/A _19985_/Y _20177_/B _19474_/X VPWR VGND sg13g2_a22oi_1
XFILLER_101_1480 VPWR VGND sg13g2_fill_2
XFILLER_10_1374 VPWR VGND sg13g2_fill_2
XFILLER_4_664 VPWR VGND sg13g2_decap_8
X_18941_ _18942_/C _18959_/A _23084_/Q VPWR VGND sg13g2_nand2_1
X_14064_ _14430_/B _14064_/A _14064_/B _14064_/C _14064_/D VPWR VGND sg13g2_nand4_1
XFILLER_98_229 VPWR VGND sg13g2_decap_8
X_11276_ _11276_/Y _11688_/A _22985_/Q VPWR VGND sg13g2_nor2b_2
XFILLER_84_1464 VPWR VGND sg13g2_decap_8
XFILLER_84_1475 VPWR VGND sg13g2_fill_2
X_18872_ _18873_/C _18890_/B _23078_/Q VPWR VGND sg13g2_nand2_1
XFILLER_80_1339 VPWR VGND sg13g2_decap_8
XFILLER_7_1932 VPWR VGND sg13g2_decap_8
X_17823_ _17823_/Y _17823_/A1 _17821_/X _17822_/Y VPWR VGND sg13g2_o21ai_1
XFILLER_66_115 VPWR VGND sg13g2_decap_8
XFILLER_94_435 VPWR VGND sg13g2_fill_1
XFILLER_66_137 VPWR VGND sg13g2_fill_1
XFILLER_94_468 VPWR VGND sg13g2_decap_8
X_17754_ _17762_/B _22569_/Q _22568_/Q _17754_/C VPWR VGND sg13g2_nand3_1
XFILLER_43_1183 VPWR VGND sg13g2_fill_1
XFILLER_114_1874 VPWR VGND sg13g2_decap_8
X_14966_ _14969_/B _14966_/A _14966_/B VPWR VGND sg13g2_nand2_1
X_16705_ _16706_/B _16709_/B _16709_/C VPWR VGND sg13g2_nor2_1
XFILLER_81_118 VPWR VGND sg13g2_fill_2
X_13917_ _13917_/X _23443_/Q _23475_/Q _23507_/Q _23539_/Q _13919_/S0 _13919_/S1 VPWR
+ VGND sg13g2_mux4_1
XFILLER_75_682 VPWR VGND sg13g2_decap_8
XFILLER_97_1858 VPWR VGND sg13g2_decap_4
X_17685_ _17686_/B _22561_/Q _17694_/C VPWR VGND sg13g2_nand2_1
X_14897_ _14899_/A _17862_/A1 _15029_/B _18635_/A2 _24254_/A _14896_/Y VPWR VGND sg13g2_a221oi_1
X_19424_ _19572_/B _19978_/A _19430_/B VPWR VGND sg13g2_nand2_1
XFILLER_21_1492 VPWR VGND sg13g2_decap_4
XFILLER_56_1500 VPWR VGND sg13g2_fill_2
XFILLER_62_343 VPWR VGND sg13g2_fill_1
X_16636_ _16636_/Y _22642_/Q _16636_/B VPWR VGND sg13g2_xnor2_1
XFILLER_63_877 VPWR VGND sg13g2_decap_8
X_13848_ _20324_/A _14342_/A _14672_/A _13847_/Y VPWR VGND sg13g2_a21oi_2
XFILLER_22_207 VPWR VGND sg13g2_decap_8
X_19355_ _19355_/Y _19978_/A _19367_/B _19354_/Y VPWR VGND sg13g2_a21oi_1
XFILLER_108_1623 VPWR VGND sg13g2_decap_8
X_16567_ _16568_/B _22628_/Q _16575_/C VPWR VGND sg13g2_xor2_1
XFILLER_17_1506 VPWR VGND sg13g2_decap_4
X_13779_ _13779_/Y _23184_/Q _13924_/A2 _13924_/B1 _13778_/X VPWR VGND sg13g2_a22oi_1
XFILLER_31_730 VPWR VGND sg13g2_decap_4
X_18306_ _22976_/D _14117_/A _18140_/B _18305_/Y VPWR VGND sg13g2_a21o_1
X_15518_ _16078_/A _23006_/Q _22556_/Q _15591_/S VPWR VGND sg13g2_mux2_1
X_19286_ _23204_/D _23204_/Q _20098_/A0 _19300_/S VPWR VGND sg13g2_mux2_1
XFILLER_34_1831 VPWR VGND sg13g2_decap_8
X_16498_ _16498_/Y _22611_/Q _16506_/B VPWR VGND sg13g2_nand2_1
XFILLER_73_1880 VPWR VGND sg13g2_fill_2
X_18237_ _18239_/B _18238_/A _18403_/A _18498_/C VPWR VGND sg13g2_o21ai_1
XFILLER_50_1121 VPWR VGND sg13g2_decap_8
XFILLER_89_1320 VPWR VGND sg13g2_fill_2
XFILLER_34_1886 VPWR VGND sg13g2_decap_8
XFILLER_30_1728 VPWR VGND sg13g2_fill_1
XFILLER_69_1905 VPWR VGND sg13g2_decap_8
XFILLER_89_1342 VPWR VGND sg13g2_fill_1
X_18168_ _18168_/Y _18301_/B _18379_/B _18332_/B _18301_/A _18443_/A VPWR VGND sg13g2_a221oi_1
XFILLER_15_1296 VPWR VGND sg13g2_fill_1
X_17119_ _17119_/Y _17119_/A _17226_/A VPWR VGND sg13g2_nor2_1
X_20130_ _20130_/Y _20129_/X _20130_/B VPWR VGND sg13g2_nand2b_1
X_20061_ _20137_/B _20060_/A _19542_/Y _20060_/Y VPWR VGND sg13g2_a21oi_1
XFILLER_98_763 VPWR VGND sg13g2_fill_1
XFILLER_112_551 VPWR VGND sg13g2_decap_8
XFILLER_115_1627 VPWR VGND sg13g2_decap_8
XFILLER_98_796 VPWR VGND sg13g2_fill_2
XFILLER_86_947 VPWR VGND sg13g2_decap_4
XFILLER_6_1431 VPWR VGND sg13g2_decap_8
XFILLER_26_1381 VPWR VGND sg13g2_fill_1
XFILLER_100_768 VPWR VGND sg13g2_fill_1
XFILLER_6_1464 VPWR VGND sg13g2_decap_8
X_23820_ _23820_/Q clkload49/A _23820_/D fanout2744/X VPWR VGND sg13g2_dfrbpq_1
XFILLER_85_468 VPWR VGND sg13g2_decap_4
XFILLER_54_811 VPWR VGND sg13g2_fill_1
XFILLER_39_896 VPWR VGND sg13g2_decap_8
X_23751_ _23751_/Q clkload37/A _23751_/D fanout2707/X VPWR VGND sg13g2_dfrbpq_1
XFILLER_54_822 VPWR VGND sg13g2_decap_8
X_20963_ _23526_/D _21331_/A1 _20962_/B _20962_/Y VPWR VGND sg13g2_o21ai_1
XFILLER_54_833 VPWR VGND sg13g2_fill_2
XFILLER_76_1909 VPWR VGND sg13g2_decap_4
XFILLER_65_181 VPWR VGND sg13g2_decap_8
X_22702_ _22702_/Q clkload19/A _22702_/D fanout2864/X VPWR VGND sg13g2_dfrbpq_1
X_23682_ _23682_/Q _23682_/CLK _23682_/D fanout2726/X VPWR VGND sg13g2_dfrbpq_1
X_20894_ _20894_/Y _20894_/A _20896_/B VPWR VGND sg13g2_nand2_1
XFILLER_55_1010 VPWR VGND sg13g2_decap_4
X_22633_ _22633_/Q clkload23/A _22633_/D fanout2883/X VPWR VGND sg13g2_dfrbpq_1
XFILLER_107_1111 VPWR VGND sg13g2_decap_8
XFILLER_110_56 VPWR VGND sg13g2_decap_8
XFILLER_74_1677 VPWR VGND sg13g2_decap_4
X_22564_ _22564_/Q clkload26/A _22564_/D fanout2850/X VPWR VGND sg13g2_dfrbpq_1
XFILLER_74_1699 VPWR VGND sg13g2_fill_2
XFILLER_55_1087 VPWR VGND sg13g2_decap_4
XFILLER_16_1049 VPWR VGND sg13g2_decap_8
XFILLER_70_49 VPWR VGND sg13g2_decap_8
X_21515_ _21515_/Y _23774_/Q _21515_/B VPWR VGND sg13g2_nand2_1
X_22495_ _22495_/Q clkload9/A _22495_/D fanout2824/X VPWR VGND sg13g2_dfrbpq_1
XFILLER_6_918 VPWR VGND sg13g2_decap_8
XFILLER_33_1363 VPWR VGND sg13g2_decap_8
XFILLER_13_1948 VPWR VGND sg13g2_decap_8
X_24234_ _24234_/Q clkload17/A _24234_/D fanout2848/X VPWR VGND sg13g2_dfrbpq_1
X_21446_ _23741_/D _21941_/A1 _21447_/B _21445_/Y VPWR VGND sg13g2_o21ai_1
Xplace3060 _21899_/S _21915_/S VPWR VGND sg13g2_buf_1
XFILLER_100_1918 VPWR VGND sg13g2_decap_8
XFILLER_5_428 VPWR VGND sg13g2_decap_4
Xplace3071 _21818_/B _21833_/B VPWR VGND sg13g2_buf_1
Xplace3082 _21600_/B _21612_/B VPWR VGND sg13g2_buf_1
X_24165_ _24165_/Q clkload34/A _24165_/D fanout2699/X VPWR VGND sg13g2_dfrbpq_1
Xplace3093 _21430_/B _21489_/B VPWR VGND sg13g2_buf_1
X_21377_ _23708_/D _21938_/A1 _21380_/B _21376_/Y VPWR VGND sg13g2_o21ai_1
XFILLER_11_1661 VPWR VGND sg13g2_fill_1
X_23116_ _23116_/Q clkload12/A _23116_/D fanout2911/X VPWR VGND sg13g2_dfrbpq_1
X_20328_ _20328_/Y _20328_/A _20328_/B VPWR VGND sg13g2_nand2_1
X_24096_ _24096_/Q clkload43/A _24096_/D fanout2769/X VPWR VGND sg13g2_dfrbpq_1
XFILLER_85_1773 VPWR VGND sg13g2_fill_2
XFILLER_46_1735 VPWR VGND sg13g2_decap_8
XFILLER_81_1626 VPWR VGND sg13g2_fill_1
X_23047_ _23047_/Q clkload12/A _23047_/D fanout2910/X VPWR VGND sg13g2_dfrbpq_1
XFILLER_77_903 VPWR VGND sg13g2_fill_2
XFILLER_0_133 VPWR VGND sg13g2_decap_4
X_20259_ _20260_/B _20355_/A _20258_/A _20258_/Y VPWR VGND sg13g2_a21oi_1
XFILLER_103_562 VPWR VGND sg13g2_decap_8
XFILLER_7_1217 VPWR VGND sg13g2_decap_8
XFILLER_46_1768 VPWR VGND sg13g2_fill_2
XFILLER_88_262 VPWR VGND sg13g2_fill_2
XFILLER_95_35 VPWR VGND sg13g2_fill_2
XFILLER_62_1069 VPWR VGND sg13g2_fill_2
X_14820_ _18613_/A _14818_/Y _14819_/Y _16240_/A VPWR VGND sg13g2_a21o_1
XFILLER_44_1481 VPWR VGND sg13g2_decap_4
XFILLER_44_1492 VPWR VGND sg13g2_decap_8
XFILLER_20_1919 VPWR VGND sg13g2_decap_8
XFILLER_28_62 VPWR VGND sg13g2_decap_4
XFILLER_40_1356 VPWR VGND sg13g2_decap_4
XFILLER_28_95 VPWR VGND sg13g2_fill_2
XFILLER_45_833 VPWR VGND sg13g2_decap_8
X_14751_ _14752_/B _14219_/A _14750_/Y _14861_/B VPWR VGND sg13g2_a21oi_1
X_23949_ _23949_/Q clkload30/A _23949_/D fanout2657/X VPWR VGND sg13g2_dfrbpq_1
X_11963_ _11973_/C _11963_/A _11963_/B _11963_/C VPWR VGND sg13g2_nand3_1
XFILLER_44_310 VPWR VGND sg13g2_fill_1
XFILLER_56_170 VPWR VGND sg13g2_decap_8
XFILLER_45_855 VPWR VGND sg13g2_decap_8
XFILLER_2_1862 VPWR VGND sg13g2_decap_8
XFILLER_44_343 VPWR VGND sg13g2_decap_4
X_13702_ _13702_/X _13702_/A _13702_/B VPWR VGND sg13g2_and2_1
X_17470_ _22852_/D _17872_/A _17507_/S _17469_/Y VPWR VGND sg13g2_o21ai_1
X_14682_ _14682_/Y _13967_/Y _14720_/B VPWR VGND sg13g2_nand2b_1
XFILLER_71_140 VPWR VGND sg13g2_fill_2
XFILLER_92_1722 VPWR VGND sg13g2_fill_1
XFILLER_44_376 VPWR VGND sg13g2_fill_1
XFILLER_71_162 VPWR VGND sg13g2_decap_8
X_16421_ _22578_/D _23028_/Q _22578_/Q _16421_/S VPWR VGND sg13g2_mux2_1
X_13633_ _13648_/A _13138_/A _13630_/X _13632_/X VPWR VGND sg13g2_o21ai_1
XFILLER_32_538 VPWR VGND sg13g2_decap_8
XFILLER_60_847 VPWR VGND sg13g2_decap_8
XFILLER_109_1932 VPWR VGND sg13g2_decap_8
XFILLER_18_1837 VPWR VGND sg13g2_decap_8
XFILLER_44_83 VPWR VGND sg13g2_decap_8
X_19140_ _23116_/D _23116_/Q _18940_/A _19141_/S VPWR VGND sg13g2_mux2_1
XFILLER_44_94 VPWR VGND sg13g2_fill_1
XFILLER_73_1154 VPWR VGND sg13g2_fill_2
X_16352_ _16352_/X _19494_/A _16352_/B VPWR VGND sg13g2_and2_1
XFILLER_73_1165 VPWR VGND sg13g2_decap_8
XFILLER_12_240 VPWR VGND sg13g2_decap_8
X_13564_ _13564_/X _23566_/Q _24014_/Q _13565_/A VPWR VGND sg13g2_mux2_1
XFILLER_12_251 VPWR VGND sg13g2_fill_1
XFILLER_9_723 VPWR VGND sg13g2_decap_4
XFILLER_8_200 VPWR VGND sg13g2_decap_4
XFILLER_73_1187 VPWR VGND sg13g2_decap_4
X_15303_ _15332_/C _15302_/Y _16776_/C VPWR VGND sg13g2_nand2b_1
X_12515_ _12515_/Y _12535_/A _12515_/B _12516_/C VPWR VGND sg13g2_nand3_1
XFILLER_8_222 VPWR VGND sg13g2_decap_8
X_19071_ _19071_/X _18010_/B _23104_/Q _19085_/S VPWR VGND sg13g2_mux2_1
XFILLER_9_756 VPWR VGND sg13g2_fill_2
X_13495_ _13495_/X _13778_/A1 _13923_/A2 _22572_/Q VPWR VGND sg13g2_a21o_1
X_18022_ _18022_/X _18884_/A _23047_/Q _18048_/S VPWR VGND sg13g2_mux2_1
XFILLER_103_1542 VPWR VGND sg13g2_decap_4
X_12446_ _12447_/C _23584_/Q _23616_/Q _23648_/Q _23680_/Q _12651_/S0 _12651_/S1 VPWR
+ VGND sg13g2_mux4_1
XFILLER_67_7 VPWR VGND sg13g2_decap_4
XFILLER_103_1575 VPWR VGND sg13g2_decap_8
X_15165_ _15307_/B _15186_/A _15165_/B _15165_/C VPWR VGND sg13g2_nor3_1
X_12377_ _12377_/X _23263_/Q _23391_/Q _12377_/S VPWR VGND sg13g2_mux2_1
XFILLER_5_962 VPWR VGND sg13g2_decap_8
XFILLER_114_816 VPWR VGND sg13g2_decap_8
XFILLER_86_1559 VPWR VGND sg13g2_decap_8
XFILLER_5_973 VPWR VGND sg13g2_fill_2
X_14116_ _14116_/X _14116_/A _14116_/B _14116_/C VPWR VGND sg13g2_and3_1
XFILLER_113_315 VPWR VGND sg13g2_decap_8
XFILLER_5_66 VPWR VGND sg13g2_decap_4
X_15096_ _15098_/A _15096_/A1 _18635_/A2 _15095_/Y VPWR VGND sg13g2_a21oi_1
XFILLER_107_890 VPWR VGND sg13g2_fill_1
XFILLER_10_1182 VPWR VGND sg13g2_decap_8
XFILLER_49_1370 VPWR VGND sg13g2_decap_4
X_18924_ _18925_/C _18926_/A _23050_/Q _18924_/C VPWR VGND sg13g2_or3_1
X_11259_ _12668_/B _11257_/Y _11258_/Y _11502_/A VPWR VGND sg13g2_o21ai_1
XFILLER_69_80 VPWR VGND sg13g2_fill_2
X_14047_ _14047_/Y _14047_/A _14045_/B VPWR VGND sg13g2_nor2b_1
XFILLER_25_1808 VPWR VGND sg13g2_decap_4
XFILLER_69_91 VPWR VGND sg13g2_decap_8
XFILLER_64_1868 VPWR VGND sg13g2_decap_4
X_18855_ _18855_/Y _18803_/A _18537_/X _18854_/Y _23043_/Q VPWR VGND sg13g2_a22oi_1
XFILLER_99_1909 VPWR VGND sg13g2_decap_8
XFILLER_80_1158 VPWR VGND sg13g2_decap_8
XFILLER_62_1570 VPWR VGND sg13g2_fill_1
X_17806_ _17820_/C _17806_/A _17806_/B VPWR VGND sg13g2_nor2_1
XFILLER_3_1604 VPWR VGND sg13g2_decap_8
X_18786_ _18788_/B _18784_/Y _18785_/Y _18824_/S VPWR VGND sg13g2_mux2_1
XFILLER_97_1611 VPWR VGND sg13g2_decap_8
XFILLER_95_788 VPWR VGND sg13g2_decap_8
X_15998_ _17220_/A _20338_/A _15996_/X _15997_/Y VPWR VGND sg13g2_a21o_1
XFILLER_3_1637 VPWR VGND sg13g2_decap_8
XFILLER_23_1565 VPWR VGND sg13g2_decap_8
XFILLER_82_427 VPWR VGND sg13g2_decap_4
X_17737_ _17737_/Y _22897_/Q _17796_/B VPWR VGND sg13g2_nor2_1
XFILLER_78_1021 VPWR VGND sg13g2_decap_8
X_14949_ _14949_/Y _14949_/A _14949_/B _14949_/C VPWR VGND sg13g2_nand3_1
XFILLER_35_332 VPWR VGND sg13g2_decap_8
XFILLER_58_1628 VPWR VGND sg13g2_decap_8
XFILLER_36_877 VPWR VGND sg13g2_decap_8
XFILLER_91_972 VPWR VGND sg13g2_fill_2
X_17668_ _17668_/Y _23168_/Q _17815_/A2 _17689_/B1 _17667_/Y VPWR VGND sg13g2_a22oi_1
XFILLER_97_1699 VPWR VGND sg13g2_fill_1
XFILLER_78_1076 VPWR VGND sg13g2_fill_1
XFILLER_78_1087 VPWR VGND sg13g2_decap_8
XFILLER_35_376 VPWR VGND sg13g2_decap_8
X_19407_ _19407_/Y _20085_/A _19412_/B VPWR VGND sg13g2_nor2_1
XFILLER_35_387 VPWR VGND sg13g2_decap_8
XFILLER_62_162 VPWR VGND sg13g2_decap_8
XFILLER_90_482 VPWR VGND sg13g2_decap_8
X_16619_ _16620_/B _22638_/Q _16635_/A _16628_/D VPWR VGND sg13g2_nand3_1
XFILLER_75_1953 VPWR VGND sg13g2_fill_2
X_17599_ _17599_/Y _22883_/Q _17631_/B VPWR VGND sg13g2_nor2_1
XFILLER_93_0 VPWR VGND sg13g2_decap_8
X_19338_ _19338_/Y _20063_/A _19430_/B VPWR VGND sg13g2_nor2_1
XFILLER_17_1325 VPWR VGND sg13g2_decap_8
X_19269_ _19269_/Y _19265_/B _19263_/Y _19268_/Y VPWR VGND sg13g2_a21oi_1
Xoutput4510 data_wdata_o[16] _14724_/X VPWR VGND sg13g2_buf_1
Xoutput4521 data_wdata_o[26] _14734_/X VPWR VGND sg13g2_buf_1
X_21300_ _21300_/Y _23672_/Q _21308_/B VPWR VGND sg13g2_nand2_1
Xoutput4532 data_wdata_o[7] _14684_/X VPWR VGND sg13g2_buf_1
Xoutput4543 instr_addr_o[17] _14982_/X VPWR VGND sg13g2_buf_1
Xoutput4554 instr_addr_o[28] _15092_/X VPWR VGND sg13g2_buf_1
XFILLER_30_1525 VPWR VGND sg13g2_decap_4
X_22280_ _24127_/D _22280_/A1 _22285_/B _22279_/Y VPWR VGND sg13g2_o21ai_1
Xoutput4565 instr_addr_o[9] _14902_/Y VPWR VGND sg13g2_buf_1
X_21231_ _23638_/D _21297_/A1 _21242_/B _21230_/Y VPWR VGND sg13g2_o21ai_1
XFILLER_89_1172 VPWR VGND sg13g2_decap_4
XFILLER_85_1003 VPWR VGND sg13g2_fill_2
XFILLER_105_816 VPWR VGND sg13g2_fill_1
X_21162_ _21162_/Y _21162_/A _21175_/B VPWR VGND sg13g2_nand2_1
XFILLER_49_28 VPWR VGND sg13g2_decap_8
XFILLER_67_1470 VPWR VGND sg13g2_decap_4
XFILLER_104_348 VPWR VGND sg13g2_fill_1
X_20113_ _20113_/Y _20117_/A _20117_/B VPWR VGND sg13g2_nor2b_1
XFILLER_104_359 VPWR VGND sg13g2_decap_4
X_21093_ _21093_/Y _21093_/A _21099_/B VPWR VGND sg13g2_nand2_1
XFILLER_28_1443 VPWR VGND sg13g2_fill_1
XFILLER_98_560 VPWR VGND sg13g2_decap_4
XFILLER_8_1526 VPWR VGND sg13g2_fill_1
XFILLER_115_1424 VPWR VGND sg13g2_decap_4
X_20044_ _20045_/B _20316_/A1 _20316_/A3 _20316_/A0 _20316_/A2 _20224_/A _20316_/S0
+ VPWR VGND sg13g2_mux4_1
XFILLER_112_370 VPWR VGND sg13g2_decap_8
XFILLER_100_532 VPWR VGND sg13g2_decap_8
XFILLER_45_1790 VPWR VGND sg13g2_fill_1
XFILLER_105_56 VPWR VGND sg13g2_decap_8
XFILLER_85_243 VPWR VGND sg13g2_decap_8
XFILLER_39_660 VPWR VGND sg13g2_decap_8
XFILLER_2_1103 VPWR VGND sg13g2_fill_2
XFILLER_41_1654 VPWR VGND sg13g2_fill_2
XFILLER_65_38 VPWR VGND sg13g2_fill_2
XFILLER_61_1091 VPWR VGND sg13g2_decap_8
X_23803_ _23803_/Q clkload58/A _23803_/D fanout2763/X VPWR VGND sg13g2_dfrbpq_1
XFILLER_22_1053 VPWR VGND sg13g2_fill_2
XFILLER_27_833 VPWR VGND sg13g2_decap_8
X_21995_ _21995_/Y _21995_/A _22031_/S VPWR VGND sg13g2_nand2_1
XFILLER_27_855 VPWR VGND sg13g2_fill_1
XFILLER_66_490 VPWR VGND sg13g2_decap_4
XFILLER_82_961 VPWR VGND sg13g2_fill_1
X_23734_ _23734_/Q clkload58/A _23734_/D fanout2758/X VPWR VGND sg13g2_dfrbpq_1
X_20946_ _23518_/D _21314_/A1 _20945_/B _20945_/Y VPWR VGND sg13g2_o21ai_1
XFILLER_76_1739 VPWR VGND sg13g2_fill_2
XFILLER_92_1007 VPWR VGND sg13g2_decap_8
XFILLER_96_1176 VPWR VGND sg13g2_decap_8
XFILLER_81_460 VPWR VGND sg13g2_decap_8
XFILLER_27_899 VPWR VGND sg13g2_fill_1
XFILLER_109_1206 VPWR VGND sg13g2_decap_8
XFILLER_53_162 VPWR VGND sg13g2_decap_8
XFILLER_74_1430 VPWR VGND sg13g2_fill_1
X_23665_ _23665_/Q _24113_/CLK _23665_/D fanout2684/X VPWR VGND sg13g2_dfrbpq_1
X_20877_ _20877_/Y _20877_/A _20879_/B VPWR VGND sg13g2_nand2_1
XFILLER_35_1414 VPWR VGND sg13g2_decap_8
X_22616_ _22616_/Q clkload10/A _22616_/D fanout2811/X VPWR VGND sg13g2_dfrbpq_1
X_23596_ _23596_/Q clkload36/A _23596_/D fanout2641/X VPWR VGND sg13g2_dfrbpq_1
X_22547_ _22547_/Q clkload27/A _22547_/D fanout2894/X VPWR VGND sg13g2_dfrbpq_1
X_12300_ _12300_/X _12300_/A _12300_/B _12300_/C _12300_/D VPWR VGND sg13g2_or4_2
XFILLER_17_1892 VPWR VGND sg13g2_decap_8
X_13280_ _13280_/X _18432_/A _13280_/B VPWR VGND sg13g2_and2_1
X_22478_ _22478_/Q clkload8/A _22478_/D fanout2807/X VPWR VGND sg13g2_dfrbpq_1
XFILLER_104_1873 VPWR VGND sg13g2_decap_8
XFILLER_108_643 VPWR VGND sg13g2_decap_8
X_12231_ _12232_/D _12249_/A1 _12230_/X _12048_/A VPWR VGND sg13g2_o21ai_1
X_21429_ _23733_/D _21924_/A1 _21430_/B _21428_/Y VPWR VGND sg13g2_o21ai_1
X_24217_ _24217_/Q clkload15/A _24217_/D fanout2852/X VPWR VGND sg13g2_dfrbpq_1
X_12162_ _12163_/B _23548_/Q _12922_/A2 _12161_/X _12285_/A VPWR VGND sg13g2_a22oi_1
X_24148_ _24148_/Q _24212_/CLK _24148_/D fanout2625/X VPWR VGND sg13g2_dfrbpq_1
XFILLER_107_175 VPWR VGND sg13g2_decap_8
Xfanout2902 fanout2902/X wire1183/X VPWR VGND sg13g2_buf_1
Xfanout2913 fanout2913/X fanout2914/X VPWR VGND sg13g2_buf_1
Xfanout2924 fanout2924/X fanout2927/X VPWR VGND sg13g2_buf_1
X_24079_ _24079_/Q clkload50/A _24079_/D fanout2661/X VPWR VGND sg13g2_dfrbpq_1
XFILLER_2_965 VPWR VGND sg13g2_decap_4
Xfanout2935 fanout2935/X wire1183/X VPWR VGND sg13g2_buf_1
X_12093_ _24251_/A _14051_/A VPWR VGND sg13g2_inv_1
X_16970_ _16971_/B _17004_/B _16970_/B VPWR VGND sg13g2_nor2_1
XFILLER_81_1445 VPWR VGND sg13g2_decap_8
XFILLER_49_402 VPWR VGND sg13g2_decap_8
XFILLER_89_582 VPWR VGND sg13g2_fill_2
X_15921_ _15929_/A _15921_/A _15921_/B _15921_/C _15921_/D VPWR VGND sg13g2_nand4_1
XFILLER_49_435 VPWR VGND sg13g2_decap_8
XFILLER_7_1047 VPWR VGND sg13g2_decap_8
XFILLER_46_1598 VPWR VGND sg13g2_fill_2
XFILLER_76_221 VPWR VGND sg13g2_decap_4
XFILLER_103_392 VPWR VGND sg13g2_decap_8
XFILLER_39_83 VPWR VGND sg13g2_fill_1
X_15852_ _15856_/A _22902_/Q _15937_/B VPWR VGND sg13g2_nand2_1
XFILLER_49_479 VPWR VGND sg13g2_decap_8
XFILLER_4_1935 VPWR VGND sg13g2_decap_8
XFILLER_20_1705 VPWR VGND sg13g2_fill_1
XFILLER_111_1822 VPWR VGND sg13g2_decap_8
XFILLER_98_1931 VPWR VGND sg13g2_decap_8
XFILLER_92_725 VPWR VGND sg13g2_decap_4
X_14803_ _16213_/A _22514_/Q _16244_/B _18607_/A VPWR VGND sg13g2_a21oi_1
XFILLER_40_1142 VPWR VGND sg13g2_decap_4
X_18571_ _18571_/Y _18573_/A _18780_/S _18571_/C VPWR VGND sg13g2_nand3b_1
XFILLER_59_1904 VPWR VGND sg13g2_fill_1
XFILLER_92_758 VPWR VGND sg13g2_decap_8
XFILLER_20_1738 VPWR VGND sg13g2_fill_2
X_15783_ _22471_/D _15936_/S _15778_/Y _15782_/Y VPWR VGND sg13g2_a21oi_1
XFILLER_91_235 VPWR VGND sg13g2_fill_2
X_12995_ _12995_/Y _22565_/Q _13692_/B _13988_/B1 VPWR VGND sg13g2_o21ai_1
XFILLER_59_1926 VPWR VGND sg13g2_fill_2
X_17522_ _22875_/D _14386_/Y _17629_/B _17518_/X _17521_/Y VPWR VGND sg13g2_a22oi_1
X_14734_ _14734_/X _14697_/Y _14695_/Y _14737_/S VPWR VGND sg13g2_mux2_1
XFILLER_111_1899 VPWR VGND sg13g2_decap_8
X_11946_ _11973_/D _13267_/A _11946_/B _11946_/C VPWR VGND sg13g2_nand3_1
XFILLER_72_471 VPWR VGND sg13g2_decap_4
XFILLER_33_836 VPWR VGND sg13g2_fill_1
XFILLER_60_622 VPWR VGND sg13g2_fill_1
X_17453_ _17453_/Y _17453_/A _17453_/B VPWR VGND sg13g2_nand2_1
XFILLER_17_398 VPWR VGND sg13g2_decap_8
X_14665_ _14665_/Y _14706_/A _14720_/B VPWR VGND sg13g2_nand2_1
X_11877_ _19728_/B _11877_/A _11877_/B VPWR VGND sg13g2_nand2_1
XFILLER_32_335 VPWR VGND sg13g2_decap_8
XFILLER_92_1552 VPWR VGND sg13g2_decap_8
XFILLER_32_346 VPWR VGND sg13g2_fill_2
XFILLER_33_869 VPWR VGND sg13g2_decap_8
XFILLER_53_1503 VPWR VGND sg13g2_decap_8
X_16404_ _16405_/B _22570_/Q _18667_/A VPWR VGND sg13g2_nand2_1
X_13616_ _13625_/C _13616_/A _13616_/B VPWR VGND sg13g2_nor2_1
XFILLER_109_1762 VPWR VGND sg13g2_fill_1
X_17384_ _17384_/Y _22817_/Q VPWR VGND sg13g2_inv_1
X_14596_ _14597_/B _14596_/A _14596_/B _14596_/C VPWR VGND sg13g2_nor3_1
X_19123_ _23101_/D _23101_/Q _19123_/A1 _19124_/S VPWR VGND sg13g2_mux2_1
Xrebuffer5509 rebuffer5509/X rebuffer5510/X VPWR VGND sg13g2_buf_1
XFILLER_105_1626 VPWR VGND sg13g2_decap_8
XFILLER_105_1637 VPWR VGND sg13g2_fill_2
X_13547_ _13657_/B _14005_/A _13530_/Y _14002_/A VPWR VGND sg13g2_o21ai_1
Xplace3807 _16353_/B _15407_/Y VPWR VGND sg13g2_buf_1
Xplace3818 _14694_/A _13648_/Y VPWR VGND sg13g2_buf_4
XFILLER_12_1200 VPWR VGND sg13g2_decap_8
Xplace3829 _20355_/A _19480_/B VPWR VGND sg13g2_buf_1
X_19054_ _19054_/X _19118_/A1 _23096_/Q _19054_/S VPWR VGND sg13g2_mux2_1
XFILLER_31_1834 VPWR VGND sg13g2_decap_4
X_16266_ _16267_/B _16320_/A _16273_/C _16273_/D VPWR VGND sg13g2_nand3_1
X_13478_ _13478_/X _24173_/Q _24205_/Q _23245_/Q _23277_/Q _13610_/S0 _13111_/A VPWR
+ VGND sg13g2_mux4_1
XFILLER_51_1282 VPWR VGND sg13g2_decap_8
X_18005_ _18451_/C _18560_/S _17992_/X _17995_/Y VPWR VGND sg13g2_a21oi_1
X_12429_ _12429_/Y _12429_/A _12429_/B _12429_/C VPWR VGND sg13g2_nand3_1
X_16197_ _16197_/Y _16197_/A _16197_/B VPWR VGND sg13g2_nor2_1
XFILLER_114_613 VPWR VGND sg13g2_decap_8
XFILLER_86_1356 VPWR VGND sg13g2_decap_4
X_15148_ _15238_/B _19673_/A _15289_/B VPWR VGND sg13g2_and2_1
XFILLER_113_112 VPWR VGND sg13g2_decap_8
XFILLER_47_1329 VPWR VGND sg13g2_decap_4
XFILLER_99_357 VPWR VGND sg13g2_fill_2
XFILLER_102_819 VPWR VGND sg13g2_decap_4
XFILLER_87_519 VPWR VGND sg13g2_decap_4
X_19956_ _19965_/B _19956_/A _19956_/B VPWR VGND sg13g2_nor2_1
X_15079_ _15080_/B _17918_/A1 _15107_/A2 _14918_/B VPWR VGND sg13g2_o21ai_1
XFILLER_9_1857 VPWR VGND sg13g2_decap_8
XFILLER_45_1042 VPWR VGND sg13g2_decap_4
XFILLER_113_189 VPWR VGND sg13g2_decap_8
X_18907_ _18909_/B _18951_/A _18907_/B VPWR VGND sg13g2_nand2_1
XFILLER_64_1676 VPWR VGND sg13g2_fill_2
XFILLER_25_1638 VPWR VGND sg13g2_fill_1
X_19887_ _19887_/Y _19887_/A _20222_/B VPWR VGND sg13g2_nor2b_1
XFILLER_95_541 VPWR VGND sg13g2_decap_8
XFILLER_112_1608 VPWR VGND sg13g2_fill_1
XFILLER_95_552 VPWR VGND sg13g2_fill_1
XFILLER_56_917 VPWR VGND sg13g2_fill_1
X_18838_ _23040_/D _18838_/A _18838_/B _18838_/C VPWR VGND sg13g2_nand3_1
XFILLER_23_1351 VPWR VGND sg13g2_decap_8
XFILLER_27_118 VPWR VGND sg13g2_decap_4
XFILLER_55_438 VPWR VGND sg13g2_fill_1
X_18769_ _18769_/Y _18029_/S _23030_/Q _18766_/Y _19116_/A1 VPWR VGND sg13g2_a22oi_1
XFILLER_67_298 VPWR VGND sg13g2_decap_8
XFILLER_3_1456 VPWR VGND sg13g2_decap_8
X_20800_ _23449_/D _21237_/A1 _20801_/B _20799_/Y VPWR VGND sg13g2_o21ai_1
XFILLER_36_663 VPWR VGND sg13g2_decap_4
X_21780_ _23890_/D _21980_/A1 _21779_/B _21779_/Y VPWR VGND sg13g2_o21ai_1
Xinput4408 _20249_/A1 data_rdata_i[8] VPWR VGND sg13g2_buf_1
XFILLER_51_600 VPWR VGND sg13g2_decap_8
XFILLER_91_780 VPWR VGND sg13g2_decap_4
Xinput4419 _18856_/A instr_rdata_i[13] VPWR VGND sg13g2_buf_1
XFILLER_75_1750 VPWR VGND sg13g2_fill_1
XFILLER_36_1712 VPWR VGND sg13g2_decap_4
X_23450_ _23450_/Q clkload53/A _23450_/D fanout2772/X VPWR VGND sg13g2_dfrbpq_1
XFILLER_52_1002 VPWR VGND sg13g2_fill_2
X_20662_ _20662_/Y _20662_/A _20673_/B VPWR VGND sg13g2_nand2_1
XFILLER_75_1783 VPWR VGND sg13g2_fill_1
XFILLER_52_1013 VPWR VGND sg13g2_fill_2
XFILLER_56_1182 VPWR VGND sg13g2_decap_8
XFILLER_36_1767 VPWR VGND sg13g2_fill_1
X_22401_ _24186_/D _22401_/A1 _22402_/B _22400_/Y VPWR VGND sg13g2_o21ai_1
XFILLER_104_1103 VPWR VGND sg13g2_decap_8
XFILLER_50_187 VPWR VGND sg13g2_decap_8
X_23381_ _23381_/Q clkload57/A _23381_/D fanout2754/X VPWR VGND sg13g2_dfrbpq_1
XFILLER_108_1283 VPWR VGND sg13g2_decap_8
X_20593_ _23351_/D _21299_/A1 _20646_/S _20592_/Y VPWR VGND sg13g2_o21ai_1
XFILLER_17_1166 VPWR VGND sg13g2_decap_4
XFILLER_17_1199 VPWR VGND sg13g2_decap_8
X_22332_ _24153_/D _19788_/Y _22341_/B _22331_/Y VPWR VGND sg13g2_o21ai_1
XFILLER_34_1491 VPWR VGND sg13g2_fill_1
XFILLER_10_1907 VPWR VGND sg13g2_decap_8
X_22263_ _22263_/Y _22263_/A _22263_/B VPWR VGND sg13g2_nand2_1
X_24002_ _24002_/Q _24131_/CLK _24002_/D fanout2745/X VPWR VGND sg13g2_dfrbpq_1
X_21214_ _23631_/D _23631_/Q _21346_/A0 _21220_/S VPWR VGND sg13g2_mux2_1
XFILLER_69_1565 VPWR VGND sg13g2_decap_8
XFILLER_105_635 VPWR VGND sg13g2_decap_8
X_22194_ _24086_/D _22260_/A1 _22249_/S _22193_/Y VPWR VGND sg13g2_o21ai_1
XFILLER_104_112 VPWR VGND sg13g2_decap_8
XFILLER_2_239 VPWR VGND sg13g2_decap_8
XFILLER_65_1429 VPWR VGND sg13g2_decap_8
X_21145_ _21145_/Y _23598_/Q _21154_/B VPWR VGND sg13g2_nand2_1
XFILLER_63_1142 VPWR VGND sg13g2_decap_8
XFILLER_8_1345 VPWR VGND sg13g2_decap_8
XFILLER_43_1727 VPWR VGND sg13g2_decap_4
X_21076_ _23568_/D _22311_/A1 _21085_/B _21075_/Y VPWR VGND sg13g2_o21ai_1
XFILLER_86_530 VPWR VGND sg13g2_fill_1
XFILLER_101_852 VPWR VGND sg13g2_fill_1
X_20027_ _20043_/A _24258_/A _20318_/B VPWR VGND sg13g2_nand2_1
XFILLER_115_1276 VPWR VGND sg13g2_decap_8
XFILLER_101_874 VPWR VGND sg13g2_decap_8
XFILLER_41_1451 VPWR VGND sg13g2_fill_2
XFILLER_100_384 VPWR VGND sg13g2_fill_1
X_11800_ _11803_/C _12788_/B _11800_/B VPWR VGND sg13g2_nor2_1
XFILLER_15_814 VPWR VGND sg13g2_fill_1
X_12780_ _12780_/Y _13028_/A _12782_/A VPWR VGND sg13g2_nor2b_1
X_21978_ _23985_/D _21978_/A0 _23985_/Q _21981_/S VPWR VGND sg13g2_mux2_1
XFILLER_55_994 VPWR VGND sg13g2_decap_8
XFILLER_76_1547 VPWR VGND sg13g2_fill_2
X_11731_ _11731_/Y _11731_/A _11731_/B _11731_/C _11731_/D VPWR VGND sg13g2_nor4_2
XFILLER_15_847 VPWR VGND sg13g2_fill_1
XFILLER_42_633 VPWR VGND sg13g2_decap_8
X_23717_ _23717_/Q clkload39/A _23717_/D fanout2735/X VPWR VGND sg13g2_dfrbpq_1
X_20929_ _23510_/D _20929_/A1 _20930_/B _20928_/Y VPWR VGND sg13g2_o21ai_1
XFILLER_109_1036 VPWR VGND sg13g2_fill_2
XFILLER_14_346 VPWR VGND sg13g2_decap_8
XFILLER_42_655 VPWR VGND sg13g2_decap_4
XFILLER_70_964 VPWR VGND sg13g2_fill_1
XFILLER_93_1872 VPWR VGND sg13g2_decap_8
XFILLER_41_143 VPWR VGND sg13g2_decap_8
XFILLER_39_1380 VPWR VGND sg13g2_decap_8
X_14450_ _17042_/C _15133_/A _24221_/Q _14609_/B _14450_/D VPWR VGND sg13g2_nor4_1
XFILLER_106_1902 VPWR VGND sg13g2_decap_8
X_11662_ _14618_/B _11662_/A _11662_/B VPWR VGND sg13g2_xnor2_1
XFILLER_19_1954 VPWR VGND sg13g2_fill_1
X_23648_ _23648_/Q clkload39/A _23648_/D fanout2739/X VPWR VGND sg13g2_dfrbpq_1
XFILLER_30_839 VPWR VGND sg13g2_decap_8
X_13401_ _13402_/B _13397_/X _13398_/X _13399_/X _13400_/X _13560_/S _13706_/S VPWR
+ VGND sg13g2_mux4_1
XFILLER_15_1829 VPWR VGND sg13g2_decap_8
X_14381_ _14382_/A _15262_/A _15257_/B VPWR VGND sg13g2_nand2_1
X_11593_ _11594_/B _14434_/A _11634_/A VPWR VGND sg13g2_nand2_1
X_23579_ _23579_/Q clkload59/A _23579_/D fanout2787/X VPWR VGND sg13g2_dfrbpq_1
X_16120_ _16120_/Y _22497_/Q _16119_/B _16119_/Y VPWR VGND sg13g2_a21oi_1
X_13332_ _13333_/A _23915_/Q _14147_/C _13331_/X _13707_/S0 VPWR VGND sg13g2_a22oi_1
XFILLER_70_1179 VPWR VGND sg13g2_fill_2
XFILLER_10_563 VPWR VGND sg13g2_fill_1
X_16051_ _16051_/Y _22484_/Q _16075_/B _16050_/Y VPWR VGND sg13g2_a21oi_1
X_13263_ _13263_/Y _13264_/B _23594_/Q _13262_/Y VPWR VGND sg13g2_o21ai_1
XFILLER_68_1020 VPWR VGND sg13g2_decap_4
XFILLER_109_996 VPWR VGND sg13g2_decap_4
X_15002_ _16292_/A _16322_/B VPWR VGND sg13g2_inv_1
X_12214_ _12215_/B _23421_/Q _23485_/Q _12216_/S VPWR VGND sg13g2_mux2_1
XFILLER_48_1616 VPWR VGND sg13g2_decap_4
X_13194_ _13194_/Y _13213_/S _13194_/B VPWR VGND sg13g2_nand2_1
XFILLER_83_1529 VPWR VGND sg13g2_decap_4
XFILLER_68_1075 VPWR VGND sg13g2_decap_8
XFILLER_97_806 VPWR VGND sg13g2_decap_4
X_12145_ _12148_/C _12145_/A _12145_/B VPWR VGND sg13g2_nor2_1
X_19810_ _19810_/Y _20316_/A3 _19881_/A2 _19881_/B1 _20316_/A1 _19996_/B2 VPWR VGND
+ sg13g2_a221oi_1
Xfanout2710 fanout2710/X fanout2711/X VPWR VGND sg13g2_buf_1
Xfanout2721 fanout2721/X fanout2724/X VPWR VGND sg13g2_buf_1
Xfanout2732 fanout2732/X fanout2734/X VPWR VGND sg13g2_buf_1
XFILLER_1_250 VPWR VGND sg13g2_fill_1
Xfanout2743 fanout2743/X fanout2791/X VPWR VGND sg13g2_buf_1
Xfanout2754 fanout2754/X fanout2760/X VPWR VGND sg13g2_buf_1
Xfanout2765 fanout2765/X fanout2766/X VPWR VGND sg13g2_buf_1
X_12076_ _12091_/A _14038_/A _14038_/B _12075_/Y VPWR VGND sg13g2_o21ai_1
X_16953_ _16954_/D _22700_/Q _22699_/Q _22696_/Q _16953_/D VPWR VGND sg13g2_nand4_1
X_19741_ _19741_/Y _20307_/A _20306_/B _19740_/Y VPWR VGND sg13g2_o21ai_1
XFILLER_110_126 VPWR VGND sg13g2_decap_8
XFILLER_104_690 VPWR VGND sg13g2_fill_2
XFILLER_81_1253 VPWR VGND sg13g2_fill_2
XFILLER_46_1373 VPWR VGND sg13g2_decap_8
Xfanout2776 fanout2776/X fanout2780/X VPWR VGND sg13g2_buf_1
XFILLER_113_1906 VPWR VGND sg13g2_decap_8
Xfanout2787 fanout2787/X fanout2788/X VPWR VGND sg13g2_buf_1
Xfanout2798 fanout2798/X fanout2799/X VPWR VGND sg13g2_buf_1
X_15904_ _15905_/B _15904_/A _15904_/B _15904_/C _15904_/D VPWR VGND sg13g2_and4_1
X_16884_ _16884_/Y _22687_/Q _16884_/B VPWR VGND sg13g2_xnor2_1
XFILLER_4_1732 VPWR VGND sg13g2_decap_8
X_18623_ _18624_/B _18623_/A _18626_/A VPWR VGND sg13g2_nor2_1
XFILLER_37_438 VPWR VGND sg13g2_fill_2
XFILLER_64_224 VPWR VGND sg13g2_decap_8
X_15835_ _15835_/Y _15947_/A1 _15834_/Y _15947_/B1 VPWR VGND sg13g2_o21ai_1
XFILLER_53_909 VPWR VGND sg13g2_decap_8
XFILLER_80_717 VPWR VGND sg13g2_decap_8
X_18554_ _18555_/B _18554_/A1 _18290_/A _18553_/Y VPWR VGND sg13g2_o21ai_1
XFILLER_92_588 VPWR VGND sg13g2_decap_4
X_15766_ _15766_/Y _15766_/A VPWR VGND sg13g2_inv_1
XFILLER_94_1625 VPWR VGND sg13g2_decap_4
X_12978_ _12979_/B _23718_/Q _23750_/Q _23782_/Q _23814_/Q _12978_/S0 _12474_/S VPWR
+ VGND sg13g2_mux4_1
XFILLER_46_994 VPWR VGND sg13g2_fill_2
XFILLER_94_1647 VPWR VGND sg13g2_decap_8
X_17505_ _17505_/Y _17505_/A _17507_/S VPWR VGND sg13g2_nand2_1
X_14717_ _14717_/X _14714_/Y _14716_/Y _14739_/S VPWR VGND sg13g2_mux2_1
X_18485_ _18485_/Y _18485_/A _18485_/B VPWR VGND sg13g2_nand2_1
X_11929_ _11929_/Y _23161_/Q _11929_/B VPWR VGND sg13g2_nand2_1
X_15697_ _15699_/A _22857_/Q _15989_/A2 _15552_/B _22927_/Q VPWR VGND sg13g2_a22oi_1
XFILLER_72_290 VPWR VGND sg13g2_fill_1
XFILLER_33_655 VPWR VGND sg13g2_decap_8
XFILLER_75_1068 VPWR VGND sg13g2_fill_1
X_17436_ _22838_/D _17854_/A1 _17437_/B _17435_/Y VPWR VGND sg13g2_o21ai_1
XFILLER_53_1311 VPWR VGND sg13g2_decap_8
XFILLER_53_1322 VPWR VGND sg13g2_decap_8
Xplace4305 _12997_/S _13243_/S0 VPWR VGND sg13g2_buf_4
Xplace4316 _12248_/S _11843_/S VPWR VGND sg13g2_buf_1
Xplace4327 _11406_/S _11924_/S0 VPWR VGND sg13g2_buf_4
Xrebuffer5306 _11776_/B1 _11772_/Y VPWR VGND sg13g2_buf_2
X_17367_ _17367_/Y _22811_/Q _17367_/B VPWR VGND sg13g2_nand2_1
Xplace4338 _14117_/A _22976_/Q VPWR VGND sg13g2_buf_1
X_14579_ _14609_/C _18742_/A _14579_/B _16860_/B VPWR VGND sg13g2_nand3_1
Xrebuffer5317 _13932_/B _13503_/Y VPWR VGND sg13g2_buf_2
Xplace3604 _14918_/B _14407_/X VPWR VGND sg13g2_buf_1
Xplace4349 _17622_/A _17573_/A VPWR VGND sg13g2_buf_1
Xrebuffer5328 _13741_/A _13932_/A VPWR VGND sg13g2_buf_1
Xrebuffer5339 _19611_/A _14618_/Y VPWR VGND sg13g2_buf_8
XFILLER_18_1497 VPWR VGND sg13g2_fill_2
XFILLER_9_350 VPWR VGND sg13g2_fill_2
X_19106_ _19106_/X _18995_/A _23121_/Q _19114_/S VPWR VGND sg13g2_mux2_1
Xplace3615 _14828_/A _18602_/A VPWR VGND sg13g2_buf_1
Xplace3626 _16013_/B1 _15662_/B1 VPWR VGND sg13g2_buf_1
X_16318_ _16319_/B _16318_/A _16318_/B VPWR VGND sg13g2_nor2_2
Xrebuffer4605 _24268_/A _15038_/A1 VPWR VGND sg13g2_buf_1
Xrebuffer4616 _12439_/A _13526_/A VPWR VGND sg13g2_buf_1
Xplace3637 _15025_/B _18635_/A2 VPWR VGND sg13g2_buf_1
X_17298_ _17298_/Y _17298_/A _17298_/B VPWR VGND sg13g2_nand2_1
Xplace3648 _14686_/B _14694_/B VPWR VGND sg13g2_buf_1
Xrebuffer4627 _15069_/B2 _13666_/Y VPWR VGND sg13g2_buf_8
Xplace3659 _16193_/B _16199_/B VPWR VGND sg13g2_buf_1
X_19037_ _19037_/Y _23060_/Q _19019_/A _19048_/B1 VPWR VGND sg13g2_o21ai_1
Xhold5007 _22341_/A _24158_/Q VPWR VGND sg13g2_dlygate4sd3_1
Xplace2936 _19061_/S _19078_/S VPWR VGND sg13g2_buf_1
X_16249_ _22520_/D _16249_/A _16249_/B VPWR VGND sg13g2_xor2_1
Xplace2947 _18821_/C _18865_/C VPWR VGND sg13g2_buf_1
Xhold5018 _22084_/A _24034_/Q VPWR VGND sg13g2_dlygate4sd3_1
Xplace2958 _16893_/A _17030_/A VPWR VGND sg13g2_buf_1
Xhold5029 _20548_/A _23330_/Q VPWR VGND sg13g2_dlygate4sd3_1
XFILLER_115_922 VPWR VGND sg13g2_fill_2
Xplace2969 _18557_/B _18535_/B VPWR VGND sg13g2_buf_1
XFILLER_56_0 VPWR VGND sg13g2_decap_8
XFILLER_114_410 VPWR VGND sg13g2_decap_8
XFILLER_99_143 VPWR VGND sg13g2_fill_1
XFILLER_115_977 VPWR VGND sg13g2_fill_1
XFILLER_88_817 VPWR VGND sg13g2_decap_8
XFILLER_115_988 VPWR VGND sg13g2_decap_8
XFILLER_87_316 VPWR VGND sg13g2_fill_2
XFILLER_114_487 VPWR VGND sg13g2_decap_8
XFILLER_102_638 VPWR VGND sg13g2_decap_8
XFILLER_99_198 VPWR VGND sg13g2_decap_8
X_19939_ _19941_/C _20295_/A1 _19937_/Y _19938_/Y _19769_/A VPWR VGND sg13g2_a22oi_1
XFILLER_96_850 VPWR VGND sg13g2_decap_8
XFILLER_60_1315 VPWR VGND sg13g2_fill_2
XFILLER_96_861 VPWR VGND sg13g2_fill_1
XFILLER_68_552 VPWR VGND sg13g2_decap_8
XFILLER_112_1405 VPWR VGND sg13g2_decap_8
XFILLER_56_703 VPWR VGND sg13g2_decap_8
X_22950_ _22950_/Q _23187_/CLK _22950_/D fanout2917/X VPWR VGND sg13g2_dfrbpq_1
XFILLER_60_1348 VPWR VGND sg13g2_decap_8
XFILLER_83_511 VPWR VGND sg13g2_fill_2
XFILLER_28_427 VPWR VGND sg13g2_decap_8
X_21901_ _23946_/D _22033_/A1 _21900_/B _21900_/Y VPWR VGND sg13g2_o21ai_1
XFILLER_95_393 VPWR VGND sg13g2_decap_8
XFILLER_83_533 VPWR VGND sg13g2_decap_8
X_22881_ _22881_/Q clkload28/A _22881_/D fanout2871/X VPWR VGND sg13g2_dfrbpq_1
XFILLER_3_1242 VPWR VGND sg13g2_decap_8
XFILLER_110_1140 VPWR VGND sg13g2_fill_1
X_21832_ _23913_/D _20187_/Y _23913_/Q _21832_/S VPWR VGND sg13g2_mux2_1
XFILLER_110_1162 VPWR VGND sg13g2_decap_4
XFILLER_102_35 VPWR VGND sg13g2_decap_8
XFILLER_36_471 VPWR VGND sg13g2_fill_1
XFILLER_64_780 VPWR VGND sg13g2_decap_4
XFILLER_97_1293 VPWR VGND sg13g2_fill_2
XFILLER_52_942 VPWR VGND sg13g2_decap_4
XFILLER_58_1255 VPWR VGND sg13g2_fill_1
XFILLER_24_655 VPWR VGND sg13g2_fill_1
XFILLER_19_1228 VPWR VGND sg13g2_decap_4
XFILLER_12_806 VPWR VGND sg13g2_decap_8
XFILLER_24_666 VPWR VGND sg13g2_fill_2
X_20714_ _23412_/D _20362_/Y _20710_/B _20713_/Y VPWR VGND sg13g2_o21ai_1
X_23502_ _23502_/Q _24170_/CLK _23502_/D fanout2640/X VPWR VGND sg13g2_dfrbpq_1
XFILLER_51_463 VPWR VGND sg13g2_decap_8
XFILLER_11_327 VPWR VGND sg13g2_decap_8
XFILLER_51_496 VPWR VGND sg13g2_decap_8
X_23433_ _23433_/Q _24205_/CLK _23433_/D fanout2679/X VPWR VGND sg13g2_dfrbpq_1
X_20645_ _23378_/D _20329_/Y _20644_/B _20644_/Y VPWR VGND sg13g2_o21ai_1
XFILLER_108_1080 VPWR VGND sg13g2_decap_8
XFILLER_32_1417 VPWR VGND sg13g2_fill_2
X_23364_ _23364_/Q _24196_/CLK _23364_/D fanout2700/X VPWR VGND sg13g2_dfrbpq_1
X_20576_ _23344_/D _20297_/Y _20581_/B _20575_/Y VPWR VGND sg13g2_o21ai_1
XFILLER_14_1851 VPWR VGND sg13g2_decap_8
X_22315_ _24147_/D _22315_/A0 _24147_/Q _22315_/S VPWR VGND sg13g2_mux2_1
XFILLER_11_21 VPWR VGND sg13g2_decap_8
XFILLER_10_1715 VPWR VGND sg13g2_decap_8
X_23295_ _23295_/Q clkload42/A _23295_/D fanout2728/X VPWR VGND sg13g2_dfrbpq_1
X_22246_ _24113_/D _22246_/A0 _24113_/Q _22249_/S VPWR VGND sg13g2_mux2_1
XFILLER_11_65 VPWR VGND sg13g2_decap_8
XFILLER_101_1887 VPWR VGND sg13g2_decap_8
XFILLER_87_14 VPWR VGND sg13g2_decap_8
Xhold4840 _21644_/A _23836_/Q VPWR VGND sg13g2_dlygate4sd3_1
XFILLER_65_1237 VPWR VGND sg13g2_decap_4
X_22177_ _24079_/D _24079_/Q _22177_/A1 _22183_/S VPWR VGND sg13g2_mux2_1
Xhold4851 _20732_/A _23417_/Q VPWR VGND sg13g2_dlygate4sd3_1
XFILLER_79_828 VPWR VGND sg13g2_fill_2
Xhold4862 _21385_/A _23712_/Q VPWR VGND sg13g2_dlygate4sd3_1
Xhold4873 _21175_/A _23612_/Q VPWR VGND sg13g2_dlygate4sd3_1
Xhold4884 _21997_/A _23993_/Q VPWR VGND sg13g2_dlygate4sd3_1
X_21128_ _21128_/Y _23589_/Q _21130_/B VPWR VGND sg13g2_nand2_1
XFILLER_8_1120 VPWR VGND sg13g2_decap_8
XFILLER_47_1682 VPWR VGND sg13g2_decap_8
Xhold4895 _21618_/A _23826_/Q VPWR VGND sg13g2_dlygate4sd3_1
XFILLER_87_850 VPWR VGND sg13g2_decap_8
XFILLER_59_541 VPWR VGND sg13g2_decap_8
XFILLER_93_308 VPWR VGND sg13g2_decap_8
XFILLER_115_1051 VPWR VGND sg13g2_decap_8
X_21059_ _23561_/D _23561_/Q _22233_/A0 _21082_/B VPWR VGND sg13g2_mux2_1
X_13950_ _13952_/C _13950_/A _13950_/B _13950_/C _13950_/D VPWR VGND sg13g2_nor4_2
XFILLER_86_360 VPWR VGND sg13g2_fill_2
XFILLER_21_1800 VPWR VGND sg13g2_decap_8
XFILLER_98_1013 VPWR VGND sg13g2_fill_1
XFILLER_98_1024 VPWR VGND sg13g2_decap_4
XFILLER_98_1046 VPWR VGND sg13g2_fill_1
X_13881_ _13883_/B _14005_/A VPWR VGND sg13g2_inv_1
XFILLER_21_1844 VPWR VGND sg13g2_decap_8
XFILLER_1_1916 VPWR VGND sg13g2_decap_8
X_15620_ _15620_/Y _22729_/Q _16013_/A2 _16013_/B1 _22665_/Q VPWR VGND sg13g2_a22oi_1
XFILLER_46_257 VPWR VGND sg13g2_decap_4
X_12832_ _12832_/Y _20013_/B _12832_/B VPWR VGND sg13g2_nand2_1
XFILLER_76_1311 VPWR VGND sg13g2_decap_4
X_15551_ _15551_/Y _22694_/Q _16013_/A2 _16013_/B1 _22630_/Q VPWR VGND sg13g2_a22oi_1
XFILLER_14_110 VPWR VGND sg13g2_fill_1
X_12763_ _12764_/B _20035_/B _12762_/Y _12843_/A VPWR VGND sg13g2_a21oi_1
XFILLER_14_143 VPWR VGND sg13g2_fill_1
X_14502_ _14508_/C _14502_/A _22587_/Q _14502_/C VPWR VGND sg13g2_nor3_1
X_11714_ _11714_/X _23608_/Q _23672_/Q _11714_/S VPWR VGND sg13g2_mux2_1
XFILLER_30_603 VPWR VGND sg13g2_fill_2
X_18270_ _18275_/B _18399_/A _18245_/Y _18264_/Y _18366_/A VPWR VGND sg13g2_a22oi_1
XFILLER_43_986 VPWR VGND sg13g2_fill_2
X_15482_ _17517_/B _15482_/A _15482_/B VPWR VGND sg13g2_nor2_1
X_12694_ _12694_/Y _13280_/B _12694_/B VPWR VGND sg13g2_nor2_1
XFILLER_70_794 VPWR VGND sg13g2_decap_8
X_17221_ _22746_/D _17220_/B _17219_/Y _17220_/Y VPWR VGND sg13g2_a21oi_1
X_14433_ _14575_/B _14433_/A _14433_/B _14433_/C _17039_/B VPWR VGND sg13g2_or4_1
XFILLER_74_1090 VPWR VGND sg13g2_fill_1
X_11645_ _11645_/X _15165_/B _14021_/B VPWR VGND sg13g2_and2_1
XFILLER_35_1063 VPWR VGND sg13g2_decap_8
XFILLER_35_1074 VPWR VGND sg13g2_fill_2
XFILLER_102_1607 VPWR VGND sg13g2_fill_2
X_17152_ _17152_/Y _22734_/Q _17152_/B VPWR VGND sg13g2_xnor2_1
XFILLER_102_1629 VPWR VGND sg13g2_decap_8
XFILLER_89_1738 VPWR VGND sg13g2_decap_8
X_16103_ _16103_/Y _17872_/A _16119_/B VPWR VGND sg13g2_nor2_1
XFILLER_6_331 VPWR VGND sg13g2_fill_1
X_13315_ _13315_/X _23595_/Q _23627_/Q _23659_/Q _23691_/Q _13671_/B _13680_/S1 VPWR
+ VGND sg13g2_mux4_1
X_17083_ _17089_/B _17083_/A _17083_/B _17083_/C VPWR VGND sg13g2_nor3_1
Xclkbuf_leaf_4_clk_i clkload10/A clkbuf_leaf_4_clk_i/A VPWR VGND sg13g2_buf_16
X_14295_ _14295_/Y _14295_/A _14295_/B VPWR VGND sg13g2_nand2_1
X_13246_ _13247_/B _13692_/A _13246_/B _13692_/B _13246_/D VPWR VGND sg13g2_nand4_1
XFILLER_108_281 VPWR VGND sg13g2_fill_2
XFILLER_48_1446 VPWR VGND sg13g2_decap_4
XFILLER_69_305 VPWR VGND sg13g2_decap_8
X_13177_ _13177_/Y _13120_/A _13174_/Y _13176_/Y VPWR VGND sg13g2_a21oi_1
XFILLER_83_1359 VPWR VGND sg13g2_fill_2
XFILLER_112_947 VPWR VGND sg13g2_decap_8
X_12128_ _12129_/C _12128_/A _12128_/B VPWR VGND sg13g2_nand2_1
XFILLER_97_658 VPWR VGND sg13g2_decap_8
XFILLER_6_1805 VPWR VGND sg13g2_decap_8
XFILLER_111_457 VPWR VGND sg13g2_fill_1
XFILLER_81_1061 VPWR VGND sg13g2_fill_1
XFILLER_96_157 VPWR VGND sg13g2_fill_2
XFILLER_26_1755 VPWR VGND sg13g2_decap_8
X_12059_ _12059_/X _24091_/Q _24123_/Q _12062_/A VPWR VGND sg13g2_mux2_1
X_16936_ _16936_/Y _17124_/A _17026_/B VPWR VGND sg13g2_nand2_1
XFILLER_81_1072 VPWR VGND sg13g2_decap_8
XFILLER_84_319 VPWR VGND sg13g2_fill_2
XFILLER_81_1083 VPWR VGND sg13g2_fill_2
XFILLER_61_1657 VPWR VGND sg13g2_fill_2
XFILLER_26_1788 VPWR VGND sg13g2_decap_8
XFILLER_42_1045 VPWR VGND sg13g2_fill_1
XFILLER_65_500 VPWR VGND sg13g2_decap_8
XFILLER_78_894 VPWR VGND sg13g2_decap_4
XFILLER_113_1747 VPWR VGND sg13g2_fill_1
XFILLER_113_1769 VPWR VGND sg13g2_decap_8
X_16867_ _16877_/B _22684_/Q VPWR VGND sg13g2_inv_1
X_19655_ _19957_/B _19702_/A _19651_/Y _19654_/Y VPWR VGND sg13g2_a21oi_1
X_18606_ _18606_/Y _15279_/Y _18780_/S _16233_/B VPWR VGND sg13g2_o21ai_1
X_15818_ _17175_/A _20208_/A _15407_/Y _15817_/Y VPWR VGND sg13g2_o21ai_1
XFILLER_65_577 VPWR VGND sg13g2_decap_8
XFILLER_111_1460 VPWR VGND sg13g2_fill_2
X_19586_ _19586_/Y _19874_/A _19703_/B _19585_/Y VPWR VGND sg13g2_o21ai_1
XFILLER_4_1584 VPWR VGND sg13g2_decap_4
XFILLER_111_1471 VPWR VGND sg13g2_fill_2
X_16798_ _16799_/B _22671_/Q _16833_/A VPWR VGND sg13g2_xnor2_1
XFILLER_94_1422 VPWR VGND sg13g2_decap_4
XFILLER_19_994 VPWR VGND sg13g2_decap_8
XFILLER_0_1437 VPWR VGND sg13g2_decap_4
XFILLER_18_482 VPWR VGND sg13g2_fill_1
XFILLER_46_791 VPWR VGND sg13g2_decap_8
X_18537_ _18537_/X _18856_/A _23075_/Q _18548_/S VPWR VGND sg13g2_mux2_1
XFILLER_20_1398 VPWR VGND sg13g2_fill_1
X_15749_ _15753_/C _22769_/Q _15700_/B _16007_/B _22801_/Q VPWR VGND sg13g2_a22oi_1
XFILLER_59_1575 VPWR VGND sg13g2_fill_2
XFILLER_80_569 VPWR VGND sg13g2_decap_8
XFILLER_21_603 VPWR VGND sg13g2_decap_8
XFILLER_34_986 VPWR VGND sg13g2_decap_4
X_18468_ _18468_/Y _18415_/Y _18467_/Y _18172_/Y VPWR VGND sg13g2_a21oi_1
XFILLER_18_1250 VPWR VGND sg13g2_decap_4
Xplace4102 _18560_/S _18549_/S VPWR VGND sg13g2_buf_1
X_17419_ _17419_/Y _22829_/Q _17419_/B VPWR VGND sg13g2_nand2_1
Xplace4113 _13966_/B _22988_/Q VPWR VGND sg13g2_buf_1
Xplace4124 _13796_/B _13213_/S VPWR VGND sg13g2_buf_1
XFILLER_21_658 VPWR VGND sg13g2_decap_8
X_18399_ _18410_/B _18399_/A _18399_/B VPWR VGND sg13g2_nor2_1
XFILLER_37_1895 VPWR VGND sg13g2_decap_8
Xplace4135 _12015_/S _12567_/A VPWR VGND sg13g2_buf_1
Xplace3401 _17315_/B _17321_/B VPWR VGND sg13g2_buf_1
XFILLER_14_1114 VPWR VGND sg13g2_decap_4
Xplace4146 _18432_/A _13964_/S1 VPWR VGND sg13g2_buf_1
XFILLER_72_1786 VPWR VGND sg13g2_decap_4
X_20430_ _23280_/D _20297_/Y _20429_/B _20429_/Y VPWR VGND sg13g2_o21ai_1
Xplace3412 _17284_/B _17291_/B VPWR VGND sg13g2_buf_1
XFILLER_33_1759 VPWR VGND sg13g2_decap_8
Xplace4157 _13565_/A _13398_/S VPWR VGND sg13g2_buf_1
Xplace4168 _11508_/S0 _11815_/S1 VPWR VGND sg13g2_buf_1
Xplace3423 _16506_/B _16517_/S VPWR VGND sg13g2_buf_1
Xplace3434 _24271_/A _15069_/B2 VPWR VGND sg13g2_buf_1
Xplace4179 _13264_/B _12789_/S VPWR VGND sg13g2_buf_1
XFILLER_101_1106 VPWR VGND sg13g2_decap_8
Xplace3445 _17811_/B _17721_/B VPWR VGND sg13g2_buf_1
XFILLER_107_708 VPWR VGND sg13g2_fill_1
XFILLER_101_1117 VPWR VGND sg13g2_fill_1
Xplace3456 _17226_/A _17113_/B VPWR VGND sg13g2_buf_1
XFILLER_107_719 VPWR VGND sg13g2_decap_4
X_20361_ _20361_/Y _20361_/A _20361_/B VPWR VGND sg13g2_nor2_1
Xplace3467 _16818_/A _16760_/A VPWR VGND sg13g2_buf_1
Xplace3478 _16673_/A _16666_/S VPWR VGND sg13g2_buf_1
Xplace3489 _15935_/S _16000_/S VPWR VGND sg13g2_buf_1
X_22100_ _24041_/D _24041_/Q _20187_/Y _22116_/S VPWR VGND sg13g2_mux2_1
X_23080_ _23080_/Q _23114_/CLK _23080_/D fanout2909/X VPWR VGND sg13g2_dfrbpq_1
X_20292_ _20292_/Y _20292_/A _20292_/B VPWR VGND sg13g2_nor2_1
X_22031_ _24009_/D _22233_/A0 _24009_/Q _22031_/S VPWR VGND sg13g2_mux2_1
XFILLER_103_914 VPWR VGND sg13g2_fill_2
XFILLER_0_507 VPWR VGND sg13g2_fill_1
XFILLER_115_796 VPWR VGND sg13g2_decap_8
XFILLER_88_625 VPWR VGND sg13g2_fill_1
XFILLER_114_273 VPWR VGND sg13g2_fill_1
XFILLER_103_958 VPWR VGND sg13g2_decap_8
XFILLER_88_658 VPWR VGND sg13g2_decap_8
XFILLER_87_135 VPWR VGND sg13g2_decap_8
XFILLER_75_308 VPWR VGND sg13g2_decap_8
X_23982_ _23982_/Q clkload36/A _23982_/D fanout2643/X VPWR VGND sg13g2_dfrbpq_1
XFILLER_84_831 VPWR VGND sg13g2_decap_8
XFILLER_28_213 VPWR VGND sg13g2_decap_8
XFILLER_44_1899 VPWR VGND sg13g2_decap_4
XFILLER_5_1348 VPWR VGND sg13g2_decap_8
X_22933_ _22933_/Q _22941_/CLK _22933_/D fanout2795/X VPWR VGND sg13g2_dfrbpq_1
XFILLER_56_533 VPWR VGND sg13g2_decap_8
XFILLER_112_1246 VPWR VGND sg13g2_decap_8
XFILLER_60_1189 VPWR VGND sg13g2_decap_8
XFILLER_113_56 VPWR VGND sg13g2_decap_8
XFILLER_44_717 VPWR VGND sg13g2_fill_1
XFILLER_83_363 VPWR VGND sg13g2_decap_8
X_22864_ _22864_/Q clkload7/A _22864_/D fanout2794/X VPWR VGND sg13g2_dfrbpq_1
XFILLER_83_385 VPWR VGND sg13g2_decap_8
XFILLER_56_599 VPWR VGND sg13g2_decap_8
XFILLER_3_1094 VPWR VGND sg13g2_fill_2
XFILLER_37_791 VPWR VGND sg13g2_fill_2
X_21815_ _23904_/D _22282_/A1 _21818_/B _21814_/Y VPWR VGND sg13g2_o21ai_1
XFILLER_71_558 VPWR VGND sg13g2_fill_1
X_22795_ _22795_/Q _22893_/CLK _22795_/D fanout2819/X VPWR VGND sg13g2_dfrbpq_1
XFILLER_24_441 VPWR VGND sg13g2_decap_8
XFILLER_38_1637 VPWR VGND sg13g2_decap_8
XFILLER_77_1697 VPWR VGND sg13g2_fill_1
XFILLER_38_1648 VPWR VGND sg13g2_fill_2
XFILLER_58_1085 VPWR VGND sg13g2_decap_4
X_21746_ _23876_/D _21956_/A1 _21751_/B _21745_/Y VPWR VGND sg13g2_o21ai_1
XFILLER_12_625 VPWR VGND sg13g2_decap_8
XFILLER_40_934 VPWR VGND sg13g2_decap_8
XFILLER_106_1006 VPWR VGND sg13g2_fill_2
XFILLER_40_945 VPWR VGND sg13g2_fill_1
XFILLER_11_124 VPWR VGND sg13g2_fill_1
XFILLER_51_1804 VPWR VGND sg13g2_decap_8
XFILLER_36_1361 VPWR VGND sg13g2_decap_8
X_21677_ _23851_/D _21677_/A1 _21690_/B _21676_/Y VPWR VGND sg13g2_o21ai_1
X_23416_ _23416_/Q clkload54/A _23416_/D fanout2781/X VPWR VGND sg13g2_dfrbpq_1
X_11430_ _11433_/C _12245_/A _11430_/B VPWR VGND sg13g2_nor2_1
XFILLER_7_128 VPWR VGND sg13g2_decap_8
XFILLER_103_1938 VPWR VGND sg13g2_decap_8
X_23347_ _23347_/Q clkload50/A _23347_/D fanout2661/X VPWR VGND sg13g2_dfrbpq_1
X_20559_ _20559_/Y _20559_/A _20572_/B VPWR VGND sg13g2_nand2_1
XFILLER_10_1501 VPWR VGND sg13g2_decap_8
XFILLER_3_301 VPWR VGND sg13g2_decap_8
XFILLER_98_35 VPWR VGND sg13g2_decap_8
XFILLER_3_312 VPWR VGND sg13g2_fill_1
Xplace3990 _13267_/A _12316_/A VPWR VGND sg13g2_buf_1
X_14080_ _14081_/B _14080_/A _14080_/B VPWR VGND sg13g2_nand2_1
X_23278_ _23278_/Q clkload35/A _23278_/D fanout2630/X VPWR VGND sg13g2_dfrbpq_1
XFILLER_101_1684 VPWR VGND sg13g2_decap_8
XFILLER_101_1695 VPWR VGND sg13g2_fill_2
XFILLER_106_763 VPWR VGND sg13g2_decap_8
X_13031_ _13032_/B _23847_/Q _23879_/Q _23943_/Q _23975_/Q _13274_/S0 _13253_/S VPWR
+ VGND sg13g2_mux4_1
X_22229_ _22229_/Y _22229_/A _22229_/B VPWR VGND sg13g2_nand2_1
XFILLER_49_1766 VPWR VGND sg13g2_decap_8
XFILLER_45_1619 VPWR VGND sg13g2_decap_8
XFILLER_84_1679 VPWR VGND sg13g2_fill_1
XFILLER_62_1900 VPWR VGND sg13g2_decap_8
XFILLER_78_113 VPWR VGND sg13g2_fill_1
Xhold4670 _17475_/A _22855_/Q VPWR VGND sg13g2_dlygate4sd3_1
Xhold4681 _17287_/A _22773_/Q VPWR VGND sg13g2_dlygate4sd3_1
XFILLER_62_1911 VPWR VGND sg13g2_fill_2
XFILLER_105_295 VPWR VGND sg13g2_decap_8
Xhold4692 _17270_/A _22765_/Q VPWR VGND sg13g2_dlygate4sd3_1
XFILLER_62_1922 VPWR VGND sg13g2_decap_4
XFILLER_94_606 VPWR VGND sg13g2_fill_2
X_17770_ _17770_/X _22572_/Q _17770_/B VPWR VGND sg13g2_xor2_1
X_14982_ _14982_/X _23141_/Q _16288_/B _14982_/S VPWR VGND sg13g2_mux2_1
XFILLER_43_1354 VPWR VGND sg13g2_fill_2
XFILLER_47_511 VPWR VGND sg13g2_decap_8
XFILLER_43_1365 VPWR VGND sg13g2_fill_2
X_16721_ _22659_/D _17854_/A1 _16728_/A _16720_/Y VPWR VGND sg13g2_a21oi_1
X_13933_ _13934_/B _13931_/A _13931_/B _13885_/B _13932_/Y VPWR VGND sg13g2_a22oi_1
XFILLER_47_544 VPWR VGND sg13g2_decap_8
XFILLER_78_1406 VPWR VGND sg13g2_decap_8
XFILLER_47_72 VPWR VGND sg13g2_fill_1
XFILLER_21_1630 VPWR VGND sg13g2_fill_1
XFILLER_5_1882 VPWR VGND sg13g2_decap_8
XFILLER_1_1713 VPWR VGND sg13g2_decap_8
XFILLER_75_875 VPWR VGND sg13g2_decap_4
XFILLER_21_1652 VPWR VGND sg13g2_decap_8
XFILLER_47_577 VPWR VGND sg13g2_decap_8
X_16652_ _16652_/Y _16656_/A _16652_/B VPWR VGND sg13g2_nor2_1
XFILLER_35_728 VPWR VGND sg13g2_fill_1
X_13864_ _13864_/Y _13864_/A _13864_/B _13864_/C VPWR VGND sg13g2_nand3_1
XFILLER_35_739 VPWR VGND sg13g2_fill_2
XFILLER_74_385 VPWR VGND sg13g2_decap_8
XFILLER_16_931 VPWR VGND sg13g2_fill_1
X_15603_ _15606_/B _22922_/Q _15552_/B _15602_/Y VPWR VGND sg13g2_a21oi_1
XFILLER_74_396 VPWR VGND sg13g2_fill_1
X_19371_ _19371_/Y _19448_/A _19463_/S VPWR VGND sg13g2_nor2_1
X_12815_ _12816_/B _23908_/Q _24004_/Q _24100_/Q _24132_/Q _12813_/S _12452_/A VPWR
+ VGND sg13g2_mux4_1
X_16583_ _16583_/Y _16591_/A _16583_/B VPWR VGND sg13g2_nor2_1
XFILLER_95_1764 VPWR VGND sg13g2_decap_8
X_13795_ _13795_/X _24049_/Q _24081_/Q _24113_/Q _24145_/Q _13798_/B2 _13795_/S1 VPWR
+ VGND sg13g2_mux4_1
XFILLER_50_709 VPWR VGND sg13g2_decap_8
XFILLER_90_889 VPWR VGND sg13g2_fill_1
X_18322_ _18385_/D _18476_/A _18501_/S _18322_/C VPWR VGND sg13g2_nand3_1
X_15534_ _15535_/B _22460_/Q _15639_/B _15296_/Y _22887_/Q _15533_/Y VPWR VGND sg13g2_a221oi_1
XFILLER_108_1827 VPWR VGND sg13g2_decap_8
XFILLER_91_1639 VPWR VGND sg13g2_decap_8
X_12746_ _12746_/Y _19235_/B _12746_/A2 _12668_/A _12746_/B2 _12584_/Y VPWR VGND sg13g2_a221oi_1
XFILLER_76_1185 VPWR VGND sg13g2_decap_4
XFILLER_97_7 VPWR VGND sg13g2_decap_8
XFILLER_15_485 VPWR VGND sg13g2_decap_8
XFILLER_42_271 VPWR VGND sg13g2_fill_2
X_18253_ _18253_/Y _18252_/Y _18253_/B VPWR VGND sg13g2_nand2b_1
XFILLER_15_1401 VPWR VGND sg13g2_fill_1
X_15465_ _15466_/C _15465_/A _15465_/B _15465_/C VPWR VGND sg13g2_nand3_1
X_12677_ _12692_/A _12677_/A _12677_/B VPWR VGND sg13g2_nor2_1
X_17204_ _17205_/A _22743_/Q VPWR VGND sg13g2_inv_1
XFILLER_8_44 VPWR VGND sg13g2_fill_2
XFILLER_8_55 VPWR VGND sg13g2_decap_8
X_18184_ _18184_/Y _18406_/A _18184_/B _18184_/C VPWR VGND sg13g2_nand3_1
X_11628_ _11628_/Y _14122_/C _11628_/B VPWR VGND sg13g2_nand2_1
X_15396_ _15404_/A _16435_/A _15396_/B _15396_/C _15396_/D VPWR VGND sg13g2_nand4_1
XFILLER_89_1513 VPWR VGND sg13g2_fill_2
XFILLER_89_1524 VPWR VGND sg13g2_fill_2
XFILLER_11_691 VPWR VGND sg13g2_fill_1
X_17135_ _17135_/Y _17135_/A _17141_/B VPWR VGND sg13g2_nor2_1
X_14347_ _14347_/Y _19673_/A _14347_/B _14372_/D _14347_/D VPWR VGND sg13g2_nand4_1
XFILLER_7_662 VPWR VGND sg13g2_fill_1
X_11559_ _11559_/Y _14098_/A _14098_/C _11606_/A _14098_/B VPWR VGND sg13g2_nor4_2
XFILLER_7_673 VPWR VGND sg13g2_fill_2
XFILLER_6_150 VPWR VGND sg13g2_fill_1
XFILLER_67_1844 VPWR VGND sg13g2_fill_2
XFILLER_98_901 VPWR VGND sg13g2_fill_1
X_16017_ _16017_/Y _16017_/A _16352_/B _16017_/C VPWR VGND sg13g2_nand3_1
X_13229_ _13229_/Y _13232_/S _24042_/Q _13228_/Y VPWR VGND sg13g2_o21ai_1
XFILLER_28_1817 VPWR VGND sg13g2_decap_8
XFILLER_100_1194 VPWR VGND sg13g2_decap_8
XFILLER_63_1708 VPWR VGND sg13g2_fill_2
XFILLER_112_733 VPWR VGND sg13g2_decap_8
XFILLER_69_113 VPWR VGND sg13g2_decap_4
XFILLER_111_210 VPWR VGND sg13g2_decap_8
XFILLER_98_956 VPWR VGND sg13g2_decap_8
XFILLER_3_890 VPWR VGND sg13g2_decap_8
XFILLER_48_1287 VPWR VGND sg13g2_decap_8
XFILLER_69_157 VPWR VGND sg13g2_decap_8
XFILLER_100_939 VPWR VGND sg13g2_fill_1
XFILLER_97_499 VPWR VGND sg13g2_decap_8
XFILLER_85_639 VPWR VGND sg13g2_decap_8
XFILLER_6_1635 VPWR VGND sg13g2_decap_8
X_17968_ _17968_/Y _18393_/S _17968_/B VPWR VGND sg13g2_nand2_1
XFILLER_111_287 VPWR VGND sg13g2_fill_1
X_19707_ _19707_/Y _19987_/A _19987_/B _19706_/Y VPWR VGND sg13g2_o21ai_1
XFILLER_19_0 VPWR VGND sg13g2_decap_8
XFILLER_6_1668 VPWR VGND sg13g2_fill_1
XFILLER_22_1427 VPWR VGND sg13g2_decap_4
X_16919_ _16920_/B _17030_/A _16954_/B _16919_/C VPWR VGND sg13g2_nor3_1
XFILLER_6_1679 VPWR VGND sg13g2_decap_8
XFILLER_77_190 VPWR VGND sg13g2_decap_4
X_17899_ _17899_/Y _17899_/A _17917_/B VPWR VGND sg13g2_nor2_1
X_19638_ _19638_/X _19336_/X _19358_/X _19638_/S VPWR VGND sg13g2_mux2_1
XFILLER_25_205 VPWR VGND sg13g2_decap_4
XFILLER_92_171 VPWR VGND sg13g2_decap_8
XFILLER_25_227 VPWR VGND sg13g2_decap_8
XFILLER_92_193 VPWR VGND sg13g2_decap_8
X_19569_ _19569_/Y _19986_/A _19934_/B _19568_/Y VPWR VGND sg13g2_o21ai_1
XFILLER_80_344 VPWR VGND sg13g2_fill_1
XFILLER_34_750 VPWR VGND sg13g2_fill_2
XFILLER_74_1826 VPWR VGND sg13g2_decap_8
X_21600_ _21600_/Y _23815_/Q _21600_/B VPWR VGND sg13g2_nand2_1
XFILLER_74_1848 VPWR VGND sg13g2_decap_8
X_22580_ _22580_/Q _22917_/CLK _22580_/D fanout2895/X VPWR VGND sg13g2_dfrbpq_1
XFILLER_107_1304 VPWR VGND sg13g2_decap_4
XFILLER_22_923 VPWR VGND sg13g2_fill_2
XFILLER_94_1296 VPWR VGND sg13g2_decap_8
XFILLER_107_1337 VPWR VGND sg13g2_decap_8
XFILLER_33_293 VPWR VGND sg13g2_decap_8
X_21531_ _23781_/D _21958_/A1 _21530_/B _21530_/Y VPWR VGND sg13g2_o21ai_1
XFILLER_22_978 VPWR VGND sg13g2_decap_4
XFILLER_72_1583 VPWR VGND sg13g2_decap_8
X_24250_ _24250_/X _24250_/A VPWR VGND sg13g2_buf_1
X_21462_ _23748_/D _21956_/A1 _21473_/B _21461_/Y VPWR VGND sg13g2_o21ai_1
Xplace3220 _22450_/B _22385_/X VPWR VGND sg13g2_buf_1
Xplace3231 _21754_/B _21779_/B VPWR VGND sg13g2_buf_1
X_20413_ _23270_/D _22427_/A1 _20412_/B _20412_/Y VPWR VGND sg13g2_o21ai_1
X_23201_ _23201_/Q clkload33/A _23201_/D fanout2931/X VPWR VGND sg13g2_dfrbpq_1
XFILLER_33_1589 VPWR VGND sg13g2_decap_8
Xplace3242 _21215_/B _21209_/B VPWR VGND sg13g2_buf_1
X_24181_ _24181_/Q clkload48/A _24181_/D fanout2755/X VPWR VGND sg13g2_dfrbpq_1
XFILLER_88_1023 VPWR VGND sg13g2_decap_4
X_21393_ _23715_/D _21954_/A1 _21398_/B _21392_/Y VPWR VGND sg13g2_o21ai_1
Xplace3253 _22317_/A1 _22451_/A1 VPWR VGND sg13g2_buf_1
Xplace3264 _22448_/A1 _20329_/Y VPWR VGND sg13g2_buf_1
XFILLER_50_1870 VPWR VGND sg13g2_fill_2
XFILLER_107_527 VPWR VGND sg13g2_decap_8
Xplace3275 _21336_/A0 _22233_/A0 VPWR VGND sg13g2_buf_1
XFILLER_11_1832 VPWR VGND sg13g2_decap_8
XFILLER_85_1900 VPWR VGND sg13g2_decap_8
X_20344_ _20344_/Y _20344_/A1 _20343_/X _20107_/Y VPWR VGND sg13g2_o21ai_1
Xplace3286 _21329_/A1 _20124_/Y VPWR VGND sg13g2_buf_1
X_23132_ _23132_/Q clkload5/A _23132_/D fanout2833/X VPWR VGND sg13g2_dfrbpq_1
Xplace3297 _22280_/A1 _19972_/Y VPWR VGND sg13g2_buf_1
XFILLER_108_56 VPWR VGND sg13g2_decap_8
X_23063_ _23063_/Q clkload14/A _23063_/D fanout2843/X VPWR VGND sg13g2_dfrbpq_1
XFILLER_103_700 VPWR VGND sg13g2_fill_2
X_20275_ _20275_/Y _20295_/A1 _19800_/Y _20274_/Y VPWR VGND sg13g2_a21oi_1
XFILLER_88_411 VPWR VGND sg13g2_decap_8
XFILLER_46_1939 VPWR VGND sg13g2_decap_8
X_22014_ _24000_/D _22282_/A1 _22017_/B _22013_/Y VPWR VGND sg13g2_o21ai_1
XFILLER_115_593 VPWR VGND sg13g2_decap_8
XFILLER_103_733 VPWR VGND sg13g2_decap_4
XFILLER_102_221 VPWR VGND sg13g2_decap_8
XFILLER_89_978 VPWR VGND sg13g2_fill_2
XFILLER_66_1398 VPWR VGND sg13g2_fill_1
XFILLER_88_466 VPWR VGND sg13g2_decap_4
XFILLER_103_777 VPWR VGND sg13g2_decap_8
XFILLER_76_617 VPWR VGND sg13g2_decap_8
XFILLER_25_1040 VPWR VGND sg13g2_fill_2
XFILLER_76_639 VPWR VGND sg13g2_decap_8
XFILLER_75_127 VPWR VGND sg13g2_fill_2
X_23965_ _23965_/Q _23966_/CLK _23965_/D fanout2786/X VPWR VGND sg13g2_dfrbpq_1
X_22916_ _22916_/Q _22917_/CLK _22916_/D fanout2871/X VPWR VGND sg13g2_dfrbpq_1
XFILLER_72_812 VPWR VGND sg13g2_fill_1
XFILLER_44_514 VPWR VGND sg13g2_fill_1
X_23896_ _23896_/Q clkload46/A _23896_/D fanout2676/X VPWR VGND sg13g2_dfrbpq_1
XFILLER_56_385 VPWR VGND sg13g2_decap_8
XFILLER_44_558 VPWR VGND sg13g2_fill_1
X_22847_ _22847_/Q _22917_/CLK _22847_/D fanout2892/X VPWR VGND sg13g2_dfrbpq_1
X_12600_ _12600_/Y _23553_/Q _12922_/A2 _12599_/X _12452_/A _12816_/A VPWR VGND sg13g2_a221oi_1
X_13580_ _13597_/B _13580_/A1 _13577_/X _13579_/X VPWR VGND sg13g2_o21ai_1
XFILLER_71_388 VPWR VGND sg13g2_fill_1
X_22778_ _22778_/Q clkload8/A _22778_/D fanout2798/X VPWR VGND sg13g2_dfrbpq_1
XFILLER_25_794 VPWR VGND sg13g2_decap_8
XFILLER_38_1478 VPWR VGND sg13g2_decap_8
X_12531_ _12544_/A _12531_/A _12531_/B _12543_/S _12531_/D VPWR VGND sg13g2_or4_1
XFILLER_38_1489 VPWR VGND sg13g2_fill_1
X_21729_ _21729_/Y _21729_/A _21738_/B VPWR VGND sg13g2_nand2_1
XFILLER_33_52 VPWR VGND sg13g2_decap_8
XFILLER_107_1860 VPWR VGND sg13g2_decap_8
XFILLER_32_1000 VPWR VGND sg13g2_decap_8
XFILLER_90_1683 VPWR VGND sg13g2_fill_1
X_15250_ _15261_/B _16778_/A _15923_/A _15538_/A _15250_/D VPWR VGND sg13g2_nand4_1
X_12462_ _12462_/X _13778_/A1 _13181_/B _22559_/Q VPWR VGND sg13g2_a21o_1
X_14201_ _14253_/A _15479_/B2 _22838_/Q _14200_/X VPWR VGND sg13g2_a21oi_1
X_11413_ _11414_/B _23414_/Q _23446_/Q _11749_/S VPWR VGND sg13g2_mux2_1
X_15181_ _15210_/B _17390_/A _15478_/B _15478_/C VPWR VGND sg13g2_nor3_1
X_12393_ _12412_/D _12460_/A _12390_/X _12392_/X VPWR VGND sg13g2_o21ai_1
XFILLER_32_1099 VPWR VGND sg13g2_decap_8
X_14132_ _14132_/Y _14129_/Y _21984_/A _14132_/C VPWR VGND sg13g2_nand3b_1
XFILLER_67_1107 VPWR VGND sg13g2_decap_8
XFILLER_99_709 VPWR VGND sg13g2_decap_4
XFILLER_4_643 VPWR VGND sg13g2_decap_8
XFILLER_3_131 VPWR VGND sg13g2_decap_8
XFILLER_98_208 VPWR VGND sg13g2_fill_2
XFILLER_113_519 VPWR VGND sg13g2_decap_8
X_18940_ _18942_/B _18940_/A _18951_/A VPWR VGND sg13g2_nand2_1
X_14063_ _14064_/D _14935_/A _14935_/B _14977_/A1 VPWR VGND sg13g2_a21oi_1
X_11275_ _11275_/X _23543_/Q _23991_/Q _11726_/S VPWR VGND sg13g2_mux2_1
XFILLER_4_687 VPWR VGND sg13g2_fill_1
Xhold5190 _20492_/A _23306_/Q VPWR VGND sg13g2_dlygate4sd3_1
XFILLER_4_698 VPWR VGND sg13g2_decap_8
X_13014_ _13014_/Y _13014_/A _13072_/A VPWR VGND sg13g2_xnor2_1
X_18871_ _18873_/B _18871_/A _18884_/B VPWR VGND sg13g2_nand2_1
XFILLER_7_1911 VPWR VGND sg13g2_decap_8
X_17822_ _17822_/Y _23187_/Q _17822_/A2 _17822_/B1 _14436_/A VPWR VGND sg13g2_a22oi_1
XFILLER_58_71 VPWR VGND sg13g2_fill_2
XFILLER_67_639 VPWR VGND sg13g2_decap_8
XFILLER_114_1853 VPWR VGND sg13g2_decap_8
XFILLER_12_7 VPWR VGND sg13g2_fill_2
XFILLER_97_1804 VPWR VGND sg13g2_fill_1
X_14965_ _14965_/Y _22528_/Q _15042_/B VPWR VGND sg13g2_nand2b_1
X_17753_ _22899_/D _17721_/B _17750_/Y _17752_/Y VPWR VGND sg13g2_a21oi_1
XFILLER_48_853 VPWR VGND sg13g2_fill_1
XFILLER_97_1815 VPWR VGND sg13g2_decap_8
XFILLER_43_1195 VPWR VGND sg13g2_decap_8
XFILLER_75_650 VPWR VGND sg13g2_fill_1
X_16704_ _16709_/B _22655_/Q VPWR VGND sg13g2_inv_1
X_13916_ _13916_/X _23603_/Q _23635_/Q _23667_/Q _23699_/Q _13919_/S0 _13919_/S1 VPWR
+ VGND sg13g2_mux4_1
X_17684_ _22891_/D _17702_/B _17682_/Y _17683_/Y VPWR VGND sg13g2_a21oi_1
XFILLER_63_823 VPWR VGND sg13g2_fill_2
XFILLER_78_1236 VPWR VGND sg13g2_decap_8
X_14896_ _14896_/Y _14949_/A _14896_/B _14896_/C VPWR VGND sg13g2_nand3_1
Xclkbuf_leaf_22_clk_i clkload32/A clkload1/A VPWR VGND sg13g2_buf_16
XFILLER_74_160 VPWR VGND sg13g2_decap_4
XFILLER_21_1460 VPWR VGND sg13g2_decap_8
XFILLER_39_1209 VPWR VGND sg13g2_decap_4
X_19423_ _19572_/A _19423_/A _19423_/B VPWR VGND sg13g2_nand2_1
XFILLER_35_547 VPWR VGND sg13g2_decap_8
X_16635_ _16636_/B _16635_/A _16638_/C VPWR VGND sg13g2_nand2_1
XFILLER_90_653 VPWR VGND sg13g2_decap_8
XFILLER_1_1554 VPWR VGND sg13g2_fill_2
X_13847_ _13847_/Y _13717_/B _13846_/Y _13350_/A VPWR VGND sg13g2_a21oi_1
XFILLER_50_517 VPWR VGND sg13g2_decap_4
X_19354_ _19354_/Y _20179_/A _19576_/B VPWR VGND sg13g2_nor2_1
X_13778_ _13778_/X _13778_/A1 _13923_/A2 _22576_/Q VPWR VGND sg13g2_a21o_1
XFILLER_50_539 VPWR VGND sg13g2_decap_8
XFILLER_17_1518 VPWR VGND sg13g2_fill_2
XFILLER_108_1646 VPWR VGND sg13g2_decap_8
X_18305_ _18305_/Y _18301_/Y _18304_/Y _18221_/S VPWR VGND sg13g2_a21oi_1
X_15517_ _15517_/X _17858_/A _15516_/Y _15589_/S VPWR VGND sg13g2_mux2_1
Xclkbuf_leaf_37_clk_i clkload55/A clkbuf_leaf_42_clk_i/A VPWR VGND sg13g2_buf_16
X_19285_ _23203_/D _23203_/Q _20343_/A1 _19303_/S VPWR VGND sg13g2_mux2_1
XFILLER_34_1810 VPWR VGND sg13g2_fill_1
X_12729_ _12729_/X _23715_/Q _23747_/Q _23779_/Q _23811_/Q _12978_/S0 _12884_/B VPWR
+ VGND sg13g2_mux4_1
X_16497_ _22610_/D _16169_/A _16506_/B _16496_/Y VPWR VGND sg13g2_o21ai_1
X_18236_ _18236_/Y _18363_/B _18236_/B VPWR VGND sg13g2_nor2_1
XFILLER_90_91 VPWR VGND sg13g2_fill_1
X_15448_ _16785_/C _15452_/C _15448_/B VPWR VGND sg13g2_and2_1
XFILLER_54_1280 VPWR VGND sg13g2_fill_1
XFILLER_30_1718 VPWR VGND sg13g2_fill_2
XFILLER_106_1392 VPWR VGND sg13g2_decap_4
X_15379_ _15379_/X _16054_/A _15377_/Y _15589_/S VPWR VGND sg13g2_mux2_1
XFILLER_102_1245 VPWR VGND sg13g2_fill_2
XFILLER_8_982 VPWR VGND sg13g2_fill_2
XFILLER_11_1139 VPWR VGND sg13g2_decap_8
X_17118_ _17118_/Y _22728_/Q _17118_/B VPWR VGND sg13g2_xnor2_1
XFILLER_69_1939 VPWR VGND sg13g2_decap_8
XFILLER_89_1387 VPWR VGND sg13g2_decap_8
XFILLER_85_1218 VPWR VGND sg13g2_decap_4
XFILLER_104_519 VPWR VGND sg13g2_decap_8
X_17049_ _17049_/X _17036_/Y _17037_/Y _17049_/S VPWR VGND sg13g2_mux2_1
XFILLER_89_219 VPWR VGND sg13g2_decap_8
XFILLER_28_1614 VPWR VGND sg13g2_decap_4
XFILLER_67_1674 VPWR VGND sg13g2_fill_2
X_20060_ _20060_/Y _20060_/A _20060_/B VPWR VGND sg13g2_nor2_1
XFILLER_112_530 VPWR VGND sg13g2_decap_8
XFILLER_28_1647 VPWR VGND sg13g2_fill_2
XFILLER_48_1073 VPWR VGND sg13g2_decap_8
XFILLER_115_1606 VPWR VGND sg13g2_decap_8
XFILLER_100_703 VPWR VGND sg13g2_fill_2
XFILLER_86_926 VPWR VGND sg13g2_fill_2
XFILLER_85_403 VPWR VGND sg13g2_decap_8
XFILLER_85_436 VPWR VGND sg13g2_decap_4
XFILLER_85_447 VPWR VGND sg13g2_decap_8
XFILLER_100_758 VPWR VGND sg13g2_fill_1
XFILLER_57_149 VPWR VGND sg13g2_decap_8
XFILLER_66_650 VPWR VGND sg13g2_fill_2
XFILLER_96_1303 VPWR VGND sg13g2_fill_2
X_23750_ _23750_/Q clkload40/A _23750_/D fanout2735/X VPWR VGND sg13g2_dfrbpq_1
XFILLER_94_992 VPWR VGND sg13g2_decap_8
X_20962_ _20962_/Y _23526_/Q _20962_/B VPWR VGND sg13g2_nand2_1
XFILLER_81_631 VPWR VGND sg13g2_fill_2
X_22701_ _22701_/Q clkload20/A _22701_/D fanout2868/X VPWR VGND sg13g2_dfrbpq_1
XFILLER_96_1369 VPWR VGND sg13g2_fill_2
XFILLER_0_1031 VPWR VGND sg13g2_fill_2
XFILLER_81_653 VPWR VGND sg13g2_decap_8
X_23681_ _23681_/Q _23682_/CLK _23681_/D fanout2728/X VPWR VGND sg13g2_dfrbpq_1
X_20893_ _23492_/D _21327_/A1 _20903_/B _20892_/Y VPWR VGND sg13g2_o21ai_1
X_22632_ _22632_/Q clkload23/A _22632_/D fanout2883/X VPWR VGND sg13g2_dfrbpq_1
XFILLER_74_1645 VPWR VGND sg13g2_decap_8
XFILLER_110_35 VPWR VGND sg13g2_decap_8
XFILLER_41_539 VPWR VGND sg13g2_fill_1
XFILLER_53_399 VPWR VGND sg13g2_fill_2
XFILLER_22_753 VPWR VGND sg13g2_fill_2
X_22563_ _22563_/Q clkload26/A _22563_/D fanout2851/X VPWR VGND sg13g2_dfrbpq_1
XFILLER_16_1028 VPWR VGND sg13g2_decap_8
XFILLER_52_1921 VPWR VGND sg13g2_decap_4
XFILLER_70_28 VPWR VGND sg13g2_decap_8
XFILLER_107_1145 VPWR VGND sg13g2_decap_8
XFILLER_22_775 VPWR VGND sg13g2_decap_4
X_21514_ _23773_/D _21941_/A1 _21515_/B _21513_/Y VPWR VGND sg13g2_o21ai_1
XFILLER_21_274 VPWR VGND sg13g2_fill_2
XFILLER_52_1954 VPWR VGND sg13g2_fill_1
X_22494_ _22494_/Q clkload26/A _22494_/D fanout2824/X VPWR VGND sg13g2_dfrbpq_1
XFILLER_13_1927 VPWR VGND sg13g2_decap_8
XFILLER_21_296 VPWR VGND sg13g2_decap_8
XFILLER_108_803 VPWR VGND sg13g2_fill_1
X_24233_ _24233_/Q clkload11/A _24233_/D fanout2846/X VPWR VGND sg13g2_dfrbpq_1
X_21445_ _21445_/Y _23741_/Q _21447_/B VPWR VGND sg13g2_nand2_1
Xplace3050 _21942_/B _21935_/B VPWR VGND sg13g2_buf_1
Xplace3061 _21915_/S _21916_/B VPWR VGND sg13g2_buf_1
Xplace3072 _21833_/B _21832_/S VPWR VGND sg13g2_buf_1
X_21376_ _21376_/Y _21376_/A _21380_/B VPWR VGND sg13g2_nand2_1
X_24164_ _24164_/Q _24196_/CLK _24164_/D fanout2706/X VPWR VGND sg13g2_dfrbpq_1
Xplace3083 _21549_/B _21555_/B VPWR VGND sg13g2_buf_1
XFILLER_107_346 VPWR VGND sg13g2_decap_8
Xplace3094 _21489_/B _21486_/B VPWR VGND sg13g2_buf_1
X_20327_ _20328_/B _19325_/X _19659_/Y _19665_/Y _20062_/B _20326_/Y VPWR VGND sg13g2_a221oi_1
X_23115_ _23115_/Q clkload12/A _23115_/D fanout2911/X VPWR VGND sg13g2_dfrbpq_1
XFILLER_107_379 VPWR VGND sg13g2_fill_1
XFILLER_85_1752 VPWR VGND sg13g2_decap_8
X_24095_ _24095_/Q _24131_/CLK _24095_/D fanout2750/X VPWR VGND sg13g2_dfrbpq_1
XFILLER_46_1714 VPWR VGND sg13g2_decap_4
XFILLER_0_101 VPWR VGND sg13g2_decap_4
X_23046_ _23046_/Q clkload13/A _23046_/D fanout2910/X VPWR VGND sg13g2_dfrbpq_1
X_20258_ _20258_/Y _20258_/A _20292_/B VPWR VGND sg13g2_nor2_1
XFILLER_115_390 VPWR VGND sg13g2_decap_8
XFILLER_103_541 VPWR VGND sg13g2_decap_8
XFILLER_89_764 VPWR VGND sg13g2_decap_8
XFILLER_95_14 VPWR VGND sg13g2_decap_8
XFILLER_95_25 VPWR VGND sg13g2_fill_2
XFILLER_114_1116 VPWR VGND sg13g2_decap_8
XFILLER_89_797 VPWR VGND sg13g2_decap_8
XFILLER_88_274 VPWR VGND sg13g2_fill_2
XFILLER_27_1179 VPWR VGND sg13g2_fill_2
XFILLER_76_425 VPWR VGND sg13g2_fill_2
XFILLER_76_458 VPWR VGND sg13g2_fill_1
XFILLER_64_609 VPWR VGND sg13g2_decap_8
XFILLER_91_417 VPWR VGND sg13g2_decap_4
XFILLER_79_1523 VPWR VGND sg13g2_decap_8
X_14750_ _14750_/Y _14215_/X _14749_/Y _14219_/B VPWR VGND sg13g2_o21ai_1
X_11962_ _11963_/C _11477_/X _11960_/X _12558_/A VPWR VGND sg13g2_a21oi_1
X_23948_ _23948_/Q clkload36/A _23948_/D fanout2641/X VPWR VGND sg13g2_dfrbpq_1
XFILLER_2_1841 VPWR VGND sg13g2_decap_8
X_13701_ _13702_/B _23600_/Q _23632_/Q _23664_/Q _23696_/Q _13701_/S0 _11726_/S VPWR
+ VGND sg13g2_mux4_1
X_14681_ _14681_/X _14720_/A _14718_/A _14686_/B VPWR VGND sg13g2_mux2_1
X_23879_ _23879_/Q clkload37/A _23879_/D fanout2709/X VPWR VGND sg13g2_dfrbpq_1
XFILLER_60_804 VPWR VGND sg13g2_fill_2
X_16420_ _22577_/D _15960_/Y _16417_/B _16419_/Y VPWR VGND sg13g2_o21ai_1
XFILLER_71_152 VPWR VGND sg13g2_fill_1
XFILLER_109_1911 VPWR VGND sg13g2_decap_8
X_13632_ _13632_/X _13632_/A _13632_/B VPWR VGND sg13g2_or2_1
XFILLER_38_1231 VPWR VGND sg13g2_fill_2
XFILLER_72_697 VPWR VGND sg13g2_fill_1
XFILLER_73_1122 VPWR VGND sg13g2_decap_8
X_16351_ _16351_/Y _16351_/A _16351_/B _16351_/C _16351_/D VPWR VGND sg13g2_nand4_1
XFILLER_38_1264 VPWR VGND sg13g2_decap_8
X_13563_ _13563_/X _24046_/Q _24110_/Q _13565_/A VPWR VGND sg13g2_mux2_1
XFILLER_38_1286 VPWR VGND sg13g2_decap_8
X_15302_ _15302_/Y _22586_/Q _15348_/B _15346_/A VPWR VGND sg13g2_a21oi_1
X_12514_ _12535_/D _12514_/A _12514_/B VPWR VGND sg13g2_xnor2_1
X_19070_ _23071_/D _23071_/Q _19068_/X _19078_/S VPWR VGND sg13g2_mux2_1
X_16282_ _18685_/A _16282_/A _16282_/B VPWR VGND sg13g2_or2_1
X_13494_ _13494_/X _13494_/A _13494_/B _13494_/C _13494_/D VPWR VGND sg13g2_or4_1
XFILLER_103_1521 VPWR VGND sg13g2_decap_8
X_18021_ _18021_/Y _18069_/A _18458_/A _18007_/Y _18020_/Y VPWR VGND sg13g2_a22oi_1
X_15233_ _15319_/C _16786_/C _15233_/B _15300_/C VPWR VGND sg13g2_nand3_1
XFILLER_60_50 VPWR VGND sg13g2_fill_1
X_12445_ _12450_/B _12445_/A _12445_/B VPWR VGND sg13g2_nor2_1
X_15164_ _15197_/A _22452_/Q _15270_/A _17234_/A _22751_/Q _15163_/X VPWR VGND sg13g2_a221oi_1
X_12376_ _12379_/C _12772_/B _12376_/B VPWR VGND sg13g2_nor2_1
XFILLER_5_34 VPWR VGND sg13g2_fill_1
X_14115_ _15268_/A _24222_/Q _17042_/B VPWR VGND sg13g2_nand2_1
XFILLER_5_985 VPWR VGND sg13g2_decap_8
X_11327_ _11327_/Y _11321_/Y _11322_/Y _11314_/A _14594_/A _11326_/Y VPWR VGND sg13g2_a221oi_1
X_15095_ _15095_/Y _15095_/A _15095_/B VPWR VGND sg13g2_nand2_1
X_19972_ _19972_/Y _19965_/Y _19966_/Y _19971_/Y VPWR VGND sg13g2_a21oi_1
XFILLER_49_1360 VPWR VGND sg13g2_fill_1
X_18923_ _18925_/B _18920_/Y _18924_/C VPWR VGND sg13g2_nand2b_1
X_14046_ _14046_/X _14046_/A _14052_/B VPWR VGND sg13g2_and2_1
X_11258_ _11258_/Y _14120_/C _11258_/B VPWR VGND sg13g2_nor2_1
XFILLER_64_1847 VPWR VGND sg13g2_decap_8
XFILLER_68_926 VPWR VGND sg13g2_fill_2
XFILLER_95_723 VPWR VGND sg13g2_decap_8
X_18854_ _18854_/Y _18854_/A VPWR VGND sg13g2_inv_1
XFILLER_39_116 VPWR VGND sg13g2_decap_8
X_11189_ _14121_/B _11311_/A _22969_/Q VPWR VGND sg13g2_and2_1
XFILLER_67_436 VPWR VGND sg13g2_decap_4
X_17805_ _22906_/D _17811_/B _17803_/Y _17804_/Y VPWR VGND sg13g2_a21oi_1
XFILLER_23_1533 VPWR VGND sg13g2_decap_8
XFILLER_62_1582 VPWR VGND sg13g2_fill_2
XFILLER_83_918 VPWR VGND sg13g2_decap_8
XFILLER_10_4 VPWR VGND sg13g2_fill_1
X_18785_ _18785_/Y _17987_/B _23032_/Q _18766_/Y _19118_/A1 VPWR VGND sg13g2_a22oi_1
XFILLER_67_469 VPWR VGND sg13g2_fill_2
X_15997_ _15997_/Y _20338_/A _16353_/B VPWR VGND sg13g2_nor2_1
XFILLER_83_929 VPWR VGND sg13g2_fill_1
XFILLER_7_1785 VPWR VGND sg13g2_decap_8
XFILLER_48_650 VPWR VGND sg13g2_fill_2
XFILLER_94_277 VPWR VGND sg13g2_decap_8
XFILLER_78_1000 VPWR VGND sg13g2_decap_8
X_17736_ _17736_/Y _17158_/A _17824_/A2 _17824_/B1 _17735_/Y VPWR VGND sg13g2_a22oi_1
X_14948_ _14949_/C _22496_/Q _15113_/B _15103_/B1 _22924_/Q VPWR VGND sg13g2_a22oi_1
XFILLER_48_683 VPWR VGND sg13g2_decap_8
XFILLER_23_1599 VPWR VGND sg13g2_decap_4
XFILLER_47_193 VPWR VGND sg13g2_decap_8
XFILLER_110_1569 VPWR VGND sg13g2_decap_8
X_14879_ _14880_/B _14879_/A VPWR VGND sg13g2_inv_1
X_17667_ _17667_/Y _15407_/A _17687_/A _17666_/Y VPWR VGND sg13g2_o21ai_1
XFILLER_63_664 VPWR VGND sg13g2_decap_8
XFILLER_90_450 VPWR VGND sg13g2_decap_4
X_19406_ _19406_/Y _13070_/B _19423_/B _19405_/Y VPWR VGND sg13g2_a21oi_1
XFILLER_23_517 VPWR VGND sg13g2_decap_8
XFILLER_23_528 VPWR VGND sg13g2_fill_1
X_16618_ _22638_/D _16136_/A _16626_/A _16617_/Y VPWR VGND sg13g2_a21oi_1
XFILLER_95_1380 VPWR VGND sg13g2_decap_4
X_17598_ _17598_/Y _17583_/A _17597_/Y _17394_/Y VPWR VGND sg13g2_a21oi_1
XFILLER_62_185 VPWR VGND sg13g2_decap_8
XFILLER_17_1304 VPWR VGND sg13g2_decap_8
XFILLER_71_1807 VPWR VGND sg13g2_decap_8
X_16549_ _16564_/D _22624_/Q _16549_/B VPWR VGND sg13g2_and2_1
XFILLER_50_358 VPWR VGND sg13g2_decap_4
XFILLER_17_1348 VPWR VGND sg13g2_fill_1
XFILLER_31_561 VPWR VGND sg13g2_fill_1
XFILLER_86_0 VPWR VGND sg13g2_fill_2
XFILLER_104_1318 VPWR VGND sg13g2_decap_8
Xoutput4500 data_be_o[2] _14632_/Y VPWR VGND sg13g2_buf_1
X_19268_ _19268_/Y _19268_/A _19268_/B VPWR VGND sg13g2_nor2_1
Xoutput4511 data_wdata_o[17] _14725_/X VPWR VGND sg13g2_buf_1
Xoutput4522 data_wdata_o[27] _14735_/X VPWR VGND sg13g2_buf_1
Xoutput4533 data_wdata_o[8] _14688_/X VPWR VGND sg13g2_buf_1
X_18219_ _18219_/Y _18485_/A _18245_/B _18219_/C _18219_/D VPWR VGND sg13g2_nand4_1
Xoutput4544 instr_addr_o[18] _14992_/X VPWR VGND sg13g2_buf_1
X_19199_ _23158_/D _24247_/A _23158_/Q _19231_/S VPWR VGND sg13g2_mux2_1
Xoutput4555 instr_addr_o[29] _15101_/X VPWR VGND sg13g2_buf_1
Xoutput4566 instr_req_o _15123_/B VPWR VGND sg13g2_buf_1
X_21230_ _21230_/Y _23638_/Q _21242_/B VPWR VGND sg13g2_nand2_1
XFILLER_89_1184 VPWR VGND sg13g2_decap_8
XFILLER_85_1026 VPWR VGND sg13g2_decap_8
XFILLER_104_305 VPWR VGND sg13g2_fill_1
XFILLER_102_1097 VPWR VGND sg13g2_decap_8
X_21161_ _23605_/D _21295_/A1 _21215_/B _21160_/Y VPWR VGND sg13g2_o21ai_1
XFILLER_85_1037 VPWR VGND sg13g2_decap_4
XFILLER_104_316 VPWR VGND sg13g2_fill_1
X_20112_ _20122_/A _20112_/A _20112_/B VPWR VGND sg13g2_nor2_1
XFILLER_63_1302 VPWR VGND sg13g2_decap_8
XFILLER_115_1403 VPWR VGND sg13g2_decap_8
X_20043_ _20043_/Y _20043_/A _20043_/B VPWR VGND sg13g2_nand2_1
XFILLER_113_883 VPWR VGND sg13g2_fill_2
XFILLER_100_511 VPWR VGND sg13g2_decap_8
XFILLER_85_200 VPWR VGND sg13g2_decap_4
XFILLER_85_211 VPWR VGND sg13g2_decap_8
XFILLER_63_1379 VPWR VGND sg13g2_decap_8
XFILLER_105_35 VPWR VGND sg13g2_decap_8
XFILLER_85_222 VPWR VGND sg13g2_decap_8
XFILLER_28_1499 VPWR VGND sg13g2_decap_4
XFILLER_115_1469 VPWR VGND sg13g2_decap_8
XFILLER_26_1190 VPWR VGND sg13g2_decap_8
XFILLER_39_650 VPWR VGND sg13g2_decap_4
X_23802_ _23802_/Q clkload58/A _23802_/D fanout2763/X VPWR VGND sg13g2_dfrbpq_1
XFILLER_6_1273 VPWR VGND sg13g2_fill_1
XFILLER_27_812 VPWR VGND sg13g2_decap_8
XFILLER_67_981 VPWR VGND sg13g2_decap_4
XFILLER_100_588 VPWR VGND sg13g2_decap_8
XFILLER_113_1182 VPWR VGND sg13g2_decap_4
XFILLER_96_1122 VPWR VGND sg13g2_decap_4
X_21994_ _23991_/D _22262_/A1 _22031_/S _21993_/Y VPWR VGND sg13g2_o21ai_1
XFILLER_22_1065 VPWR VGND sg13g2_decap_8
XFILLER_41_1688 VPWR VGND sg13g2_decap_4
XFILLER_82_940 VPWR VGND sg13g2_decap_8
XFILLER_76_1707 VPWR VGND sg13g2_fill_1
X_23733_ _23733_/Q clkload52/A _23733_/D fanout2757/X VPWR VGND sg13g2_dfrbpq_1
X_20945_ _20945_/Y _20945_/A _20945_/B VPWR VGND sg13g2_nand2_1
XFILLER_53_141 VPWR VGND sg13g2_decap_8
XFILLER_54_675 VPWR VGND sg13g2_fill_1
XFILLER_41_303 VPWR VGND sg13g2_decap_8
XFILLER_42_826 VPWR VGND sg13g2_decap_4
XFILLER_41_314 VPWR VGND sg13g2_fill_2
XFILLER_42_848 VPWR VGND sg13g2_decap_4
X_23664_ _23664_/Q clkload56/A _23664_/D fanout2672/X VPWR VGND sg13g2_dfrbpq_1
XFILLER_35_1404 VPWR VGND sg13g2_decap_4
X_22615_ _22615_/Q _22893_/CLK _22615_/D fanout2820/X VPWR VGND sg13g2_dfrbpq_1
X_23595_ _23595_/Q clkload49/A _23595_/D fanout2670/X VPWR VGND sg13g2_dfrbpq_1
XFILLER_14_65 VPWR VGND sg13g2_fill_2
XFILLER_10_723 VPWR VGND sg13g2_decap_8
X_22546_ _22546_/Q clkload27/A _22546_/D fanout2894/X VPWR VGND sg13g2_dfrbpq_1
XFILLER_22_594 VPWR VGND sg13g2_fill_1
XFILLER_17_1871 VPWR VGND sg13g2_decap_8
XFILLER_52_1773 VPWR VGND sg13g2_decap_8
XFILLER_104_1852 VPWR VGND sg13g2_decap_8
X_22477_ _22477_/Q _23029_/CLK _22477_/D fanout2806/X VPWR VGND sg13g2_dfrbpq_1
XFILLER_108_622 VPWR VGND sg13g2_decap_8
XFILLER_87_1825 VPWR VGND sg13g2_fill_1
X_24216_ _24216_/Q clkload27/A _24216_/D fanout2856/X VPWR VGND sg13g2_dfrbpq_1
X_12230_ _12230_/X _23357_/Q _23389_/Q _12248_/S VPWR VGND sg13g2_mux2_1
X_21428_ _21428_/Y _23733_/Q _21430_/B VPWR VGND sg13g2_nand2_1
XFILLER_107_154 VPWR VGND sg13g2_decap_8
X_24147_ _24147_/Q clkload50/A _24147_/D fanout2666/X VPWR VGND sg13g2_dfrbpq_1
XFILLER_2_911 VPWR VGND sg13g2_fill_2
XFILLER_30_75 VPWR VGND sg13g2_decap_8
X_12161_ _12161_/X _24028_/Q _24060_/Q _12166_/B VPWR VGND sg13g2_mux2_1
XFILLER_30_86 VPWR VGND sg13g2_fill_2
Xfanout2903 fanout2903/X fanout2905/X VPWR VGND sg13g2_buf_1
Xfanout2914 fanout2914/X fanout2935/X VPWR VGND sg13g2_buf_1
Xfanout2925 fanout2925/X fanout2927/X VPWR VGND sg13g2_buf_1
X_12092_ _14051_/A _12092_/A _12092_/B VPWR VGND sg13g2_xnor2_1
X_24078_ _24078_/Q clkload36/A _24078_/D fanout2639/X VPWR VGND sg13g2_dfrbpq_1
XFILLER_89_550 VPWR VGND sg13g2_fill_1
XFILLER_46_1544 VPWR VGND sg13g2_fill_2
XFILLER_81_1435 VPWR VGND sg13g2_fill_2
XFILLER_89_572 VPWR VGND sg13g2_fill_1
XFILLER_1_476 VPWR VGND sg13g2_decap_4
X_15920_ _15921_/D _15920_/A1 _15969_/B _15349_/Y VPWR VGND sg13g2_a21oi_1
X_23029_ _23029_/Q _23029_/CLK _23029_/D fanout2838/X VPWR VGND sg13g2_dfrbpq_1
XFILLER_76_200 VPWR VGND sg13g2_decap_8
XFILLER_39_62 VPWR VGND sg13g2_fill_2
XFILLER_103_382 VPWR VGND sg13g2_fill_1
XFILLER_77_745 VPWR VGND sg13g2_fill_2
X_15851_ _16177_/A _18723_/A _15956_/B _15850_/Y VPWR VGND sg13g2_o21ai_1
XFILLER_49_458 VPWR VGND sg13g2_decap_8
XFILLER_4_1914 VPWR VGND sg13g2_decap_8
XFILLER_65_918 VPWR VGND sg13g2_fill_2
XFILLER_111_1801 VPWR VGND sg13g2_decap_8
XFILLER_98_1910 VPWR VGND sg13g2_decap_8
XFILLER_92_715 VPWR VGND sg13g2_decap_4
XFILLER_18_801 VPWR VGND sg13g2_decap_8
X_14802_ _18607_/A _14778_/Y _14798_/Y _16240_/A VPWR VGND sg13g2_a21oi_1
XFILLER_40_1132 VPWR VGND sg13g2_decap_4
X_18570_ _18570_/Y _18573_/A _18571_/C VPWR VGND sg13g2_nand2_1
X_15782_ _15782_/Y _15936_/S _16152_/A VPWR VGND sg13g2_nor2_1
XFILLER_17_300 VPWR VGND sg13g2_decap_8
XFILLER_98_1954 VPWR VGND sg13g2_fill_1
X_12994_ _12994_/Y _23173_/Q _19197_/A VPWR VGND sg13g2_nand2_1
XFILLER_59_1916 VPWR VGND sg13g2_fill_1
XFILLER_111_1878 VPWR VGND sg13g2_decap_8
X_14733_ _14733_/X _14692_/Y _14690_/Y _14737_/S VPWR VGND sg13g2_mux2_1
X_17521_ _17521_/Y _22875_/Q _17528_/B VPWR VGND sg13g2_nand2_1
XFILLER_94_1818 VPWR VGND sg13g2_fill_2
X_11945_ _11946_/C _12015_/S _11945_/B VPWR VGND sg13g2_nand2_1
XFILLER_45_653 VPWR VGND sg13g2_decap_8
XFILLER_73_962 VPWR VGND sg13g2_decap_8
XFILLER_94_1829 VPWR VGND sg13g2_fill_1
XFILLER_18_878 VPWR VGND sg13g2_fill_2
XFILLER_73_973 VPWR VGND sg13g2_fill_1
XFILLER_73_984 VPWR VGND sg13g2_decap_8
X_17452_ _22844_/D _16058_/A _17453_/B _17451_/Y VPWR VGND sg13g2_o21ai_1
XFILLER_17_377 VPWR VGND sg13g2_decap_8
XFILLER_44_163 VPWR VGND sg13g2_fill_1
X_14664_ _14664_/X _14661_/Y _14663_/Y _14729_/S VPWR VGND sg13g2_mux2_1
X_11876_ _11877_/B _22551_/Q _11736_/Y _11775_/Y VPWR VGND sg13g2_a21oi_1
XFILLER_18_1602 VPWR VGND sg13g2_decap_8
XFILLER_92_1542 VPWR VGND sg13g2_fill_2
X_16403_ _16405_/A _23020_/Q _18742_/A _18672_/B VPWR VGND sg13g2_nand3_1
XFILLER_57_1662 VPWR VGND sg13g2_fill_1
X_13615_ _13616_/B _13613_/X _13614_/X _13615_/S VPWR VGND sg13g2_mux2_1
X_17383_ _22816_/D _14833_/Y _17382_/A _17382_/Y VPWR VGND sg13g2_o21ai_1
X_14595_ _24213_/D _14637_/B _24213_/Q _19274_/B VPWR VGND sg13g2_mux2_1
XFILLER_13_572 VPWR VGND sg13g2_fill_2
X_19122_ _23100_/D _23100_/Q _19122_/A1 _19124_/S VPWR VGND sg13g2_mux2_1
X_16334_ _16425_/B _16334_/A _17835_/B VPWR VGND sg13g2_nand2_1
X_13546_ _14002_/A _13546_/A _13546_/B VPWR VGND sg13g2_and2_1
Xplace3808 _15591_/S _15442_/S VPWR VGND sg13g2_buf_1
XFILLER_9_554 VPWR VGND sg13g2_fill_2
Xplace3819 _14715_/A _12745_/Y VPWR VGND sg13g2_buf_1
XFILLER_40_391 VPWR VGND sg13g2_fill_1
X_19053_ _23063_/D _23063_/Q _19052_/X _19061_/S VPWR VGND sg13g2_mux2_1
X_16265_ _16273_/D _16265_/A _16263_/A VPWR VGND sg13g2_nor2b_1
X_13477_ _13494_/A _13608_/A1 _13474_/X _13476_/X VPWR VGND sg13g2_o21ai_1
XFILLER_9_587 VPWR VGND sg13g2_fill_1
XFILLER_51_1261 VPWR VGND sg13g2_fill_2
XFILLER_70_1884 VPWR VGND sg13g2_fill_1
X_15216_ _15950_/B _15216_/A _15216_/B _15216_/C VPWR VGND sg13g2_nand3_1
XFILLER_103_1362 VPWR VGND sg13g2_fill_1
X_12428_ _12428_/Y _12428_/A_N _19930_/A _12428_/C VPWR VGND sg13g2_nand3b_1
XFILLER_86_1313 VPWR VGND sg13g2_fill_1
XFILLER_12_1278 VPWR VGND sg13g2_decap_8
XFILLER_66_1909 VPWR VGND sg13g2_decap_8
X_15147_ _15289_/B _19346_/A _15257_/A _19322_/A _15165_/C VPWR VGND sg13g2_nor4_1
X_12359_ _12359_/X _24031_/Q _24063_/Q _24095_/Q _24127_/Q _11465_/A _11449_/B VPWR
+ VGND sg13g2_mux4_1
XFILLER_86_1368 VPWR VGND sg13g2_decap_8
XFILLER_99_336 VPWR VGND sg13g2_decap_8
XFILLER_114_669 VPWR VGND sg13g2_decap_8
XFILLER_102_809 VPWR VGND sg13g2_decap_4
X_19955_ _19956_/B _19955_/A _19955_/B _20338_/C VPWR VGND sg13g2_nor3_1
X_15078_ _15080_/A _24272_/A _15025_/B _15077_/Y VPWR VGND sg13g2_a21oi_1
XFILLER_87_509 VPWR VGND sg13g2_fill_2
XFILLER_29_1753 VPWR VGND sg13g2_decap_8
XFILLER_45_1010 VPWR VGND sg13g2_fill_2
XFILLER_113_168 VPWR VGND sg13g2_decap_8
XFILLER_9_1836 VPWR VGND sg13g2_decap_8
X_14029_ _14029_/Y _15218_/A _14029_/B _14029_/C VPWR VGND sg13g2_nand3_1
XFILLER_84_1092 VPWR VGND sg13g2_decap_8
X_18906_ _23048_/D _18899_/Y _18903_/Y _18904_/Y _18905_/Y VPWR VGND sg13g2_a22oi_1
XFILLER_29_1775 VPWR VGND sg13g2_decap_4
XFILLER_68_712 VPWR VGND sg13g2_decap_4
XFILLER_67_200 VPWR VGND sg13g2_fill_2
X_19886_ _19887_/A _19886_/A1 _20349_/A2 _19509_/Y _23220_/Q VPWR VGND sg13g2_a22oi_1
X_18837_ _18838_/C _23072_/Q _18869_/B VPWR VGND sg13g2_nand2_1
XFILLER_110_864 VPWR VGND sg13g2_decap_8
XFILLER_95_564 VPWR VGND sg13g2_decap_4
XFILLER_67_266 VPWR VGND sg13g2_fill_1
XFILLER_97_1420 VPWR VGND sg13g2_decap_4
XFILLER_110_1333 VPWR VGND sg13g2_decap_8
XFILLER_97_1453 VPWR VGND sg13g2_decap_8
X_17719_ _17719_/Y _17823_/A1 _17717_/Y _17718_/Y VPWR VGND sg13g2_o21ai_1
XFILLER_64_973 VPWR VGND sg13g2_decap_8
X_18699_ _23018_/D _18692_/B _18698_/Y _15010_/B VPWR VGND sg13g2_a21oi_1
XFILLER_93_1317 VPWR VGND sg13g2_decap_8
Xinput4409 _20255_/A1 data_rdata_i[9] VPWR VGND sg13g2_buf_1
XFILLER_64_984 VPWR VGND sg13g2_fill_1
XFILLER_35_163 VPWR VGND sg13g2_fill_1
X_20730_ _23416_/D _22396_/A1 _20738_/B _20729_/Y VPWR VGND sg13g2_o21ai_1
XFILLER_35_196 VPWR VGND sg13g2_fill_1
XFILLER_71_1604 VPWR VGND sg13g2_fill_2
X_20661_ _23384_/D _22396_/A1 _20712_/S _20660_/Y VPWR VGND sg13g2_o21ai_1
XFILLER_50_166 VPWR VGND sg13g2_decap_8
X_22400_ _22400_/Y _22400_/A _22402_/B VPWR VGND sg13g2_nand2_1
XFILLER_17_1145 VPWR VGND sg13g2_decap_8
X_20592_ _20592_/Y _23351_/Q _20646_/S VPWR VGND sg13g2_nand2_1
X_23380_ _23380_/Q _24214_/CLK _23380_/D fanout2628/X VPWR VGND sg13g2_dfrbpq_1
XFILLER_32_892 VPWR VGND sg13g2_decap_4
XFILLER_36_1779 VPWR VGND sg13g2_fill_1
XFILLER_71_1659 VPWR VGND sg13g2_fill_2
XFILLER_52_1058 VPWR VGND sg13g2_fill_2
X_22331_ _22331_/Y _22331_/A _22341_/B VPWR VGND sg13g2_nand2_1
X_22262_ _24119_/D _22262_/A1 _22269_/B _22261_/Y VPWR VGND sg13g2_o21ai_1
XFILLER_69_1544 VPWR VGND sg13g2_fill_2
X_24001_ _24001_/Q clkload45/A _24001_/D fanout2716/X VPWR VGND sg13g2_dfrbpq_1
XFILLER_105_614 VPWR VGND sg13g2_decap_8
X_21213_ _23630_/D _21345_/A1 _21209_/B _21212_/Y VPWR VGND sg13g2_o21ai_1
X_22193_ _22193_/Y _24086_/Q _22249_/S VPWR VGND sg13g2_nand2_1
XFILLER_65_1408 VPWR VGND sg13g2_fill_2
XFILLER_69_1577 VPWR VGND sg13g2_fill_1
XFILLER_65_1419 VPWR VGND sg13g2_fill_1
X_21144_ _23597_/D _23597_/Q _21343_/A0 _21153_/S VPWR VGND sg13g2_mux2_1
XFILLER_104_157 VPWR VGND sg13g2_decap_8
XFILLER_28_1252 VPWR VGND sg13g2_decap_8
XFILLER_59_712 VPWR VGND sg13g2_decap_8
XFILLER_82_1766 VPWR VGND sg13g2_decap_8
X_21075_ _21075_/Y _21075_/A _21085_/B VPWR VGND sg13g2_nand2_1
XFILLER_113_680 VPWR VGND sg13g2_decap_8
XFILLER_47_1886 VPWR VGND sg13g2_decap_8
XFILLER_24_1127 VPWR VGND sg13g2_decap_8
X_20026_ _23233_/D _20052_/B _22416_/A1 _20025_/Y VPWR VGND sg13g2_o21ai_1
XFILLER_115_1255 VPWR VGND sg13g2_decap_8
XFILLER_47_907 VPWR VGND sg13g2_fill_1
XFILLER_47_929 VPWR VGND sg13g2_decap_8
XFILLER_46_406 VPWR VGND sg13g2_decap_8
XFILLER_98_1228 VPWR VGND sg13g2_decap_8
XFILLER_80_1490 VPWR VGND sg13g2_decap_8
XFILLER_58_288 VPWR VGND sg13g2_decap_8
XFILLER_46_439 VPWR VGND sg13g2_decap_4
XFILLER_27_620 VPWR VGND sg13g2_fill_1
XFILLER_6_1092 VPWR VGND sg13g2_decap_8
XFILLER_73_236 VPWR VGND sg13g2_decap_8
XFILLER_55_951 VPWR VGND sg13g2_decap_4
XFILLER_61_409 VPWR VGND sg13g2_decap_8
XFILLER_73_269 VPWR VGND sg13g2_fill_2
XFILLER_55_973 VPWR VGND sg13g2_decap_8
X_21977_ _23984_/D _21977_/A1 _21982_/B _21976_/Y VPWR VGND sg13g2_o21ai_1
XFILLER_54_461 VPWR VGND sg13g2_decap_8
XFILLER_55_984 VPWR VGND sg13g2_fill_1
XFILLER_70_921 VPWR VGND sg13g2_decap_8
X_11730_ _11731_/C _12119_/A _11727_/Y _11729_/Y VPWR VGND sg13g2_a21oi_1
X_23716_ _23716_/Q clkload40/A _23716_/D fanout2735/X VPWR VGND sg13g2_dfrbpq_1
X_20928_ _20928_/Y _20928_/A _20930_/B VPWR VGND sg13g2_nand2_1
XFILLER_76_1559 VPWR VGND sg13g2_fill_2
XFILLER_25_42 VPWR VGND sg13g2_decap_8
XFILLER_26_185 VPWR VGND sg13g2_decap_8
XFILLER_93_1851 VPWR VGND sg13g2_fill_2
XFILLER_41_122 VPWR VGND sg13g2_fill_2
XFILLER_19_1933 VPWR VGND sg13g2_decap_8
X_11661_ _11867_/A _14634_/B _11661_/B VPWR VGND sg13g2_nand2_1
X_23647_ _23647_/Q clkload39/A _23647_/D fanout2737/X VPWR VGND sg13g2_dfrbpq_1
XFILLER_74_1250 VPWR VGND sg13g2_decap_8
XFILLER_14_369 VPWR VGND sg13g2_decap_8
XFILLER_42_678 VPWR VGND sg13g2_fill_2
XFILLER_74_1261 VPWR VGND sg13g2_fill_2
XFILLER_15_1808 VPWR VGND sg13g2_decap_8
X_13400_ _13400_/X _13565_/A _23916_/Q VPWR VGND sg13g2_and2_1
X_14380_ _15262_/B _22942_/Q _15264_/B VPWR VGND sg13g2_nor2_1
XFILLER_23_892 VPWR VGND sg13g2_decap_8
XFILLER_54_1868 VPWR VGND sg13g2_decap_8
XFILLER_74_1294 VPWR VGND sg13g2_decap_8
X_23578_ _23578_/Q clkload53/A _23578_/D fanout2781/X VPWR VGND sg13g2_dfrbpq_1
XFILLER_41_199 VPWR VGND sg13g2_decap_4
X_11592_ _19320_/B _11592_/A _19480_/B VPWR VGND sg13g2_nor2_2
XFILLER_70_1136 VPWR VGND sg13g2_decap_8
XFILLER_35_1267 VPWR VGND sg13g2_fill_2
XFILLER_13_1510 VPWR VGND sg13g2_decap_8
X_13331_ _13331_/X _23563_/Q _24011_/Q _13331_/S VPWR VGND sg13g2_mux2_1
X_22529_ _22529_/Q _22941_/CLK _22529_/D fanout2804/X VPWR VGND sg13g2_dfrbpq_1
XFILLER_104_1660 VPWR VGND sg13g2_fill_1
X_16050_ _16050_/Y _16050_/A _16075_/B VPWR VGND sg13g2_nor2_1
X_13262_ _13262_/Y _23658_/Q _13264_/B VPWR VGND sg13g2_nand2b_1
XFILLER_109_964 VPWR VGND sg13g2_decap_4
XFILLER_104_1693 VPWR VGND sg13g2_fill_2
X_15001_ _16322_/B _14993_/Y _14990_/B _15000_/Y VPWR VGND sg13g2_a21oi_1
X_12213_ _12218_/B _12475_/A _12213_/B VPWR VGND sg13g2_nor2_1
X_13193_ _13194_/B _23593_/Q _23625_/Q _23657_/Q _23689_/Q _13193_/S0 _13797_/S VPWR
+ VGND sg13g2_mux4_1
XFILLER_30_1890 VPWR VGND sg13g2_decap_8
XFILLER_108_496 VPWR VGND sg13g2_decap_8
XFILLER_83_1508 VPWR VGND sg13g2_decap_8
Xfanout2700 fanout2700/X fanout2701/X VPWR VGND sg13g2_buf_1
X_12144_ _12145_/B _23772_/Q _23932_/Q _12146_/S VPWR VGND sg13g2_mux2_1
Xfanout2711 fanout2711/X fanout2712/X VPWR VGND sg13g2_buf_1
Xfanout2722 fanout2722/X fanout2723/X VPWR VGND sg13g2_buf_1
XFILLER_2_763 VPWR VGND sg13g2_fill_2
Xfanout2733 fanout2733/X fanout2742/X VPWR VGND sg13g2_buf_1
XFILLER_65_1953 VPWR VGND sg13g2_fill_2
XFILLER_46_1341 VPWR VGND sg13g2_decap_8
Xfanout2744 fanout2744/X fanout2746/X VPWR VGND sg13g2_buf_1
XFILLER_110_105 VPWR VGND sg13g2_decap_8
XFILLER_96_328 VPWR VGND sg13g2_decap_4
X_19740_ _19740_/Y _19740_/A _19740_/B _19740_/C VPWR VGND sg13g2_nor3_1
XFILLER_46_1352 VPWR VGND sg13g2_decap_8
XFILLER_111_639 VPWR VGND sg13g2_decap_8
Xfanout2755 fanout2755/X fanout2760/X VPWR VGND sg13g2_buf_1
X_16952_ _16953_/D _22698_/Q _22697_/Q VPWR VGND sg13g2_and2_1
X_12075_ _12075_/Y _12959_/A _12075_/B _14041_/B _12075_/D VPWR VGND sg13g2_nor4_1
Xfanout2766 fanout2766/X fanout2767/X VPWR VGND sg13g2_buf_1
Xfanout2777 fanout2777/X fanout2779/X VPWR VGND sg13g2_buf_1
Xfanout2788 fanout2788/X fanout2789/X VPWR VGND sg13g2_buf_1
XFILLER_2_35 VPWR VGND sg13g2_decap_8
Xfanout2799 fanout2799/X fanout2800/X VPWR VGND sg13g2_buf_1
X_15903_ _15904_/D _22613_/Q _15992_/A2 _15902_/Y VPWR VGND sg13g2_a21oi_1
X_19671_ _19671_/Y _19671_/A _19671_/B VPWR VGND sg13g2_nand2_1
XFILLER_77_553 VPWR VGND sg13g2_decap_8
X_16883_ _16884_/B _16893_/A _16907_/C VPWR VGND sg13g2_nor2b_1
XFILLER_4_1711 VPWR VGND sg13g2_decap_8
XFILLER_77_575 VPWR VGND sg13g2_fill_1
XFILLER_2_79 VPWR VGND sg13g2_fill_1
XFILLER_37_428 VPWR VGND sg13g2_fill_2
XFILLER_111_1620 VPWR VGND sg13g2_fill_1
X_15834_ _15834_/Y _22739_/Q _15946_/A2 _15946_/B1 _22675_/Q VPWR VGND sg13g2_a22oi_1
XFILLER_66_71 VPWR VGND sg13g2_decap_8
XFILLER_18_631 VPWR VGND sg13g2_decap_8
XFILLER_111_1653 VPWR VGND sg13g2_fill_2
XFILLER_92_567 VPWR VGND sg13g2_decap_8
XFILLER_4_1788 VPWR VGND sg13g2_decap_8
X_18553_ _18553_/Y _18553_/A1 _18254_/A _18423_/Y VPWR VGND sg13g2_o21ai_1
XFILLER_46_962 VPWR VGND sg13g2_fill_1
XFILLER_98_1784 VPWR VGND sg13g2_decap_8
XFILLER_18_664 VPWR VGND sg13g2_decap_8
X_12977_ _12977_/X _23846_/Q _23878_/Q _23942_/Q _23974_/Q _13028_/A _12877_/B VPWR
+ VGND sg13g2_mux4_1
X_15765_ _15766_/A _22704_/Q _15901_/A2 _15898_/B1 _22640_/Q VPWR VGND sg13g2_a22oi_1
X_17504_ _22869_/D _16197_/A _17503_/B _17503_/Y VPWR VGND sg13g2_o21ai_1
XFILLER_79_1194 VPWR VGND sg13g2_decap_8
XFILLER_18_697 VPWR VGND sg13g2_decap_4
X_14716_ _14716_/Y _14295_/A _14715_/B _14715_/Y VPWR VGND sg13g2_a21oi_1
X_18484_ _18484_/Y _18144_/A _18473_/X _18504_/A VPWR VGND sg13g2_o21ai_1
X_15696_ _16132_/A _23015_/Q _22565_/Q _15982_/S VPWR VGND sg13g2_mux2_1
XFILLER_60_442 VPWR VGND sg13g2_fill_1
X_14647_ _14647_/X _14643_/Y _14646_/Y _14726_/S VPWR VGND sg13g2_mux2_1
X_17435_ _17435_/Y _22838_/Q _17437_/B VPWR VGND sg13g2_nand2_1
X_11859_ _11859_/Y _11826_/Y _11828_/Y _11858_/Y VPWR VGND sg13g2_o21ai_1
XFILLER_61_987 VPWR VGND sg13g2_decap_8
XFILLER_18_1443 VPWR VGND sg13g2_decap_8
XFILLER_72_1946 VPWR VGND sg13g2_decap_8
XFILLER_105_1402 VPWR VGND sg13g2_fill_2
Xplace4306 _13243_/S0 _13039_/S VPWR VGND sg13g2_buf_8
Xplace4317 _11843_/S _11836_/B VPWR VGND sg13g2_buf_1
Xplace4328 _11923_/S0 _11768_/S0 VPWR VGND sg13g2_buf_2
X_17366_ _22810_/D _17920_/B2 _22810_/Q _17366_/S VPWR VGND sg13g2_mux2_1
X_14578_ _16860_/B _14578_/A _14578_/B VPWR VGND sg13g2_nand2_1
Xrebuffer5307 _12052_/B _12050_/Y VPWR VGND sg13g2_buf_2
Xrebuffer5318 _16330_/B1 _16331_/A VPWR VGND sg13g2_buf_1
Xplace4339 _22050_/C _22975_/Q VPWR VGND sg13g2_buf_1
XFILLER_14_1318 VPWR VGND sg13g2_fill_2
Xplace3605 _15070_/B _14407_/X VPWR VGND sg13g2_buf_1
X_19105_ _23088_/D _23088_/Q _19104_/X _19115_/S VPWR VGND sg13g2_mux2_1
Xrebuffer5329 _13757_/A _13932_/A VPWR VGND sg13g2_buf_1
X_16317_ _22538_/D _16318_/A _16318_/B VPWR VGND sg13g2_xor2_1
Xplace3616 _18602_/A _14244_/Y VPWR VGND sg13g2_buf_1
Xplace3627 _15731_/B1 _15946_/B1 VPWR VGND sg13g2_buf_1
X_17297_ _22778_/D _17920_/B2 _22778_/Q _17302_/S VPWR VGND sg13g2_mux2_1
Xrebuffer4606 _15038_/A1 _13449_/Y VPWR VGND sg13g2_buf_8
Xrebuffer4617 _13526_/A _12108_/Y VPWR VGND sg13g2_buf_8
Xplace3638 _18635_/A2 _14879_/A VPWR VGND sg13g2_buf_1
Xplace3649 _14694_/B _19195_/B VPWR VGND sg13g2_buf_1
Xrebuffer4628 _15048_/A1 _13523_/Y VPWR VGND sg13g2_buf_8
X_19036_ _19036_/Y _19045_/B _23092_/Q _19047_/C VPWR VGND sg13g2_nand3_1
X_16248_ _16249_/B _16250_/B _16248_/B VPWR VGND sg13g2_nand2_1
Xhold5008 _21389_/A _23714_/Q VPWR VGND sg13g2_dlygate4sd3_1
Xhold5019 _21363_/A _23702_/Q VPWR VGND sg13g2_dlygate4sd3_1
XFILLER_12_1053 VPWR VGND sg13g2_decap_8
Xplace2937 _19115_/S _19099_/S VPWR VGND sg13g2_buf_1
XFILLER_115_901 VPWR VGND sg13g2_decap_8
XFILLER_86_1110 VPWR VGND sg13g2_fill_2
Xplace2948 _18713_/A _18689_/A VPWR VGND sg13g2_buf_1
XFILLER_103_1181 VPWR VGND sg13g2_decap_8
Xplace2959 _17030_/A _17024_/A VPWR VGND sg13g2_buf_1
X_16179_ _16179_/X _22507_/Q _16183_/B VPWR VGND sg13g2_and2_1
XFILLER_99_122 VPWR VGND sg13g2_decap_8
XFILLER_115_956 VPWR VGND sg13g2_decap_8
XFILLER_47_1116 VPWR VGND sg13g2_fill_1
XFILLER_49_0 VPWR VGND sg13g2_decap_8
XFILLER_82_1018 VPWR VGND sg13g2_decap_4
XFILLER_114_466 VPWR VGND sg13g2_decap_8
XFILLER_102_617 VPWR VGND sg13g2_decap_8
X_19938_ _19938_/Y _20092_/A2 _19825_/Y _19663_/X VPWR VGND sg13g2_a21oi_1
XFILLER_64_1452 VPWR VGND sg13g2_decap_8
XFILLER_64_1463 VPWR VGND sg13g2_fill_2
XFILLER_9_1666 VPWR VGND sg13g2_fill_2
XFILLER_68_531 VPWR VGND sg13g2_decap_4
X_19869_ _19869_/Y _19869_/A _19869_/B VPWR VGND sg13g2_nand2_1
XFILLER_25_1458 VPWR VGND sg13g2_fill_2
XFILLER_29_918 VPWR VGND sg13g2_decap_4
X_21900_ _21900_/Y _21900_/A _21900_/B VPWR VGND sg13g2_nand2_1
XFILLER_110_683 VPWR VGND sg13g2_decap_8
XFILLER_3_1221 VPWR VGND sg13g2_decap_8
X_22880_ _22880_/Q clkload28/A _22880_/D fanout2871/X VPWR VGND sg13g2_dfrbpq_1
XFILLER_23_1171 VPWR VGND sg13g2_decap_8
XFILLER_83_556 VPWR VGND sg13g2_decap_8
XFILLER_37_951 VPWR VGND sg13g2_fill_2
XFILLER_77_1813 VPWR VGND sg13g2_fill_1
XFILLER_55_258 VPWR VGND sg13g2_decap_4
X_21831_ _23912_/D _22298_/A0 _23912_/Q _21832_/S VPWR VGND sg13g2_mux2_1
XFILLER_102_14 VPWR VGND sg13g2_decap_8
XFILLER_24_601 VPWR VGND sg13g2_decap_8
X_21762_ _23882_/D _22033_/A1 _21771_/B _21761_/Y VPWR VGND sg13g2_o21ai_1
XFILLER_77_1879 VPWR VGND sg13g2_decap_4
X_23501_ _23501_/Q clkload51/A _23501_/D fanout2659/X VPWR VGND sg13g2_dfrbpq_1
XFILLER_93_1158 VPWR VGND sg13g2_decap_8
XFILLER_93_1169 VPWR VGND sg13g2_fill_2
XFILLER_23_144 VPWR VGND sg13g2_fill_2
X_20713_ _20713_/Y _20713_/A _20713_/B VPWR VGND sg13g2_nand2_1
XFILLER_52_998 VPWR VGND sg13g2_decap_4
X_21693_ _21779_/B _22430_/B _21756_/B VPWR VGND sg13g2_or2_1
XFILLER_11_306 VPWR VGND sg13g2_decap_8
XFILLER_75_1592 VPWR VGND sg13g2_fill_2
X_23432_ _23432_/Q clkload31/A _23432_/D fanout2654/X VPWR VGND sg13g2_dfrbpq_1
XFILLER_71_1434 VPWR VGND sg13g2_decap_8
X_20644_ _20644_/Y _20644_/A _20644_/B VPWR VGND sg13g2_nand2_1
XFILLER_71_1456 VPWR VGND sg13g2_decap_8
XFILLER_36_1576 VPWR VGND sg13g2_decap_4
XFILLER_36_1598 VPWR VGND sg13g2_fill_2
XFILLER_14_1830 VPWR VGND sg13g2_decap_8
X_23363_ _23363_/Q clkload34/A _23363_/D fanout2695/X VPWR VGND sg13g2_dfrbpq_1
XFILLER_20_873 VPWR VGND sg13g2_fill_2
X_20575_ _20575_/Y _23344_/Q _20581_/B VPWR VGND sg13g2_nand2_1
XFILLER_109_238 VPWR VGND sg13g2_decap_8
XFILLER_109_249 VPWR VGND sg13g2_fill_1
X_22314_ _24146_/D _22314_/A1 _22316_/B _22313_/Y VPWR VGND sg13g2_o21ai_1
X_23294_ _23294_/Q _24190_/CLK _23294_/D fanout2774/X VPWR VGND sg13g2_dfrbpq_1
XFILLER_101_1866 VPWR VGND sg13g2_decap_8
X_22245_ _24112_/D _22311_/A1 _22250_/B _22244_/Y VPWR VGND sg13g2_o21ai_1
XFILLER_30_1186 VPWR VGND sg13g2_decap_4
XFILLER_49_1948 VPWR VGND sg13g2_decap_8
XFILLER_106_967 VPWR VGND sg13g2_decap_8
Xhold4830 _21802_/A _23899_/Q VPWR VGND sg13g2_dlygate4sd3_1
Xhold4841 _20406_/A _23267_/Q VPWR VGND sg13g2_dlygate4sd3_1
X_22176_ _24078_/D _22308_/A1 _22175_/B _22175_/Y VPWR VGND sg13g2_o21ai_1
XFILLER_105_466 VPWR VGND sg13g2_fill_1
Xhold4852 _22434_/A _24202_/Q VPWR VGND sg13g2_dlygate4sd3_1
Xhold4863 _20555_/A _23333_/Q VPWR VGND sg13g2_dlygate4sd3_1
XFILLER_47_1650 VPWR VGND sg13g2_decap_8
Xhold4874 _21171_/A _23610_/Q VPWR VGND sg13g2_dlygate4sd3_1
Xhold4885 _20936_/A _23514_/Q VPWR VGND sg13g2_dlygate4sd3_1
X_21127_ _23588_/D _21327_/A1 _21130_/B _21126_/Y VPWR VGND sg13g2_o21ai_1
XFILLER_78_339 VPWR VGND sg13g2_decap_8
XFILLER_59_520 VPWR VGND sg13g2_decap_8
Xhold4896 _21812_/A _23903_/Q VPWR VGND sg13g2_dlygate4sd3_1
XFILLER_115_1030 VPWR VGND sg13g2_decap_8
XFILLER_82_1585 VPWR VGND sg13g2_decap_8
XFILLER_28_1082 VPWR VGND sg13g2_decap_8
XFILLER_8_1154 VPWR VGND sg13g2_fill_1
XFILLER_82_1596 VPWR VGND sg13g2_fill_1
X_21058_ _23560_/D _23560_/Q _22298_/A0 _21082_/B VPWR VGND sg13g2_mux2_1
XFILLER_87_873 VPWR VGND sg13g2_fill_1
X_12900_ _12900_/Y _11681_/Y _12870_/Y _13383_/A _12900_/B2 _12899_/X VPWR VGND sg13g2_a221oi_1
XFILLER_100_160 VPWR VGND sg13g2_fill_2
X_20009_ _20009_/Y _20229_/A _20009_/B VPWR VGND sg13g2_nor2_1
XFILLER_86_383 VPWR VGND sg13g2_decap_8
X_13880_ _13886_/B _13880_/A _13880_/B _13880_/C VPWR VGND sg13g2_nor3_1
XFILLER_115_1096 VPWR VGND sg13g2_decap_8
XFILLER_100_182 VPWR VGND sg13g2_decap_8
XFILLER_60_1883 VPWR VGND sg13g2_decap_8
XFILLER_74_545 VPWR VGND sg13g2_fill_2
X_12831_ _12832_/B _12837_/A _12831_/B VPWR VGND sg13g2_xnor2_1
XFILLER_74_589 VPWR VGND sg13g2_decap_8
XFILLER_95_1946 VPWR VGND sg13g2_decap_8
XFILLER_15_612 VPWR VGND sg13g2_decap_8
XFILLER_21_1889 VPWR VGND sg13g2_decap_8
XFILLER_36_63 VPWR VGND sg13g2_fill_1
X_15550_ _16094_/A _23008_/Q _22558_/Q _15591_/S VPWR VGND sg13g2_mux2_1
X_12762_ _12762_/Y _12831_/B _12762_/B VPWR VGND sg13g2_nand2b_1
X_14501_ _14502_/C _22610_/Q _23021_/Q VPWR VGND sg13g2_xor2_1
Xclkbuf_4_4__f_clk_i clkbuf_leaf_6_clk_i/A clkbuf_3_2_0_clk_i/X VPWR VGND sg13g2_buf_8
XFILLER_70_751 VPWR VGND sg13g2_fill_2
XFILLER_76_1378 VPWR VGND sg13g2_decap_8
X_15481_ _15489_/A _15481_/A _15481_/B _15481_/C _15481_/D VPWR VGND sg13g2_nand4_1
XFILLER_54_1621 VPWR VGND sg13g2_decap_8
XFILLER_30_626 VPWR VGND sg13g2_decap_4
X_17220_ _17220_/Y _17220_/A _17220_/B VPWR VGND sg13g2_nor2_1
XFILLER_52_40 VPWR VGND sg13g2_decap_8
X_14432_ _14575_/A _14433_/A _14433_/C _14431_/Y VPWR VGND sg13g2_o21ai_1
XFILLER_14_188 VPWR VGND sg13g2_fill_1
XFILLER_54_1654 VPWR VGND sg13g2_fill_1
XFILLER_74_1080 VPWR VGND sg13g2_fill_1
XFILLER_19_1785 VPWR VGND sg13g2_decap_8
XFILLER_52_62 VPWR VGND sg13g2_fill_2
X_17151_ _17152_/B _17195_/A _17173_/B _17156_/D VPWR VGND sg13g2_nor3_1
XFILLER_11_851 VPWR VGND sg13g2_fill_2
X_14363_ _15307_/A _15289_/A _19322_/A VPWR VGND sg13g2_nor2_1
X_11575_ _11575_/Y _14434_/A _11561_/Y _11567_/Y _14152_/B _11574_/Y VPWR VGND sg13g2_a221oi_1
X_13314_ _13314_/X _13308_/X _13311_/Y _13312_/X _13313_/X _14129_/B _12050_/B VPWR
+ VGND sg13g2_mux4_1
X_17082_ _17083_/A _22721_/Q VPWR VGND sg13g2_inv_1
X_14294_ _14294_/Y _16782_/B _16852_/A VPWR VGND sg13g2_nor2_1
X_13245_ _13246_/B _11363_/B _13241_/X _13244_/X _13245_/B2 VPWR VGND sg13g2_a22oi_1
X_13176_ _13176_/Y _13120_/A _13175_/X _13776_/A1 VPWR VGND sg13g2_o21ai_1
XFILLER_112_915 VPWR VGND sg13g2_decap_8
XFILLER_100_1398 VPWR VGND sg13g2_decap_8
XFILLER_112_926 VPWR VGND sg13g2_fill_1
XFILLER_111_403 VPWR VGND sg13g2_fill_1
XFILLER_112_937 VPWR VGND sg13g2_decap_4
XFILLER_97_637 VPWR VGND sg13g2_fill_2
X_12127_ _12128_/B _24188_/Q _23260_/Q _23324_/Q _23388_/Q _11797_/S _11708_/B VPWR
+ VGND sg13g2_mux4_1
XFILLER_26_1712 VPWR VGND sg13g2_fill_1
XFILLER_96_125 VPWR VGND sg13g2_decap_8
X_17984_ _18498_/A _18560_/S _17980_/X _17983_/Y VPWR VGND sg13g2_a21o_1
XFILLER_26_1734 VPWR VGND sg13g2_decap_8
XFILLER_65_1783 VPWR VGND sg13g2_decap_4
XFILLER_46_1182 VPWR VGND sg13g2_decap_8
X_16935_ _16935_/Y _22697_/Q _16935_/B VPWR VGND sg13g2_xnor2_1
X_12058_ _12065_/C _12606_/A _12058_/B VPWR VGND sg13g2_nor2_1
XFILLER_37_203 VPWR VGND sg13g2_fill_1
XFILLER_42_1057 VPWR VGND sg13g2_fill_1
X_19654_ _19654_/Y _19872_/A _19654_/B VPWR VGND sg13g2_nor2_1
X_16866_ _16877_/A _22685_/Q VPWR VGND sg13g2_inv_1
XFILLER_93_854 VPWR VGND sg13g2_fill_2
XFILLER_4_1552 VPWR VGND sg13g2_fill_1
X_18605_ _18605_/Y _18616_/D _18607_/A _18757_/A VPWR VGND sg13g2_o21ai_1
XFILLER_0_1405 VPWR VGND sg13g2_decap_4
XFILLER_37_258 VPWR VGND sg13g2_decap_8
X_15817_ _15817_/Y _20208_/A _15817_/B VPWR VGND sg13g2_nand2_1
X_19585_ _19585_/Y _19634_/B _19585_/B VPWR VGND sg13g2_nand2_1
XFILLER_37_269 VPWR VGND sg13g2_decap_8
XFILLER_46_770 VPWR VGND sg13g2_decap_8
X_18536_ _22992_/D _18557_/B _18534_/Y _18535_/Y VPWR VGND sg13g2_o21ai_1
XFILLER_80_548 VPWR VGND sg13g2_decap_8
XFILLER_18_494 VPWR VGND sg13g2_decap_4
X_15748_ _15753_/B _15944_/A _15748_/B VPWR VGND sg13g2_or2_1
XFILLER_34_965 VPWR VGND sg13g2_decap_8
XFILLER_34_976 VPWR VGND sg13g2_fill_1
X_18467_ _18467_/Y _18385_/B _18259_/B _18466_/Y _18007_/Y VPWR VGND sg13g2_a22oi_1
X_15679_ _15681_/A _22766_/Q _15700_/B _16007_/B _22798_/Q VPWR VGND sg13g2_a22oi_1
XFILLER_33_486 VPWR VGND sg13g2_fill_2
Xplace4103 _18549_/S _18030_/A VPWR VGND sg13g2_buf_1
X_17418_ _22828_/D _16169_/A _17419_/B _17417_/Y VPWR VGND sg13g2_o21ai_1
Xplace4114 _13343_/B _22988_/Q VPWR VGND sg13g2_buf_1
X_18398_ _18399_/B _18279_/A _18403_/B _18397_/Y _18197_/B VPWR VGND sg13g2_a22oi_1
Xplace4125 _13213_/S _13708_/B VPWR VGND sg13g2_buf_2
XFILLER_20_136 VPWR VGND sg13g2_fill_1
Xplace4136 _12567_/A _11456_/B VPWR VGND sg13g2_buf_1
XFILLER_105_1232 VPWR VGND sg13g2_decap_8
Xplace3402 _17324_/B _17321_/B VPWR VGND sg13g2_buf_1
Xplace4147 _13964_/S1 _11493_/A VPWR VGND sg13g2_buf_1
X_17349_ _22801_/D _16142_/A _17369_/B _17348_/Y VPWR VGND sg13g2_o21ai_1
Xplace3413 _17291_/B _17266_/B VPWR VGND sg13g2_buf_1
Xplace4158 _12121_/S _11726_/S VPWR VGND sg13g2_buf_2
Xplace3424 _16495_/S _16512_/B VPWR VGND sg13g2_buf_1
Xplace4169 _13016_/S _13251_/B VPWR VGND sg13g2_buf_2
XFILLER_105_1265 VPWR VGND sg13g2_fill_1
XFILLER_14_1159 VPWR VGND sg13g2_decap_4
Xplace3435 _20345_/A1 _20367_/B VPWR VGND sg13g2_buf_1
Xplace3446 _17789_/B _17796_/B VPWR VGND sg13g2_buf_1
Xplace3457 _17080_/B _17092_/B VPWR VGND sg13g2_buf_1
XFILLER_88_1227 VPWR VGND sg13g2_decap_8
XFILLER_9_192 VPWR VGND sg13g2_fill_2
X_20360_ _20361_/B _20177_/A _19471_/Y _20091_/B _20360_/B2 _20359_/Y VPWR VGND sg13g2_a221oi_1
Xplace3468 _16760_/A _16711_/A VPWR VGND sg13g2_buf_1
Xplace3479 _16075_/B _16071_/B VPWR VGND sg13g2_buf_1
X_19019_ _19019_/Y _19019_/A _19019_/B _19019_/C VPWR VGND sg13g2_nand3_1
X_20291_ _20291_/Y _20291_/A _20291_/B VPWR VGND sg13g2_nand2_1
XFILLER_66_1503 VPWR VGND sg13g2_fill_2
X_22030_ _24008_/D _22298_/A0 _24008_/Q _22047_/S VPWR VGND sg13g2_mux2_1
XFILLER_66_1536 VPWR VGND sg13g2_decap_8
XFILLER_115_775 VPWR VGND sg13g2_decap_8
XFILLER_114_252 VPWR VGND sg13g2_decap_8
XFILLER_103_937 VPWR VGND sg13g2_fill_2
XFILLER_102_414 VPWR VGND sg13g2_decap_8
XFILLER_87_114 VPWR VGND sg13g2_decap_8
XFILLER_83_1872 VPWR VGND sg13g2_decap_8
XFILLER_69_862 VPWR VGND sg13g2_decap_8
X_23981_ _23981_/Q clkload30/A _23981_/D fanout2657/X VPWR VGND sg13g2_dfrbpq_1
XFILLER_69_873 VPWR VGND sg13g2_fill_1
XFILLER_60_1135 VPWR VGND sg13g2_decap_8
XFILLER_44_1878 VPWR VGND sg13g2_decap_8
XFILLER_56_512 VPWR VGND sg13g2_decap_4
X_22932_ _22932_/Q _22941_/CLK _22932_/D fanout2801/X VPWR VGND sg13g2_dfrbpq_1
XFILLER_83_320 VPWR VGND sg13g2_decap_4
XFILLER_29_759 VPWR VGND sg13g2_fill_1
XFILLER_113_35 VPWR VGND sg13g2_decap_8
XFILLER_3_1040 VPWR VGND sg13g2_decap_8
X_22863_ _22863_/Q clkload7/A _22863_/D fanout2794/X VPWR VGND sg13g2_dfrbpq_1
XFILLER_56_578 VPWR VGND sg13g2_fill_2
XFILLER_71_504 VPWR VGND sg13g2_decap_8
XFILLER_44_729 VPWR VGND sg13g2_decap_8
XFILLER_71_515 VPWR VGND sg13g2_fill_2
X_21814_ _21814_/Y _21814_/A _21818_/B VPWR VGND sg13g2_nand2_1
X_22794_ _22794_/Q clkload19/A _22794_/D fanout2864/X VPWR VGND sg13g2_dfrbpq_1
XFILLER_36_291 VPWR VGND sg13g2_decap_8
XFILLER_52_751 VPWR VGND sg13g2_decap_4
XFILLER_25_976 VPWR VGND sg13g2_decap_8
XFILLER_58_1064 VPWR VGND sg13g2_decap_8
XFILLER_19_1026 VPWR VGND sg13g2_decap_8
XFILLER_12_604 VPWR VGND sg13g2_decap_8
X_21745_ _21745_/Y _23876_/Q _21751_/B VPWR VGND sg13g2_nand2_1
XFILLER_52_795 VPWR VGND sg13g2_decap_4
XFILLER_11_114 VPWR VGND sg13g2_fill_1
XFILLER_36_1340 VPWR VGND sg13g2_decap_8
XFILLER_40_968 VPWR VGND sg13g2_fill_2
X_21676_ _21676_/Y _21676_/A _21690_/B VPWR VGND sg13g2_nand2_1
XFILLER_16_1947 VPWR VGND sg13g2_decap_8
XFILLER_11_147 VPWR VGND sg13g2_decap_8
X_23415_ _23415_/Q clkload57/A _23415_/D fanout2762/X VPWR VGND sg13g2_dfrbpq_1
XFILLER_11_158 VPWR VGND sg13g2_fill_2
X_20627_ _23367_/D _22429_/A1 _20638_/B _20626_/Y VPWR VGND sg13g2_o21ai_1
XFILLER_103_1917 VPWR VGND sg13g2_decap_8
X_11360_ _12039_/B _12175_/B _12042_/B VPWR VGND sg13g2_and2_2
X_23346_ _23346_/Q _24212_/CLK _23346_/D fanout2633/X VPWR VGND sg13g2_dfrbpq_1
X_20558_ _23334_/D _22427_/A1 _20565_/B _20557_/Y VPWR VGND sg13g2_o21ai_1
XFILLER_4_803 VPWR VGND sg13g2_decap_4
XFILLER_98_14 VPWR VGND sg13g2_decap_8
Xplace3980 _13975_/A2 _11824_/Y VPWR VGND sg13g2_buf_1
Xplace3991 _11951_/A _12575_/A VPWR VGND sg13g2_buf_2
X_23277_ _23277_/Q _24205_/CLK _23277_/D fanout2645/X VPWR VGND sg13g2_dfrbpq_1
X_20489_ _23304_/D _23304_/Q _21898_/A0 _20511_/S VPWR VGND sg13g2_mux2_1
X_13030_ _13030_/X _23719_/Q _23751_/Q _23783_/Q _23815_/Q _13707_/S0 _13270_/S1 VPWR
+ VGND sg13g2_mux4_1
X_22228_ _24102_/D _22294_/A1 _22229_/B _22227_/Y VPWR VGND sg13g2_o21ai_1
XFILLER_79_615 VPWR VGND sg13g2_decap_8
XFILLER_106_786 VPWR VGND sg13g2_decap_4
Xhold4660 _17315_/A _22786_/Q VPWR VGND sg13g2_dlygate4sd3_1
XFILLER_105_274 VPWR VGND sg13g2_decap_8
XFILLER_79_648 VPWR VGND sg13g2_fill_1
XFILLER_78_125 VPWR VGND sg13g2_decap_8
XFILLER_26_1019 VPWR VGND sg13g2_decap_8
Xhold4671 _17329_/A _22792_/Q VPWR VGND sg13g2_dlygate4sd3_1
X_22159_ _24069_/D _22292_/A1 _22160_/B _22158_/Y VPWR VGND sg13g2_o21ai_1
XFILLER_65_1068 VPWR VGND sg13g2_decap_8
Xhold4682 _18108_/A _22949_/Q VPWR VGND sg13g2_dlygate4sd3_1
Xhold4693 _17298_/A _22779_/Q VPWR VGND sg13g2_dlygate4sd3_1
XFILLER_47_1480 VPWR VGND sg13g2_decap_4
XFILLER_78_158 VPWR VGND sg13g2_decap_8
XFILLER_47_1491 VPWR VGND sg13g2_fill_1
XFILLER_82_1382 VPWR VGND sg13g2_fill_2
XFILLER_43_1333 VPWR VGND sg13g2_decap_8
X_14981_ _16288_/B _16282_/A _16282_/B _16284_/B VPWR VGND sg13g2_o21ai_1
XFILLER_93_106 VPWR VGND sg13g2_decap_4
XFILLER_19_203 VPWR VGND sg13g2_decap_8
XFILLER_59_372 VPWR VGND sg13g2_decap_8
XFILLER_75_821 VPWR VGND sg13g2_decap_8
X_16720_ _16720_/Y _16728_/A _16720_/B VPWR VGND sg13g2_nor2_1
XFILLER_19_214 VPWR VGND sg13g2_fill_1
XFILLER_59_383 VPWR VGND sg13g2_fill_1
X_13932_ _13932_/Y _13932_/A _13932_/B _13932_/C _13932_/D VPWR VGND sg13g2_nand4_1
XFILLER_86_180 VPWR VGND sg13g2_decap_8
XFILLER_19_225 VPWR VGND sg13g2_decap_8
XFILLER_5_1861 VPWR VGND sg13g2_decap_8
XFILLER_74_342 VPWR VGND sg13g2_decap_8
XFILLER_35_707 VPWR VGND sg13g2_fill_2
X_16651_ _16652_/B _22645_/Q _16651_/B VPWR VGND sg13g2_xnor2_1
X_13863_ _13864_/C _13717_/B _13805_/Y _13350_/A VPWR VGND sg13g2_a21o_1
XFILLER_74_353 VPWR VGND sg13g2_fill_1
XFILLER_95_1710 VPWR VGND sg13g2_fill_1
XFILLER_34_206 VPWR VGND sg13g2_decap_8
XFILLER_90_846 VPWR VGND sg13g2_decap_8
X_12814_ _12814_/Y _23556_/Q _12922_/A2 _12813_/X _12452_/A VPWR VGND sg13g2_a22oi_1
X_15602_ _15602_/Y _15602_/A _15602_/B VPWR VGND sg13g2_nand2_1
X_19370_ _19634_/A _19366_/Y _19368_/Y _19563_/B VPWR VGND sg13g2_mux2_1
XFILLER_95_1743 VPWR VGND sg13g2_decap_8
XFILLER_62_548 VPWR VGND sg13g2_decap_8
X_16582_ _16583_/B _22631_/Q _16589_/C VPWR VGND sg13g2_xor2_1
X_13794_ _13794_/X _13792_/X _13793_/X _13794_/S VPWR VGND sg13g2_mux2_1
XFILLER_1_1769 VPWR VGND sg13g2_decap_8
XFILLER_43_751 VPWR VGND sg13g2_fill_2
XFILLER_91_1618 VPWR VGND sg13g2_fill_2
XFILLER_31_902 VPWR VGND sg13g2_fill_2
X_18321_ _22978_/D _11571_/B _18355_/A _18320_/Y VPWR VGND sg13g2_a21oi_1
X_15533_ _15533_/Y _16014_/A _15533_/B VPWR VGND sg13g2_nor2_1
X_12745_ _12745_/Y _12745_/A _12745_/B _12745_/C _12745_/D VPWR VGND sg13g2_nor4_2
XFILLER_43_762 VPWR VGND sg13g2_decap_8
XFILLER_16_998 VPWR VGND sg13g2_decap_4
XFILLER_15_475 VPWR VGND sg13g2_fill_2
X_18252_ _18252_/Y _18517_/A _18144_/A _18254_/A _18301_/B VPWR VGND sg13g2_a22oi_1
X_15464_ _15465_/C _22916_/Q _15289_/X _15463_/Y VPWR VGND sg13g2_a21oi_1
XFILLER_31_957 VPWR VGND sg13g2_fill_1
XFILLER_42_294 VPWR VGND sg13g2_fill_2
X_12676_ _12677_/B _12676_/A _13552_/A VPWR VGND sg13g2_nor2_1
XFILLER_30_445 VPWR VGND sg13g2_decap_8
XFILLER_106_1541 VPWR VGND sg13g2_decap_8
X_17203_ _22743_/D _17220_/B _17201_/Y _17202_/Y VPWR VGND sg13g2_a21oi_1
XFILLER_8_34 VPWR VGND sg13g2_fill_2
XFILLER_50_1315 VPWR VGND sg13g2_fill_2
X_11627_ _11628_/B _14120_/C _11311_/A _11250_/A VPWR VGND sg13g2_o21ai_1
X_15395_ _15396_/D _22591_/Q _16441_/A _16161_/A _22486_/Q VPWR VGND sg13g2_a22oi_1
X_18183_ _18184_/C _18421_/A _18416_/A _18562_/A VPWR VGND sg13g2_o21ai_1
XFILLER_15_1468 VPWR VGND sg13g2_decap_8
X_14346_ _14347_/D _15165_/B _14346_/B _14346_/C VPWR VGND sg13g2_nor3_1
X_17134_ _17134_/Y _22731_/Q _17134_/B VPWR VGND sg13g2_xnor2_1
XFILLER_15_1479 VPWR VGND sg13g2_fill_1
XFILLER_102_1449 VPWR VGND sg13g2_fill_1
XFILLER_13_1170 VPWR VGND sg13g2_fill_1
XFILLER_67_1801 VPWR VGND sg13g2_fill_1
XFILLER_109_580 VPWR VGND sg13g2_decap_8
X_14277_ _19777_/A _14346_/B _14346_/C VPWR VGND sg13g2_nor2_1
X_11489_ _11489_/X _11487_/X _11488_/X _12557_/S VPWR VGND sg13g2_mux2_1
X_16016_ _16017_/C _16016_/A _16016_/B _16016_/C _16016_/D VPWR VGND sg13g2_nand4_1
X_13228_ _13228_/Y _24074_/Q _13232_/S VPWR VGND sg13g2_nand2b_1
XFILLER_100_1173 VPWR VGND sg13g2_decap_8
XFILLER_87_1293 VPWR VGND sg13g2_decap_8
XFILLER_112_712 VPWR VGND sg13g2_decap_8
X_13159_ _13159_/Y _23529_/Q _13166_/B VPWR VGND sg13g2_nand2b_1
XFILLER_44_1108 VPWR VGND sg13g2_fill_1
XFILLER_85_607 VPWR VGND sg13g2_fill_1
XFILLER_112_789 VPWR VGND sg13g2_decap_8
XFILLER_97_478 VPWR VGND sg13g2_decap_8
X_17967_ _17968_/B _18918_/B _23050_/Q _18052_/S VPWR VGND sg13g2_mux2_1
X_19706_ _19706_/Y _20080_/A _19706_/B _19706_/C VPWR VGND sg13g2_nand3_1
X_16918_ _16919_/C _22693_/Q _22692_/Q VPWR VGND sg13g2_nand2_1
XFILLER_78_692 VPWR VGND sg13g2_decap_8
X_17898_ _22930_/D _17898_/A _17898_/B VPWR VGND sg13g2_nand2_1
XFILLER_38_545 VPWR VGND sg13g2_decap_8
XFILLER_66_865 VPWR VGND sg13g2_decap_4
X_19637_ _19637_/Y _19874_/B _19635_/Y _19636_/Y VPWR VGND sg13g2_a21oi_1
X_16849_ _16850_/B _16849_/A _16849_/B VPWR VGND sg13g2_nor2_1
XFILLER_0_1202 VPWR VGND sg13g2_fill_2
XFILLER_66_898 VPWR VGND sg13g2_fill_1
XFILLER_81_835 VPWR VGND sg13g2_decap_8
XFILLER_80_312 VPWR VGND sg13g2_decap_8
XFILLER_39_1903 VPWR VGND sg13g2_fill_1
XFILLER_81_846 VPWR VGND sg13g2_fill_1
XFILLER_80_323 VPWR VGND sg13g2_fill_1
X_19568_ _19568_/Y _19986_/A _19568_/B VPWR VGND sg13g2_nand2_1
XFILLER_0_1246 VPWR VGND sg13g2_fill_1
XFILLER_39_1947 VPWR VGND sg13g2_decap_8
XFILLER_22_902 VPWR VGND sg13g2_decap_8
X_18519_ _18519_/Y _18539_/A _18509_/X _18518_/Y _18064_/C _18348_/B VPWR VGND sg13g2_a221oi_1
X_19499_ _19512_/A _23196_/Q VPWR VGND sg13g2_inv_1
XFILLER_21_401 VPWR VGND sg13g2_decap_8
XFILLER_55_1248 VPWR VGND sg13g2_fill_2
X_21530_ _21530_/Y _23781_/Q _21530_/B VPWR VGND sg13g2_nand2_1
XFILLER_55_1259 VPWR VGND sg13g2_fill_2
XFILLER_21_467 VPWR VGND sg13g2_fill_2
XFILLER_33_1535 VPWR VGND sg13g2_fill_1
X_21461_ _21461_/Y _21461_/A _21473_/B VPWR VGND sg13g2_nand2_1
XFILLER_33_1546 VPWR VGND sg13g2_fill_2
Xplace3210 _20365_/B _20300_/B VPWR VGND sg13g2_buf_1
Xplace3221 _22393_/B _22402_/B VPWR VGND sg13g2_buf_1
X_23200_ _23200_/Q clkload33/A _23200_/D fanout2930/X VPWR VGND sg13g2_dfrbpq_1
Xplace3232 _21648_/B _21642_/B VPWR VGND sg13g2_buf_1
X_20412_ _20412_/Y _20412_/A _20412_/B VPWR VGND sg13g2_nand2_1
Xplace3243 _21197_/B _21205_/B VPWR VGND sg13g2_buf_1
X_24180_ _24180_/Q _24214_/CLK _24180_/D fanout2628/X VPWR VGND sg13g2_dfrbpq_1
XFILLER_107_506 VPWR VGND sg13g2_decap_8
XFILLER_11_1811 VPWR VGND sg13g2_decap_8
X_21392_ _21392_/Y _21392_/A _21398_/B VPWR VGND sg13g2_nand2_1
Xplace3254 _21622_/A1 _21983_/A1 VPWR VGND sg13g2_buf_1
Xplace3265 _21975_/A0 _21346_/A0 VPWR VGND sg13g2_buf_1
Xplace3276 _22233_/A0 _20187_/Y VPWR VGND sg13g2_buf_1
X_23131_ _23131_/Q clkload5/A _23131_/D fanout2835/X VPWR VGND sg13g2_dfrbpq_1
X_20343_ _20343_/X _20343_/A0 _20343_/A1 _20343_/A2 _20343_/A3 _20343_/S0 _20343_/S1
+ VPWR VGND sg13g2_mux4_1
Xplace3287 _21958_/A1 _22292_/A1 VPWR VGND sg13g2_buf_1
XFILLER_49_1019 VPWR VGND sg13g2_decap_8
Xplace3298 _21946_/A1 _19972_/Y VPWR VGND sg13g2_buf_1
XFILLER_108_35 VPWR VGND sg13g2_decap_8
XFILLER_11_1888 VPWR VGND sg13g2_decap_8
X_23062_ _23062_/Q clkload14/A _23062_/D fanout2843/X VPWR VGND sg13g2_dfrbpq_1
XFILLER_89_913 VPWR VGND sg13g2_fill_2
X_20274_ _20274_/Y _20335_/A _19798_/X _20273_/Y VPWR VGND sg13g2_o21ai_1
XFILLER_115_572 VPWR VGND sg13g2_decap_8
XFILLER_66_1355 VPWR VGND sg13g2_fill_2
X_22013_ _22013_/Y _22013_/A _22017_/B VPWR VGND sg13g2_nand2_1
XFILLER_27_1328 VPWR VGND sg13g2_decap_8
XFILLER_103_767 VPWR VGND sg13g2_fill_1
XFILLER_9_1260 VPWR VGND sg13g2_fill_2
XFILLER_44_1653 VPWR VGND sg13g2_decap_8
XFILLER_69_670 VPWR VGND sg13g2_decap_8
XFILLER_112_1000 VPWR VGND sg13g2_fill_1
X_23964_ _23964_/Q _23966_/CLK _23964_/D fanout2765/X VPWR VGND sg13g2_dfrbpq_1
XFILLER_99_1120 VPWR VGND sg13g2_fill_1
XFILLER_5_1168 VPWR VGND sg13g2_fill_1
XFILLER_112_1055 VPWR VGND sg13g2_decap_4
X_22915_ _22915_/Q _22917_/CLK _22915_/D fanout2895/X VPWR VGND sg13g2_dfrbpq_1
XFILLER_56_364 VPWR VGND sg13g2_decap_8
X_23895_ _23895_/Q clkload46/A _23895_/D fanout2686/X VPWR VGND sg13g2_dfrbpq_1
XFILLER_95_1017 VPWR VGND sg13g2_decap_4
Xclkbuf_leaf_3_clk_i clkload9/A clkbuf_leaf_4_clk_i/A VPWR VGND sg13g2_buf_16
XFILLER_44_526 VPWR VGND sg13g2_fill_1
X_22846_ _22846_/Q clkload21/A _22846_/D fanout2874/X VPWR VGND sg13g2_dfrbpq_1
XFILLER_13_902 VPWR VGND sg13g2_fill_2
X_22777_ _22777_/Q clkload8/A _22777_/D fanout2798/X VPWR VGND sg13g2_dfrbpq_1
XFILLER_13_968 VPWR VGND sg13g2_decap_8
XFILLER_16_1733 VPWR VGND sg13g2_fill_1
XFILLER_9_939 VPWR VGND sg13g2_decap_8
X_12461_ _12461_/Y _12461_/A _12461_/B _12461_/C _12461_/D VPWR VGND sg13g2_nand4_1
XFILLER_16_1755 VPWR VGND sg13g2_fill_1
X_14200_ _14200_/X _15356_/A _22839_/Q VPWR VGND sg13g2_and2_1
X_11412_ _11412_/Y _11752_/B _23574_/Q _11411_/Y VPWR VGND sg13g2_o21ai_1
XFILLER_32_1045 VPWR VGND sg13g2_decap_8
XFILLER_32_1056 VPWR VGND sg13g2_fill_1
X_12392_ _12392_/X _12458_/A _12392_/B VPWR VGND sg13g2_or2_1
X_14131_ _14132_/C _19235_/B _22971_/Q _22972_/Q VPWR VGND sg13g2_nor3_1
X_23329_ _23329_/Q _23682_/CLK _23329_/D fanout2723/X VPWR VGND sg13g2_dfrbpq_1
Xrebuffer5490 _13758_/B1 _13856_/D VPWR VGND sg13g2_buf_1
X_11343_ _11910_/B _11921_/A _12175_/B VPWR VGND sg13g2_nor2b_2
XFILLER_10_1343 VPWR VGND sg13g2_fill_2
XFILLER_3_110 VPWR VGND sg13g2_decap_8
X_14062_ _14064_/C _24253_/A _14062_/B VPWR VGND sg13g2_nor2_1
X_11274_ _11274_/X _24023_/Q _24055_/Q _24087_/Q _24119_/Q _13193_/S0 _12004_/S VPWR
+ VGND sg13g2_mux4_1
XFILLER_10_1387 VPWR VGND sg13g2_decap_8
Xhold5180 _20805_/A _23452_/Q VPWR VGND sg13g2_dlygate4sd3_1
XFILLER_10_1398 VPWR VGND sg13g2_fill_2
X_13013_ _13014_/A _13434_/A _13077_/C VPWR VGND sg13g2_xnor2_1
Xhold5191 _21605_/A _23818_/Q VPWR VGND sg13g2_dlygate4sd3_1
XFILLER_106_594 VPWR VGND sg13g2_decap_8
XFILLER_80_1308 VPWR VGND sg13g2_decap_4
X_18870_ _23045_/D _18870_/A _18870_/B _18870_/C VPWR VGND sg13g2_nand3_1
XFILLER_45_1428 VPWR VGND sg13g2_decap_8
XFILLER_95_905 VPWR VGND sg13g2_fill_2
X_17821_ _17821_/X _22579_/Q _17821_/B VPWR VGND sg13g2_xor2_1
XFILLER_67_607 VPWR VGND sg13g2_decap_8
XFILLER_62_1742 VPWR VGND sg13g2_fill_2
XFILLER_114_1832 VPWR VGND sg13g2_decap_8
XFILLER_94_426 VPWR VGND sg13g2_decap_8
XFILLER_0_894 VPWR VGND sg13g2_fill_2
XFILLER_94_448 VPWR VGND sg13g2_decap_8
X_17752_ _17752_/Y _22899_/Q _17811_/B VPWR VGND sg13g2_nor2_1
X_14964_ _14964_/Y _14982_/S _16278_/C _14963_/Y VPWR VGND sg13g2_a21oi_1
X_16703_ _16709_/A _22656_/Q VPWR VGND sg13g2_inv_1
X_13915_ _13915_/X _13909_/X _13912_/Y _13913_/X _13914_/X _13770_/A _11774_/A VPWR
+ VGND sg13g2_mux4_1
XFILLER_81_109 VPWR VGND sg13g2_decap_4
XFILLER_48_887 VPWR VGND sg13g2_decap_8
XFILLER_78_1226 VPWR VGND sg13g2_decap_4
X_17683_ _17683_/Y _22891_/Q _17702_/B VPWR VGND sg13g2_nor2_1
X_14895_ _14896_/C _22491_/Q _14912_/B _15103_/B1 _22919_/Q VPWR VGND sg13g2_a22oi_1
XFILLER_90_621 VPWR VGND sg13g2_fill_2
XFILLER_35_526 VPWR VGND sg13g2_decap_8
X_19422_ _19422_/Y _20193_/B _19443_/B _19421_/Y VPWR VGND sg13g2_o21ai_1
XFILLER_1_1533 VPWR VGND sg13g2_decap_8
XFILLER_74_172 VPWR VGND sg13g2_decap_8
XFILLER_63_857 VPWR VGND sg13g2_decap_4
X_16634_ _16638_/C _22641_/Q _16634_/B VPWR VGND sg13g2_and2_1
X_13846_ _13846_/Y _13846_/A _13904_/B VPWR VGND sg13g2_nand2_1
XFILLER_74_71 VPWR VGND sg13g2_decap_4
XFILLER_50_507 VPWR VGND sg13g2_decap_4
X_19353_ _19639_/B _19350_/X _19352_/Y _19573_/S VPWR VGND sg13g2_mux2_1
X_16565_ _16575_/C _22584_/Q _16565_/B _16683_/A VPWR VGND sg13g2_nor3_1
X_13777_ _13777_/Y _11355_/A _13766_/X _13776_/Y VPWR VGND sg13g2_o21ai_1
XFILLER_91_1448 VPWR VGND sg13g2_decap_8
X_18304_ _18304_/Y _18427_/A _18334_/A _18564_/A1 _18485_/B VPWR VGND sg13g2_a22oi_1
X_15516_ _15516_/Y _22459_/Q VPWR VGND sg13g2_inv_1
XFILLER_15_294 VPWR VGND sg13g2_decap_8
X_19284_ _23202_/D _23202_/Q _20316_/A1 _19303_/S VPWR VGND sg13g2_mux2_1
XFILLER_34_1800 VPWR VGND sg13g2_fill_1
X_12728_ _12728_/X _23843_/Q _23875_/Q _23939_/Q _23971_/Q _12978_/S0 _12877_/B VPWR
+ VGND sg13g2_mux4_1
X_16496_ _16496_/Y _22610_/Q _16506_/B VPWR VGND sg13g2_nand2_1
X_18235_ _22970_/D _11311_/A _18286_/A _18234_/Y VPWR VGND sg13g2_a21o_1
X_15447_ _15452_/C _15447_/A _15447_/B _15447_/C VPWR VGND sg13g2_nor3_1
X_12659_ _12659_/X _23906_/Q _24002_/Q _12721_/S VPWR VGND sg13g2_mux2_1
XFILLER_31_798 VPWR VGND sg13g2_fill_1
XFILLER_54_1292 VPWR VGND sg13g2_decap_8
XFILLER_12_990 VPWR VGND sg13g2_fill_1
XFILLER_106_1382 VPWR VGND sg13g2_decap_4
XFILLER_89_1322 VPWR VGND sg13g2_fill_1
XFILLER_11_1107 VPWR VGND sg13g2_decap_8
XFILLER_69_1918 VPWR VGND sg13g2_decap_8
XFILLER_102_1257 VPWR VGND sg13g2_decap_8
X_17117_ _17118_/B _17122_/B _17177_/A VPWR VGND sg13g2_nor2_1
X_14329_ _16439_/A _15289_/A _19346_/A _19322_/A _15178_/C VPWR VGND sg13g2_nor4_2
X_18097_ _22946_/D _22946_/Q _18096_/C _18096_/Y VPWR VGND sg13g2_a21o_1
X_17048_ _17049_/S _17048_/A _17122_/B VPWR VGND sg13g2_nor2_1
XFILLER_48_1052 VPWR VGND sg13g2_decap_8
XFILLER_67_1686 VPWR VGND sg13g2_fill_2
XFILLER_98_776 VPWR VGND sg13g2_fill_1
XFILLER_58_629 VPWR VGND sg13g2_decap_8
XFILLER_98_798 VPWR VGND sg13g2_fill_1
XFILLER_85_415 VPWR VGND sg13g2_decap_8
X_18999_ _18999_/Y _18999_/A _18999_/B VPWR VGND sg13g2_nand2_1
XFILLER_112_586 VPWR VGND sg13g2_decap_8
XFILLER_61_1241 VPWR VGND sg13g2_fill_1
XFILLER_100_737 VPWR VGND sg13g2_decap_8
XFILLER_80_1864 VPWR VGND sg13g2_fill_2
XFILLER_26_1361 VPWR VGND sg13g2_fill_1
XFILLER_6_1444 VPWR VGND sg13g2_fill_2
XFILLER_22_1214 VPWR VGND sg13g2_decap_8
XFILLER_54_802 VPWR VGND sg13g2_decap_8
X_20961_ _23525_/D _21329_/A1 _20962_/B _20960_/Y VPWR VGND sg13g2_o21ai_1
XFILLER_26_504 VPWR VGND sg13g2_fill_2
XFILLER_38_364 VPWR VGND sg13g2_decap_4
XFILLER_113_1386 VPWR VGND sg13g2_decap_4
X_22700_ _22700_/Q _22733_/CLK _22700_/D fanout2882/X VPWR VGND sg13g2_dfrbpq_1
XFILLER_53_312 VPWR VGND sg13g2_decap_8
XFILLER_54_846 VPWR VGND sg13g2_decap_8
X_23680_ _23680_/Q clkload39/A _23680_/D fanout2739/X VPWR VGND sg13g2_dfrbpq_1
X_20892_ _20892_/Y _23492_/Q _20903_/B VPWR VGND sg13g2_nand2_1
X_22631_ _22631_/Q clkload23/A _22631_/D fanout2883/X VPWR VGND sg13g2_dfrbpq_1
XFILLER_78_1782 VPWR VGND sg13g2_decap_8
XFILLER_55_1001 VPWR VGND sg13g2_fill_2
XFILLER_110_14 VPWR VGND sg13g2_decap_8
XFILLER_34_592 VPWR VGND sg13g2_fill_1
X_22562_ _22562_/Q clkload26/A _22562_/D fanout2851/X VPWR VGND sg13g2_dfrbpq_1
XFILLER_16_1007 VPWR VGND sg13g2_decap_8
X_21513_ _21513_/Y _23773_/Q _21515_/B VPWR VGND sg13g2_nand2_1
XFILLER_21_253 VPWR VGND sg13g2_decap_8
XFILLER_33_1321 VPWR VGND sg13g2_decap_4
XFILLER_37_1490 VPWR VGND sg13g2_decap_4
X_22493_ _22493_/Q clkload26/A _22493_/D fanout2829/X VPWR VGND sg13g2_dfrbpq_1
XFILLER_13_1906 VPWR VGND sg13g2_decap_8
X_24232_ _24232_/Q clkload5/A _24232_/D fanout2841/X VPWR VGND sg13g2_dfrbpq_1
X_21444_ _23740_/D _21938_/A1 _21447_/B _21443_/Y VPWR VGND sg13g2_o21ai_1
Xplace3040 _22108_/B _22095_/B VPWR VGND sg13g2_buf_1
Xplace3051 _21935_/B _21965_/S VPWR VGND sg13g2_buf_1
Xplace3062 _21910_/B _21916_/B VPWR VGND sg13g2_buf_1
X_24163_ _24163_/Q _24196_/CLK _24163_/D fanout2698/X VPWR VGND sg13g2_dfrbpq_1
Xplace3073 _21826_/B _21832_/S VPWR VGND sg13g2_buf_1
X_21375_ _23707_/D _21936_/A1 _21374_/B _21374_/Y VPWR VGND sg13g2_o21ai_1
XFILLER_79_16 VPWR VGND sg13g2_decap_8
XFILLER_11_1641 VPWR VGND sg13g2_decap_8
Xplace3084 _21515_/B _21508_/B VPWR VGND sg13g2_buf_1
Xplace3095 _21483_/B _21467_/B VPWR VGND sg13g2_buf_1
XFILLER_107_358 VPWR VGND sg13g2_decap_8
XFILLER_102_1780 VPWR VGND sg13g2_fill_1
X_23114_ _23114_/Q _23114_/CLK _23114_/D fanout2910/X VPWR VGND sg13g2_dfrbpq_1
X_20326_ _20326_/Y _15977_/C _20326_/B VPWR VGND sg13g2_nand2b_1
X_24094_ _24094_/Q clkload44/A _24094_/D fanout2745/X VPWR VGND sg13g2_dfrbpq_1
XFILLER_85_1775 VPWR VGND sg13g2_fill_1
X_23045_ _23045_/Q clkload13/A _23045_/D fanout2907/X VPWR VGND sg13g2_dfrbpq_1
XFILLER_103_520 VPWR VGND sg13g2_decap_8
X_20257_ _20265_/B _24270_/A _20286_/B VPWR VGND sg13g2_nand2_1
XFILLER_77_905 VPWR VGND sg13g2_fill_1
XFILLER_88_264 VPWR VGND sg13g2_fill_1
XFILLER_0_157 VPWR VGND sg13g2_decap_4
XFILLER_76_404 VPWR VGND sg13g2_decap_4
XFILLER_95_37 VPWR VGND sg13g2_fill_1
XFILLER_103_597 VPWR VGND sg13g2_decap_8
XFILLER_44_1461 VPWR VGND sg13g2_fill_2
XFILLER_48_139 VPWR VGND sg13g2_decap_8
XFILLER_92_919 VPWR VGND sg13g2_fill_2
XFILLER_57_662 VPWR VGND sg13g2_decap_8
XFILLER_85_982 VPWR VGND sg13g2_decap_8
X_11961_ _12558_/A _12577_/B _12778_/A VPWR VGND sg13g2_nand2_1
XFILLER_57_673 VPWR VGND sg13g2_decap_8
XFILLER_2_1820 VPWR VGND sg13g2_decap_8
XFILLER_56_150 VPWR VGND sg13g2_fill_2
X_23947_ _23947_/Q _24210_/CLK _23947_/D fanout2642/X VPWR VGND sg13g2_dfrbpq_1
XFILLER_57_684 VPWR VGND sg13g2_fill_2
XFILLER_84_492 VPWR VGND sg13g2_decap_4
X_13700_ _13700_/X _23440_/Q _23472_/Q _23504_/Q _23536_/Q _13707_/S0 _13251_/B VPWR
+ VGND sg13g2_mux4_1
XFILLER_45_846 VPWR VGND sg13g2_fill_2
X_14680_ _14680_/X _14676_/Y _14678_/Y _14728_/S VPWR VGND sg13g2_mux2_1
X_11892_ _12001_/D _12428_/C _12075_/B _14041_/B VPWR VGND sg13g2_or3_1
X_23878_ _23878_/Q clkload41/A _23878_/D fanout2729/X VPWR VGND sg13g2_dfrbpq_1
XFILLER_56_194 VPWR VGND sg13g2_fill_2
XFILLER_57_1811 VPWR VGND sg13g2_fill_2
XFILLER_72_665 VPWR VGND sg13g2_decap_8
X_13631_ _13632_/B _23855_/Q _23887_/Q _23951_/Q _23983_/Q _13635_/S0 _13631_/S1 VPWR
+ VGND sg13g2_mux4_1
XFILLER_92_1713 VPWR VGND sg13g2_decap_8
XFILLER_2_1897 VPWR VGND sg13g2_decap_8
XFILLER_38_1210 VPWR VGND sg13g2_decap_8
X_22829_ _22829_/Q clkload7/A _22829_/D fanout2795/X VPWR VGND sg13g2_dfrbpq_1
XFILLER_32_518 VPWR VGND sg13g2_decap_8
XFILLER_13_710 VPWR VGND sg13g2_fill_2
XFILLER_38_1243 VPWR VGND sg13g2_decap_8
X_16350_ _16351_/D _16350_/A _16350_/B VPWR VGND sg13g2_nor2_1
X_13562_ _13562_/X _24078_/Q _24142_/Q _13565_/A VPWR VGND sg13g2_mux2_1
XFILLER_34_1129 VPWR VGND sg13g2_fill_2
XFILLER_38_1298 VPWR VGND sg13g2_fill_1
X_12513_ _12543_/S _12538_/A _12538_/B VPWR VGND sg13g2_nor2_1
X_16281_ _22528_/D _16285_/A _16285_/B VPWR VGND sg13g2_xor2_1
XFILLER_90_1470 VPWR VGND sg13g2_fill_2
X_13493_ _13494_/D _13624_/A _13493_/B VPWR VGND sg13g2_nor2_1
XFILLER_40_573 VPWR VGND sg13g2_fill_1
XFILLER_55_1590 VPWR VGND sg13g2_decap_8
XFILLER_40_584 VPWR VGND sg13g2_fill_2
XFILLER_9_758 VPWR VGND sg13g2_fill_1
XFILLER_100_91 VPWR VGND sg13g2_fill_1
XFILLER_16_1563 VPWR VGND sg13g2_fill_2
XFILLER_9_769 VPWR VGND sg13g2_decap_8
X_18020_ _18020_/Y _18541_/A1 _18385_/B _18554_/A1 VPWR VGND sg13g2_a21oi_1
X_15232_ _15232_/Y _15229_/Y _16786_/C VPWR VGND sg13g2_nand2b_1
X_12444_ _12445_/B _24160_/Q _24192_/Q _23232_/Q _23264_/Q _12819_/S0 _12816_/A VPWR
+ VGND sg13g2_mux4_1
XFILLER_8_257 VPWR VGND sg13g2_decap_8
XFILLER_12_1427 VPWR VGND sg13g2_fill_1
XFILLER_8_268 VPWR VGND sg13g2_fill_1
XFILLER_12_1438 VPWR VGND sg13g2_decap_8
XFILLER_60_73 VPWR VGND sg13g2_decap_8
X_15163_ _15163_/X _22588_/Q _16441_/A VPWR VGND sg13g2_and2_1
X_12375_ _12376_/B _23231_/Q _23359_/Q _12377_/S VPWR VGND sg13g2_mux2_1
X_14114_ _17042_/B _14263_/A _22945_/Q VPWR VGND sg13g2_nor2_1
XFILLER_10_1151 VPWR VGND sg13g2_decap_8
X_11326_ _11326_/Y _11595_/A _14124_/A _11596_/C _11326_/D VPWR VGND sg13g2_nor4_1
X_19971_ _19971_/Y _20100_/A1 _19968_/Y _19970_/Y _20352_/A _20367_/A VPWR VGND sg13g2_a221oi_1
X_15094_ _15095_/B _22480_/Q _15114_/A2 _14826_/X VPWR VGND sg13g2_a21oi_1
XFILLER_64_1804 VPWR VGND sg13g2_decap_4
X_18922_ _18922_/Y _18922_/A _18922_/B VPWR VGND sg13g2_nand2_1
XFILLER_64_1815 VPWR VGND sg13g2_fill_1
X_14045_ _14052_/B _14045_/A _14045_/B VPWR VGND sg13g2_nor2_1
X_11257_ _11257_/Y _11316_/B _11257_/B _14121_/B VPWR VGND sg13g2_nand3_1
XFILLER_49_1383 VPWR VGND sg13g2_fill_2
XFILLER_84_1285 VPWR VGND sg13g2_decap_8
XFILLER_79_253 VPWR VGND sg13g2_decap_4
XFILLER_95_713 VPWR VGND sg13g2_decap_4
X_18853_ _18858_/B _23075_/Q _18869_/B VPWR VGND sg13g2_nand2_1
XFILLER_95_735 VPWR VGND sg13g2_decap_8
X_17804_ _17804_/Y _22906_/Q _17811_/B VPWR VGND sg13g2_nor2_1
XFILLER_7_1764 VPWR VGND sg13g2_decap_8
X_18784_ _18784_/Y _18822_/A _18784_/B VPWR VGND sg13g2_nand2_1
XFILLER_94_245 VPWR VGND sg13g2_decap_8
X_15996_ _15996_/X _15996_/A _15996_/B VPWR VGND sg13g2_and2_1
XFILLER_62_1594 VPWR VGND sg13g2_fill_1
XFILLER_94_267 VPWR VGND sg13g2_fill_2
X_17735_ _17735_/Y _17809_/A1 _17733_/Y _17734_/Y VPWR VGND sg13g2_o21ai_1
XFILLER_110_1526 VPWR VGND sg13g2_decap_8
X_14947_ _14949_/B _22465_/Q _14947_/B VPWR VGND sg13g2_nand2_1
XFILLER_85_92 VPWR VGND sg13g2_decap_8
XFILLER_63_632 VPWR VGND sg13g2_decap_8
XFILLER_58_1619 VPWR VGND sg13g2_decap_4
X_17666_ _17666_/Y _17687_/A _22960_/Q VPWR VGND sg13g2_nand2_1
XFILLER_62_120 VPWR VGND sg13g2_fill_2
X_14878_ _14878_/X _23131_/Q _16250_/B _14933_/S VPWR VGND sg13g2_mux2_1
X_19405_ _19405_/Y _20063_/A _19423_/B VPWR VGND sg13g2_nor2_1
XFILLER_75_1922 VPWR VGND sg13g2_decap_4
X_16617_ _16617_/Y _16626_/A _16617_/B VPWR VGND sg13g2_nor2_1
X_13829_ _13831_/A _13925_/A1 _13826_/Y _13828_/Y VPWR VGND sg13g2_a21o_1
X_17597_ _17597_/Y _17597_/A _17597_/B VPWR VGND sg13g2_nand2_1
XFILLER_51_838 VPWR VGND sg13g2_decap_8
XFILLER_51_849 VPWR VGND sg13g2_fill_2
XFILLER_108_1422 VPWR VGND sg13g2_fill_1
X_19336_ _19336_/X _19330_/Y _19335_/Y _19573_/S VPWR VGND sg13g2_mux2_1
X_16548_ _22624_/D _17316_/A1 _16547_/A _16547_/Y VPWR VGND sg13g2_a21oi_1
XFILLER_108_1444 VPWR VGND sg13g2_decap_4
X_19267_ _19276_/B _11222_/B _19263_/Y _19245_/Y VPWR VGND sg13g2_o21ai_1
XFILLER_31_573 VPWR VGND sg13g2_decap_4
Xoutput4501 data_be_o[3] _14640_/Y VPWR VGND sg13g2_buf_1
XFILLER_31_584 VPWR VGND sg13g2_decap_8
X_16479_ _22602_/D _17476_/A1 _16514_/B _16478_/Y VPWR VGND sg13g2_o21ai_1
Xoutput4512 data_wdata_o[18] _14726_/X VPWR VGND sg13g2_buf_1
Xoutput4523 data_wdata_o[28] _14736_/X VPWR VGND sg13g2_buf_1
X_18218_ _18219_/D _18539_/A _18217_/Y _18115_/Y VPWR VGND sg13g2_o21ai_1
XFILLER_34_1663 VPWR VGND sg13g2_fill_1
XFILLER_79_0 VPWR VGND sg13g2_decap_8
Xoutput4534 data_wdata_o[9] _14693_/X VPWR VGND sg13g2_buf_1
XFILLER_15_1062 VPWR VGND sg13g2_decap_8
Xoutput4545 instr_addr_o[19] _15004_/Y VPWR VGND sg13g2_buf_1
XFILLER_34_1685 VPWR VGND sg13g2_decap_8
X_19198_ _23157_/D _23157_/Q _19200_/S _19197_/Y VPWR VGND sg13g2_a21o_1
Xoutput4556 instr_addr_o[2] _14805_/Y VPWR VGND sg13g2_buf_1
XFILLER_102_1032 VPWR VGND sg13g2_fill_2
XFILLER_69_1737 VPWR VGND sg13g2_decap_4
XFILLER_102_1065 VPWR VGND sg13g2_fill_1
XFILLER_85_1005 VPWR VGND sg13g2_fill_1
XFILLER_105_807 VPWR VGND sg13g2_decap_4
X_21160_ _21160_/Y _21160_/A _21215_/B VPWR VGND sg13g2_nand2_1
XFILLER_82_1915 VPWR VGND sg13g2_decap_4
X_20111_ _20111_/Y _20110_/X _20317_/B VPWR VGND sg13g2_nand2b_1
XFILLER_82_1926 VPWR VGND sg13g2_fill_2
XFILLER_113_862 VPWR VGND sg13g2_decap_8
XFILLER_86_702 VPWR VGND sg13g2_decap_4
XFILLER_28_1456 VPWR VGND sg13g2_decap_8
X_20042_ _20043_/B _20062_/B _20032_/Y _20041_/Y VPWR VGND sg13g2_a21oi_1
XFILLER_24_1309 VPWR VGND sg13g2_fill_2
XFILLER_58_404 VPWR VGND sg13g2_decap_8
XFILLER_105_14 VPWR VGND sg13g2_decap_8
XFILLER_63_1358 VPWR VGND sg13g2_decap_8
XFILLER_86_735 VPWR VGND sg13g2_decap_8
XFILLER_115_1448 VPWR VGND sg13g2_decap_8
XFILLER_6_1230 VPWR VGND sg13g2_decap_8
XFILLER_100_567 VPWR VGND sg13g2_decap_8
XFILLER_73_407 VPWR VGND sg13g2_fill_2
X_23801_ _23801_/Q _23966_/CLK _23801_/D fanout2783/X VPWR VGND sg13g2_dfrbpq_1
XFILLER_22_1033 VPWR VGND sg13g2_fill_2
X_21993_ _21993_/Y _21993_/A _22001_/B VPWR VGND sg13g2_nand2_1
XFILLER_6_1285 VPWR VGND sg13g2_decap_8
XFILLER_39_695 VPWR VGND sg13g2_decap_8
XFILLER_27_846 VPWR VGND sg13g2_decap_8
XFILLER_38_183 VPWR VGND sg13g2_fill_2
X_23732_ _23732_/Q clkload29/A _23732_/D fanout2669/X VPWR VGND sg13g2_dfrbpq_1
X_20944_ _23517_/D _21312_/A1 _20945_/B _20943_/Y VPWR VGND sg13g2_o21ai_1
XFILLER_26_334 VPWR VGND sg13g2_fill_1
XFILLER_57_1129 VPWR VGND sg13g2_fill_2
X_23663_ _23663_/Q clkload51/A _23663_/D fanout2665/X VPWR VGND sg13g2_dfrbpq_1
X_20875_ _23484_/D _21309_/A1 _20874_/B _20874_/Y VPWR VGND sg13g2_o21ai_1
XFILLER_81_495 VPWR VGND sg13g2_decap_8
XFILLER_35_890 VPWR VGND sg13g2_fill_2
X_22614_ _22614_/Q clkload8/A _22614_/D fanout2798/X VPWR VGND sg13g2_dfrbpq_1
X_23594_ _23594_/Q clkload41/A _23594_/D fanout2729/X VPWR VGND sg13g2_dfrbpq_1
XFILLER_35_1449 VPWR VGND sg13g2_decap_8
X_22545_ _22545_/Q clkload27/A _22545_/D fanout2894/X VPWR VGND sg13g2_dfrbpq_1
XFILLER_17_1850 VPWR VGND sg13g2_decap_8
XFILLER_13_1714 VPWR VGND sg13g2_fill_1
X_22476_ _22476_/Q clkload8/A _22476_/D fanout2806/X VPWR VGND sg13g2_dfrbpq_1
XFILLER_108_601 VPWR VGND sg13g2_decap_8
XFILLER_52_1796 VPWR VGND sg13g2_decap_8
XFILLER_100_1706 VPWR VGND sg13g2_fill_2
X_24215_ _24215_/Q clkload15/A _24215_/D fanout2853/X VPWR VGND sg13g2_dfrbpq_1
XFILLER_107_133 VPWR VGND sg13g2_decap_8
Xclkbuf_leaf_21_clk_i clkload31/A clkload1/A VPWR VGND sg13g2_buf_16
XFILLER_108_678 VPWR VGND sg13g2_fill_2
X_24146_ _24146_/Q clkload16/A _24146_/D fanout2622/X VPWR VGND sg13g2_dfrbpq_1
Xfanout2904 fanout2904/X fanout2905/X VPWR VGND sg13g2_buf_1
X_20309_ _20309_/Y _20309_/A _20309_/B _20309_/C _20309_/D VPWR VGND sg13g2_nor4_1
X_12091_ _12092_/B _12091_/A _12091_/B _12091_/C _12091_/D VPWR VGND sg13g2_and4_1
X_24077_ _24077_/Q _24205_/CLK _24077_/D fanout2649/X VPWR VGND sg13g2_dfrbpq_1
Xfanout2915 fanout2915/X fanout2916/X VPWR VGND sg13g2_buf_1
XFILLER_81_1414 VPWR VGND sg13g2_decap_8
Xfanout2926 fanout2926/X fanout2927/X VPWR VGND sg13g2_buf_1
X_21289_ _21332_/B _21918_/D _22252_/A _21289_/C VPWR VGND sg13g2_nand3_1
XFILLER_104_862 VPWR VGND sg13g2_fill_1
XFILLER_2_989 VPWR VGND sg13g2_decap_8
X_23028_ _23028_/Q clkload11/A _23028_/D fanout2837/X VPWR VGND sg13g2_dfrbpq_1
XFILLER_7_1016 VPWR VGND sg13g2_decap_4
XFILLER_39_41 VPWR VGND sg13g2_decap_8
Xclkbuf_leaf_36_clk_i clkload54/A clkbuf_leaf_42_clk_i/A VPWR VGND sg13g2_buf_16
XFILLER_46_1589 VPWR VGND sg13g2_fill_2
X_15850_ _15850_/Y _22572_/Q _15956_/B VPWR VGND sg13g2_nand2_1
XFILLER_49_448 VPWR VGND sg13g2_decap_4
XFILLER_24_1843 VPWR VGND sg13g2_decap_4
XFILLER_44_1280 VPWR VGND sg13g2_decap_4
X_14801_ _16240_/A _14801_/A _14801_/B VPWR VGND sg13g2_nand2_1
XFILLER_64_407 VPWR VGND sg13g2_decap_8
XFILLER_58_982 VPWR VGND sg13g2_decap_8
XFILLER_64_418 VPWR VGND sg13g2_fill_2
X_15781_ _16152_/A _15779_/Y _15889_/S _15780_/Y VPWR VGND sg13g2_o21ai_1
XFILLER_29_150 VPWR VGND sg13g2_decap_8
XFILLER_45_621 VPWR VGND sg13g2_decap_8
XFILLER_111_1857 VPWR VGND sg13g2_decap_8
XFILLER_17_323 VPWR VGND sg13g2_fill_2
X_17520_ _22874_/D _17515_/Y _17629_/B _17518_/X _17519_/Y VPWR VGND sg13g2_a22oi_1
XFILLER_73_941 VPWR VGND sg13g2_decap_8
X_14732_ _14732_/X _14687_/Y _14685_/X _14732_/S VPWR VGND sg13g2_mux2_1
X_11944_ _11945_/B _23578_/Q _23610_/Q _23642_/Q _23674_/Q _11477_/A _11706_/S VPWR
+ VGND sg13g2_mux4_1
XFILLER_18_868 VPWR VGND sg13g2_decap_4
XFILLER_17_356 VPWR VGND sg13g2_decap_8
XFILLER_33_805 VPWR VGND sg13g2_fill_2
XFILLER_72_451 VPWR VGND sg13g2_fill_1
XFILLER_33_816 VPWR VGND sg13g2_fill_2
XFILLER_45_676 VPWR VGND sg13g2_decap_8
X_17451_ _17451_/Y _17451_/A _17453_/B VPWR VGND sg13g2_nand2_1
X_11875_ _11877_/A _11993_/A _11875_/B VPWR VGND sg13g2_nand2_1
X_14663_ _14663_/Y _14701_/A _14701_/B _14662_/Y VPWR VGND sg13g2_o21ai_1
XFILLER_2_1694 VPWR VGND sg13g2_decap_8
XFILLER_44_175 VPWR VGND sg13g2_decap_4
XFILLER_32_326 VPWR VGND sg13g2_fill_1
X_16402_ _22569_/D _23019_/Q _22569_/Q _16421_/S VPWR VGND sg13g2_mux2_1
X_13614_ _13614_/X _23439_/Q _23471_/Q _23503_/Q _23535_/Q _13614_/S0 _13614_/S1 VPWR
+ VGND sg13g2_mux4_1
X_17382_ _17382_/Y _17382_/A _17382_/B VPWR VGND sg13g2_nand2_1
XFILLER_57_1674 VPWR VGND sg13g2_decap_8
X_14594_ _14637_/B _14594_/A _19235_/C VPWR VGND sg13g2_nor2_1
X_19121_ _23099_/D _23099_/Q _19121_/A1 _19124_/S VPWR VGND sg13g2_mux2_1
XFILLER_9_511 VPWR VGND sg13g2_decap_8
X_16333_ _22543_/D _16333_/A _16333_/B VPWR VGND sg13g2_xor2_1
X_13545_ _13546_/B _20245_/B _13545_/B VPWR VGND sg13g2_nand2_1
XFILLER_35_1950 VPWR VGND sg13g2_decap_4
XFILLER_40_370 VPWR VGND sg13g2_decap_8
XFILLER_71_72 VPWR VGND sg13g2_decap_8
Xplace3809 _15982_/S _15442_/S VPWR VGND sg13g2_buf_1
XFILLER_31_1803 VPWR VGND sg13g2_decap_4
X_19052_ _19052_/X _18024_/B _23095_/Q _19054_/S VPWR VGND sg13g2_mux2_1
X_13476_ _13476_/X _13607_/A _13476_/B VPWR VGND sg13g2_or2_1
XFILLER_16_1371 VPWR VGND sg13g2_fill_1
X_16264_ _22524_/D _16320_/A _16321_/A VPWR VGND sg13g2_xnor2_1
XFILLER_16_1382 VPWR VGND sg13g2_decap_8
X_18003_ _18425_/B _18560_/S _17986_/X _17989_/Y VPWR VGND sg13g2_a21oi_1
X_15215_ _19612_/A _15215_/A _15215_/B VPWR VGND sg13g2_or2_1
X_12427_ _12436_/A _19428_/A _12425_/Y _12426_/Y VPWR VGND sg13g2_o21ai_1
XFILLER_12_1235 VPWR VGND sg13g2_decap_8
X_16195_ _16197_/A _16195_/A _15978_/B VPWR VGND sg13g2_nor2b_1
XFILLER_86_1325 VPWR VGND sg13g2_fill_2
XFILLER_86_1336 VPWR VGND sg13g2_decap_4
XFILLER_99_304 VPWR VGND sg13g2_fill_2
X_12358_ _12358_/Y _23903_/Q _12889_/C _12357_/X _11465_/A VPWR VGND sg13g2_a22oi_1
XFILLER_99_315 VPWR VGND sg13g2_decap_8
XFILLER_114_648 VPWR VGND sg13g2_decap_8
X_11309_ _11309_/Y _22967_/Q _14120_/B _14121_/B VPWR VGND sg13g2_a21oi_1
X_19954_ _19965_/A _12535_/B _19835_/Y _19837_/Y _19953_/Y VPWR VGND sg13g2_a22oi_1
X_15077_ _15077_/Y _15077_/A _15077_/B VPWR VGND sg13g2_nand2_1
X_12289_ _12289_/Y _12287_/X _12643_/B VPWR VGND sg13g2_nand2b_1
XFILLER_113_147 VPWR VGND sg13g2_decap_8
XFILLER_9_1815 VPWR VGND sg13g2_decap_8
XFILLER_101_309 VPWR VGND sg13g2_decap_8
X_14028_ _14029_/C _14028_/A _14028_/B VPWR VGND sg13g2_xnor2_1
X_18905_ _18905_/Y _23048_/Q _18953_/A _18580_/X VPWR VGND sg13g2_o21ai_1
X_19885_ _19885_/Y _19881_/Y _19882_/Y _19884_/X VPWR VGND sg13g2_o21ai_1
XFILLER_110_843 VPWR VGND sg13g2_decap_8
X_18836_ _18838_/B _18834_/Y _18835_/Y _18857_/S VPWR VGND sg13g2_mux2_1
XFILLER_7_1550 VPWR VGND sg13g2_fill_1
XFILLER_67_245 VPWR VGND sg13g2_decap_8
XFILLER_95_587 VPWR VGND sg13g2_decap_8
XFILLER_67_278 VPWR VGND sg13g2_decap_8
XFILLER_3_1425 VPWR VGND sg13g2_fill_1
XFILLER_82_215 VPWR VGND sg13g2_decap_8
XFILLER_3_1436 VPWR VGND sg13g2_fill_1
XFILLER_36_632 VPWR VGND sg13g2_fill_2
X_17718_ _17718_/Y _23173_/Q _17734_/A2 _17706_/X _17718_/B2 VPWR VGND sg13g2_a22oi_1
XFILLER_64_952 VPWR VGND sg13g2_decap_8
XFILLER_110_1356 VPWR VGND sg13g2_fill_1
XFILLER_82_259 VPWR VGND sg13g2_decap_8
X_18698_ _18698_/Y _23018_/Q _18698_/B VPWR VGND sg13g2_xnor2_1
XFILLER_24_827 VPWR VGND sg13g2_fill_2
X_17649_ _17649_/Y _23166_/Q _17621_/B _17706_/B _17648_/Y VPWR VGND sg13g2_a22oi_1
XFILLER_90_270 VPWR VGND sg13g2_decap_8
XFILLER_51_646 VPWR VGND sg13g2_decap_8
X_20660_ _20660_/Y _20660_/A _20666_/B VPWR VGND sg13g2_nand2_1
XFILLER_17_1124 VPWR VGND sg13g2_decap_8
XFILLER_52_1015 VPWR VGND sg13g2_fill_1
XFILLER_71_1638 VPWR VGND sg13g2_fill_2
XFILLER_52_1026 VPWR VGND sg13g2_decap_4
XFILLER_108_1263 VPWR VGND sg13g2_decap_4
X_20591_ _23350_/D _20929_/A1 _20600_/B _20590_/Y VPWR VGND sg13g2_o21ai_1
XFILLER_52_1037 VPWR VGND sg13g2_fill_2
XFILLER_109_409 VPWR VGND sg13g2_decap_4
XFILLER_31_392 VPWR VGND sg13g2_fill_2
XFILLER_104_1138 VPWR VGND sg13g2_decap_8
X_22261_ _22261_/Y _24119_/Q _22269_/B VPWR VGND sg13g2_nand2_1
XFILLER_3_709 VPWR VGND sg13g2_decap_8
XFILLER_30_1368 VPWR VGND sg13g2_decap_4
X_24000_ _24000_/Q _24131_/CLK _24000_/D fanout2749/X VPWR VGND sg13g2_dfrbpq_1
X_21212_ _21212_/Y _23630_/Q _21221_/B VPWR VGND sg13g2_nand2_1
X_22192_ _24085_/D _22258_/A1 _22203_/B _22191_/Y VPWR VGND sg13g2_o21ai_1
XFILLER_2_219 VPWR VGND sg13g2_fill_1
X_21143_ _23596_/D _21342_/A1 _21154_/B _21142_/Y VPWR VGND sg13g2_o21ai_1
XFILLER_104_136 VPWR VGND sg13g2_decap_8
XFILLER_82_1712 VPWR VGND sg13g2_decap_8
XFILLER_76_28 VPWR VGND sg13g2_fill_2
XFILLER_115_1234 VPWR VGND sg13g2_decap_8
X_20025_ _20025_/Y _20025_/A _20052_/B VPWR VGND sg13g2_nand2_1
XFILLER_59_768 VPWR VGND sg13g2_decap_4
XFILLER_41_1420 VPWR VGND sg13g2_decap_4
XFILLER_74_705 VPWR VGND sg13g2_decap_4
XFILLER_74_727 VPWR VGND sg13g2_fill_1
XFILLER_41_1453 VPWR VGND sg13g2_fill_1
XFILLER_73_204 VPWR VGND sg13g2_fill_2
XFILLER_39_470 VPWR VGND sg13g2_decap_8
XFILLER_100_397 VPWR VGND sg13g2_decap_4
XFILLER_67_790 VPWR VGND sg13g2_decap_4
XFILLER_41_1486 VPWR VGND sg13g2_fill_2
X_21976_ _21976_/Y _21976_/A _21976_/B VPWR VGND sg13g2_nand2_1
XFILLER_92_38 VPWR VGND sg13g2_decap_4
XFILLER_15_805 VPWR VGND sg13g2_decap_8
XFILLER_54_440 VPWR VGND sg13g2_fill_1
XFILLER_27_676 VPWR VGND sg13g2_fill_1
X_20927_ _23509_/D _20927_/A1 _20930_/B _20926_/Y VPWR VGND sg13g2_o21ai_1
XFILLER_25_21 VPWR VGND sg13g2_decap_8
X_23715_ _23715_/Q clkload39/A _23715_/D fanout2735/X VPWR VGND sg13g2_dfrbpq_1
XFILLER_76_1549 VPWR VGND sg13g2_fill_1
XFILLER_93_1830 VPWR VGND sg13g2_decap_8
XFILLER_41_101 VPWR VGND sg13g2_decap_8
XFILLER_19_1912 VPWR VGND sg13g2_decap_8
XFILLER_54_495 VPWR VGND sg13g2_decap_8
XFILLER_109_1038 VPWR VGND sg13g2_fill_1
X_11660_ _24247_/A _14028_/A _11660_/B VPWR VGND sg13g2_xnor2_1
X_23646_ _23646_/Q clkload55/A _23646_/D fanout2777/X VPWR VGND sg13g2_dfrbpq_1
XFILLER_70_999 VPWR VGND sg13g2_decap_8
XFILLER_23_871 VPWR VGND sg13g2_decap_8
XFILLER_54_1847 VPWR VGND sg13g2_decap_8
XFILLER_70_1104 VPWR VGND sg13g2_decap_4
XFILLER_74_1273 VPWR VGND sg13g2_decap_8
XFILLER_41_178 VPWR VGND sg13g2_decap_8
XFILLER_106_1937 VPWR VGND sg13g2_decap_8
X_23577_ _23577_/Q clkload59/A _23577_/D fanout2787/X VPWR VGND sg13g2_dfrbpq_1
XFILLER_22_370 VPWR VGND sg13g2_fill_2
X_13330_ _13330_/X _24043_/Q _24075_/Q _24107_/Q _24139_/Q _13707_/S0 _13707_/S1 VPWR
+ VGND sg13g2_mux4_1
X_22528_ _22528_/Q clkload6/A _22528_/D fanout2804/X VPWR VGND sg13g2_dfrbpq_1
XFILLER_17_1680 VPWR VGND sg13g2_decap_4
XFILLER_10_554 VPWR VGND sg13g2_decap_4
XFILLER_87_1601 VPWR VGND sg13g2_decap_8
X_13261_ _13267_/B _11953_/A _13258_/Y _13260_/Y _11954_/Y VPWR VGND sg13g2_a22oi_1
X_22459_ _22459_/Q clkload18/A _22459_/D fanout2829/X VPWR VGND sg13g2_dfrbpq_1
XFILLER_13_1566 VPWR VGND sg13g2_decap_8
X_12212_ _12213_/B _23453_/Q _23517_/Q _12216_/S VPWR VGND sg13g2_mux2_1
X_15000_ _15000_/Y _17893_/A1 _15029_/B _18679_/A2 _15000_/B2 _14999_/Y VPWR VGND
+ sg13g2_a221oi_1
X_13192_ _13216_/A _12119_/A _13189_/Y _13191_/Y VPWR VGND sg13g2_a21oi_1
X_12143_ _12148_/B _13210_/A _12143_/B VPWR VGND sg13g2_nor2_1
XFILLER_2_720 VPWR VGND sg13g2_fill_2
X_24129_ _24129_/Q clkload45/A _24129_/D fanout2733/X VPWR VGND sg13g2_dfrbpq_1
Xfanout2701 fanout2701/X fanout2705/X VPWR VGND sg13g2_buf_1
XFILLER_9_0 VPWR VGND sg13g2_decap_8
XFILLER_29_1039 VPWR VGND sg13g2_decap_8
Xfanout2712 fanout2712/X fanout2743/X VPWR VGND sg13g2_buf_1
XFILLER_65_1932 VPWR VGND sg13g2_decap_8
XFILLER_81_1200 VPWR VGND sg13g2_fill_2
XFILLER_46_1320 VPWR VGND sg13g2_decap_8
XFILLER_96_307 VPWR VGND sg13g2_decap_8
Xfanout2723 fanout2723/X fanout2724/X VPWR VGND sg13g2_buf_1
XFILLER_111_618 VPWR VGND sg13g2_decap_8
Xfanout2734 fanout2734/X fanout2742/X VPWR VGND sg13g2_buf_1
X_12074_ _12075_/D _12088_/A _14304_/C VPWR VGND sg13g2_nor2b_1
Xfanout2745 fanout2745/X fanout2746/X VPWR VGND sg13g2_buf_1
Xfanout2756 fanout2756/X fanout2759/X VPWR VGND sg13g2_buf_1
XFILLER_26_1927 VPWR VGND sg13g2_fill_1
Xfanout2767 fanout2767/X fanout2768/X VPWR VGND sg13g2_buf_1
XFILLER_81_1255 VPWR VGND sg13g2_fill_1
XFILLER_2_14 VPWR VGND sg13g2_decap_8
XFILLER_89_392 VPWR VGND sg13g2_fill_1
Xfanout2778 fanout2778/X fanout2779/X VPWR VGND sg13g2_buf_1
X_15902_ _15902_/Y _15947_/A1 _15901_/Y _15947_/B1 VPWR VGND sg13g2_o21ai_1
Xfanout2789 fanout2789/X fanout2790/X VPWR VGND sg13g2_buf_1
X_19670_ _19671_/B _19673_/B _20162_/A _19669_/Y VPWR VGND sg13g2_a21oi_1
XFILLER_103_191 VPWR VGND sg13g2_fill_1
XFILLER_8_1881 VPWR VGND sg13g2_decap_8
XFILLER_49_256 VPWR VGND sg13g2_decap_8
XFILLER_24_1651 VPWR VGND sg13g2_decap_4
X_18621_ _23002_/D _18619_/A _18618_/Y _18620_/Y VPWR VGND sg13g2_a21oi_1
X_15833_ _15837_/C _22474_/Q _15900_/A2 _15992_/B1 _22805_/Q VPWR VGND sg13g2_a22oi_1
XFILLER_66_50 VPWR VGND sg13g2_decap_8
XFILLER_98_1752 VPWR VGND sg13g2_decap_4
XFILLER_92_546 VPWR VGND sg13g2_decap_8
XFILLER_4_1767 VPWR VGND sg13g2_decap_8
XFILLER_20_1526 VPWR VGND sg13g2_decap_4
XFILLER_59_1703 VPWR VGND sg13g2_fill_2
X_18552_ _18555_/A _18465_/B _18550_/Y _18551_/Y VPWR VGND sg13g2_a21oi_1
XFILLER_94_1605 VPWR VGND sg13g2_decap_8
X_15764_ _15773_/C _22802_/Q _15284_/Y _15346_/A _16776_/C _15986_/C1 VPWR VGND sg13g2_a221oi_1
X_12976_ _12989_/A _14134_/D _12976_/B VPWR VGND sg13g2_nor2_1
XFILLER_59_1725 VPWR VGND sg13g2_fill_1
XFILLER_17_153 VPWR VGND sg13g2_decap_4
X_17503_ _17503_/Y _17503_/A _17503_/B VPWR VGND sg13g2_nand2_1
XFILLER_73_771 VPWR VGND sg13g2_fill_2
X_14715_ _14715_/Y _14715_/A _14715_/B VPWR VGND sg13g2_nor2_1
XFILLER_75_1015 VPWR VGND sg13g2_decap_8
X_11927_ _11927_/Y _11355_/A _11922_/X _11926_/X _11363_/B VPWR VGND sg13g2_a22oi_1
X_18483_ _18483_/Y _18531_/A _18483_/B _18483_/C VPWR VGND sg13g2_nand3_1
XFILLER_75_1026 VPWR VGND sg13g2_fill_1
X_15695_ _22467_/D _16126_/A _15694_/X _15695_/S VPWR VGND sg13g2_mux2_1
XFILLER_60_421 VPWR VGND sg13g2_decap_8
XFILLER_61_955 VPWR VGND sg13g2_fill_1
X_17434_ _22837_/D _17517_/C _17437_/B _17433_/Y VPWR VGND sg13g2_o21ai_1
XFILLER_75_1059 VPWR VGND sg13g2_decap_4
XFILLER_82_71 VPWR VGND sg13g2_decap_8
X_14646_ _14646_/Y _11528_/B _14720_/B _14645_/Y VPWR VGND sg13g2_o21ai_1
XFILLER_61_977 VPWR VGND sg13g2_fill_1
X_11858_ _11858_/Y _11835_/Y _11838_/Y _11845_/Y _11848_/Y _11857_/Y VPWR VGND sg13g2_a221oi_1
XFILLER_82_82 VPWR VGND sg13g2_fill_2
XFILLER_72_1925 VPWR VGND sg13g2_decap_8
XFILLER_14_860 VPWR VGND sg13g2_fill_2
Xplace4307 _13039_/S _12819_/S0 VPWR VGND sg13g2_buf_8
X_17365_ _22809_/D _17917_/A _17367_/B _17364_/Y VPWR VGND sg13g2_o21ai_1
XFILLER_33_1909 VPWR VGND sg13g2_decap_8
Xplace4318 _11836_/B _12453_/S VPWR VGND sg13g2_buf_1
XFILLER_18_1466 VPWR VGND sg13g2_decap_4
X_14577_ _14579_/B _24219_/D _17044_/B VPWR VGND sg13g2_nor2_1
X_11789_ _11794_/B _13210_/A _11789_/B VPWR VGND sg13g2_nor2_1
Xplace4329 _11768_/S0 _11924_/S0 VPWR VGND sg13g2_buf_1
Xrebuffer5308 _12593_/A _13579_/A VPWR VGND sg13g2_buf_2
Xrebuffer5319 _12855_/A1 _12536_/Y VPWR VGND sg13g2_buf_1
X_19104_ _19104_/X _18984_/A _23120_/Q _19114_/S VPWR VGND sg13g2_mux2_1
Xplace3606 _15068_/A _16304_/A VPWR VGND sg13g2_buf_1
X_16316_ _22537_/D _16316_/A _16318_/B VPWR VGND sg13g2_nor2b_1
Xplace3617 _16233_/B _14244_/Y VPWR VGND sg13g2_buf_1
X_13528_ _13530_/B _13528_/A _13528_/B _13528_/C VPWR VGND sg13g2_and3_1
XFILLER_105_1458 VPWR VGND sg13g2_fill_1
X_17296_ _22777_/D _17917_/A _17302_/S _17295_/Y VPWR VGND sg13g2_o21ai_1
Xrebuffer4607 _24270_/A _15058_/A1 VPWR VGND sg13g2_buf_1
Xplace3628 _15898_/B1 _15901_/B1 VPWR VGND sg13g2_buf_1
Xplace3639 _14879_/A _14956_/C VPWR VGND sg13g2_buf_1
Xrebuffer4618 _19983_/B _12829_/C VPWR VGND sg13g2_buf_1
X_19035_ _19035_/Y _19043_/A _19035_/B _19035_/C VPWR VGND sg13g2_nand3b_1
Xrebuffer4629 _14427_/B _13936_/A VPWR VGND sg13g2_buf_1
X_16247_ _22519_/D _16250_/B _16248_/B VPWR VGND sg13g2_xor2_1
X_13459_ _13459_/X _23469_/Q _23533_/Q _23629_/Q _23693_/Q _13643_/S _13639_/S1 VPWR
+ VGND sg13g2_mux4_1
Xhold5009 _21706_/A _23864_/Q VPWR VGND sg13g2_dlygate4sd3_1
XFILLER_12_1043 VPWR VGND sg13g2_decap_4
Xplace2938 _19099_/S _19086_/S VPWR VGND sg13g2_buf_1
Xplace2949 _18689_/A _18757_/A VPWR VGND sg13g2_buf_1
XFILLER_115_924 VPWR VGND sg13g2_fill_1
X_16178_ _22506_/D _16145_/B _16176_/Y _16177_/Y VPWR VGND sg13g2_o21ai_1
XFILLER_115_935 VPWR VGND sg13g2_decap_8
X_15129_ _15129_/Y _18567_/B _15128_/Y VPWR VGND sg13g2_nor2b_1
XFILLER_114_445 VPWR VGND sg13g2_decap_8
XFILLER_87_318 VPWR VGND sg13g2_fill_1
XFILLER_9_1623 VPWR VGND sg13g2_fill_2
XFILLER_99_189 VPWR VGND sg13g2_fill_1
X_19937_ _19937_/Y _20060_/A _19935_/Y _19936_/Y VPWR VGND sg13g2_o21ai_1
XFILLER_101_117 VPWR VGND sg13g2_decap_8
XFILLER_9_1645 VPWR VGND sg13g2_decap_8
XFILLER_68_510 VPWR VGND sg13g2_decap_8
X_19868_ _20080_/B _19872_/A _19695_/Y _19867_/Y VPWR VGND sg13g2_o21ai_1
XFILLER_96_874 VPWR VGND sg13g2_decap_8
XFILLER_110_662 VPWR VGND sg13g2_decap_8
XFILLER_83_513 VPWR VGND sg13g2_fill_1
XFILLER_3_1200 VPWR VGND sg13g2_fill_1
X_18819_ _18820_/C _23069_/Q _18825_/B VPWR VGND sg13g2_nand2_1
XFILLER_56_738 VPWR VGND sg13g2_decap_8
XFILLER_68_598 VPWR VGND sg13g2_fill_1
X_19799_ _19799_/Y _19824_/A _19637_/Y _19541_/A VPWR VGND sg13g2_a21oi_1
XFILLER_55_215 VPWR VGND sg13g2_decap_4
XFILLER_52_900 VPWR VGND sg13g2_decap_4
XFILLER_3_1277 VPWR VGND sg13g2_decap_4
XFILLER_36_462 VPWR VGND sg13g2_decap_8
XFILLER_64_771 VPWR VGND sg13g2_decap_4
X_21761_ _21761_/Y _23882_/Q _21771_/B VPWR VGND sg13g2_nand2_1
XFILLER_36_484 VPWR VGND sg13g2_decap_8
XFILLER_63_270 VPWR VGND sg13g2_decap_8
XFILLER_64_793 VPWR VGND sg13g2_decap_8
XFILLER_93_1137 VPWR VGND sg13g2_decap_8
X_20712_ _23411_/D _22315_/A0 _23411_/Q _20712_/S VPWR VGND sg13g2_mux2_1
X_23500_ _23500_/Q _24170_/CLK _23500_/D fanout2640/X VPWR VGND sg13g2_dfrbpq_1
XFILLER_52_977 VPWR VGND sg13g2_decap_8
XFILLER_24_679 VPWR VGND sg13g2_decap_8
XFILLER_36_1522 VPWR VGND sg13g2_decap_8
XFILLER_71_1402 VPWR VGND sg13g2_decap_8
XFILLER_71_1413 VPWR VGND sg13g2_fill_1
X_23431_ _23431_/Q _24196_/CLK _23431_/D fanout2698/X VPWR VGND sg13g2_dfrbpq_1
X_20643_ _23377_/D _22246_/A0 _23377_/Q _20646_/S VPWR VGND sg13g2_mux2_1
XFILLER_20_852 VPWR VGND sg13g2_decap_8
X_23362_ _23362_/Q _23682_/CLK _23362_/D fanout2720/X VPWR VGND sg13g2_dfrbpq_1
XFILLER_108_1093 VPWR VGND sg13g2_decap_8
X_20574_ _23343_/D _23343_/Q _22177_/A1 _20580_/S VPWR VGND sg13g2_mux2_1
XFILLER_109_217 VPWR VGND sg13g2_decap_8
X_22313_ _22313_/Y _22313_/A _22316_/B VPWR VGND sg13g2_nand2_1
XFILLER_30_1121 VPWR VGND sg13g2_fill_2
XFILLER_30_1132 VPWR VGND sg13g2_decap_4
X_23293_ _23293_/Q clkload55/A _23293_/D fanout2774/X VPWR VGND sg13g2_dfrbpq_1
XFILLER_14_1886 VPWR VGND sg13g2_decap_8
XFILLER_101_1845 VPWR VGND sg13g2_decap_8
X_22244_ _22244_/Y _22244_/A _22250_/B VPWR VGND sg13g2_nand2_1
Xhold4820 _21552_/A _23794_/Q VPWR VGND sg13g2_dlygate4sd3_1
Xhold4831 _20205_/A _23242_/Q VPWR VGND sg13g2_dlygate4sd3_1
X_22175_ _22175_/Y _22175_/A _22175_/B VPWR VGND sg13g2_nand2_1
XFILLER_2_7 VPWR VGND sg13g2_decap_8
Xhold4842 _21115_/A _23583_/Q VPWR VGND sg13g2_dlygate4sd3_1
Xhold4853 _22080_/A _24032_/Q VPWR VGND sg13g2_dlygate4sd3_1
Xhold4864 _21534_/A _23783_/Q VPWR VGND sg13g2_dlygate4sd3_1
X_21126_ _21126_/Y _23588_/Q _21138_/B VPWR VGND sg13g2_nand2_1
Xhold4875 _20896_/A _23494_/Q VPWR VGND sg13g2_dlygate4sd3_1
Xhold4886 _19791_/A _23225_/Q VPWR VGND sg13g2_dlygate4sd3_1
Xhold4897 _21716_/A _23867_/Q VPWR VGND sg13g2_dlygate4sd3_1
XFILLER_99_690 VPWR VGND sg13g2_decap_8
X_20008_ _20016_/B _19769_/A _20003_/Y _20007_/Y _20295_/A1 VPWR VGND sg13g2_a22oi_1
XFILLER_86_362 VPWR VGND sg13g2_fill_1
XFILLER_47_749 VPWR VGND sg13g2_decap_8
XFILLER_112_1952 VPWR VGND sg13g2_fill_2
XFILLER_95_1903 VPWR VGND sg13g2_fill_2
XFILLER_60_1895 VPWR VGND sg13g2_decap_8
X_12830_ _12830_/Y _12638_/C _12630_/Y _12762_/Y _12829_/X VPWR VGND sg13g2_a22oi_1
XFILLER_28_974 VPWR VGND sg13g2_decap_4
XFILLER_43_900 VPWR VGND sg13g2_decap_4
XFILLER_27_451 VPWR VGND sg13g2_decap_8
XFILLER_61_207 VPWR VGND sg13g2_decap_8
XFILLER_61_218 VPWR VGND sg13g2_fill_1
XFILLER_14_101 VPWR VGND sg13g2_fill_2
XFILLER_27_484 VPWR VGND sg13g2_decap_4
X_12761_ _14056_/B _12761_/A _12761_/B _12761_/C VPWR VGND sg13g2_nand3_1
X_21959_ _21959_/Y _21959_/A _21961_/B VPWR VGND sg13g2_nand2_1
XFILLER_36_86 VPWR VGND sg13g2_fill_2
X_14500_ _14502_/A _22586_/Q VPWR VGND sg13g2_inv_1
XFILLER_15_657 VPWR VGND sg13g2_fill_1
X_11712_ _14439_/A _22984_/Q _11712_/B VPWR VGND sg13g2_nand2_1
X_12692_ _12692_/Y _12692_/A _12692_/B _12692_/C _12692_/D VPWR VGND sg13g2_nand4_1
X_15480_ _15481_/D _22847_/Q _17439_/A _16161_/A _22489_/Q VPWR VGND sg13g2_a22oi_1
XFILLER_43_988 VPWR VGND sg13g2_fill_1
XFILLER_93_1671 VPWR VGND sg13g2_fill_2
XFILLER_14_156 VPWR VGND sg13g2_fill_2
XFILLER_35_1021 VPWR VGND sg13g2_decap_8
X_14431_ _14431_/Y _14431_/A _17039_/B VPWR VGND sg13g2_nor2_1
X_23629_ _23629_/Q clkload30/A _23629_/D fanout2659/X VPWR VGND sg13g2_dfrbpq_1
XFILLER_42_498 VPWR VGND sg13g2_decap_8
XFILLER_19_1775 VPWR VGND sg13g2_decap_4
XFILLER_15_1628 VPWR VGND sg13g2_decap_4
X_17150_ _17156_/D _22733_/Q _17160_/D VPWR VGND sg13g2_nand2_1
XFILLER_15_1639 VPWR VGND sg13g2_decap_8
X_14362_ _14378_/B _15389_/A _15461_/B _14361_/Y VPWR VGND sg13g2_a21oi_1
X_11574_ _11574_/Y _14117_/B _11623_/D _11574_/B1 _14102_/C _14119_/B VPWR VGND sg13g2_a221oi_1
XFILLER_10_340 VPWR VGND sg13g2_fill_1
XFILLER_102_1609 VPWR VGND sg13g2_fill_1
XFILLER_11_896 VPWR VGND sg13g2_decap_8
X_13313_ _13313_/X _24171_/Q _24203_/Q _23307_/Q _23339_/Q _13978_/S0 _13689_/S1 VPWR
+ VGND sg13g2_mux4_1
X_17081_ _22721_/D _17080_/B _17079_/Y _17080_/Y VPWR VGND sg13g2_a21oi_1
XFILLER_52_1390 VPWR VGND sg13g2_fill_1
XFILLER_87_1431 VPWR VGND sg13g2_decap_4
X_13244_ _13244_/X _13242_/X _13243_/X _13244_/S VPWR VGND sg13g2_mux2_1
XFILLER_108_283 VPWR VGND sg13g2_fill_1
X_13175_ _13175_/X _23913_/Q _24009_/Q _24105_/Q _24137_/Q _13173_/S _13774_/A VPWR
+ VGND sg13g2_mux4_1
X_12126_ _12129_/B _12126_/A _12126_/B VPWR VGND sg13g2_nand2_1
XFILLER_2_550 VPWR VGND sg13g2_fill_1
XFILLER_96_104 VPWR VGND sg13g2_decap_8
X_17983_ _17983_/Y _17981_/Y _17982_/Y _18473_/S VPWR VGND sg13g2_a21oi_1
XFILLER_35_7 VPWR VGND sg13g2_decap_8
XFILLER_46_1161 VPWR VGND sg13g2_decap_8
XFILLER_111_448 VPWR VGND sg13g2_decap_8
X_16934_ _16935_/B _17024_/A _16947_/C VPWR VGND sg13g2_nor2_1
X_12057_ _12058_/B _12055_/X _12056_/X _12406_/A VPWR VGND sg13g2_mux2_1
XFILLER_42_1036 VPWR VGND sg13g2_decap_8
XFILLER_61_1659 VPWR VGND sg13g2_fill_1
X_19653_ _19654_/B _19696_/B _19417_/B _19652_/Y VPWR VGND sg13g2_o21ai_1
XFILLER_93_822 VPWR VGND sg13g2_fill_1
X_16865_ _22684_/D _17444_/A1 _17032_/B _16864_/Y VPWR VGND sg13g2_a21oi_1
XFILLER_37_215 VPWR VGND sg13g2_decap_8
XFILLER_65_524 VPWR VGND sg13g2_decap_8
XFILLER_37_237 VPWR VGND sg13g2_decap_8
X_15816_ _15817_/B _15930_/A _15816_/B VPWR VGND sg13g2_nor2_1
X_19584_ _19585_/B _19455_/Y _19462_/B _19584_/S VPWR VGND sg13g2_mux2_1
XFILLER_93_888 VPWR VGND sg13g2_fill_2
X_16796_ _16833_/A _16796_/A _16796_/B _16796_/C _16796_/D VPWR VGND sg13g2_or4_1
XFILLER_92_376 VPWR VGND sg13g2_fill_2
XFILLER_111_1484 VPWR VGND sg13g2_decap_8
X_18535_ _18535_/Y _22992_/Q _18535_/B VPWR VGND sg13g2_nand2_1
XFILLER_98_1593 VPWR VGND sg13g2_fill_1
XFILLER_92_398 VPWR VGND sg13g2_decap_8
XFILLER_34_933 VPWR VGND sg13g2_fill_2
X_15747_ _15748_/B _22703_/Q _15898_/A2 _15898_/B1 _22639_/Q VPWR VGND sg13g2_a22oi_1
X_12959_ _12959_/X _12959_/A _14304_/C VPWR VGND sg13g2_and2_1
XFILLER_20_1389 VPWR VGND sg13g2_decap_8
XFILLER_94_1446 VPWR VGND sg13g2_decap_4
XFILLER_61_730 VPWR VGND sg13g2_fill_1
X_18466_ _18466_/Y _18120_/Y _18465_/B _18465_/Y VPWR VGND sg13g2_o21ai_1
XFILLER_37_1820 VPWR VGND sg13g2_fill_2
X_15678_ _15689_/A _15984_/A _15678_/B VPWR VGND sg13g2_nor2_1
XFILLER_33_465 VPWR VGND sg13g2_decap_8
X_17417_ _17417_/Y _22828_/Q _17419_/B VPWR VGND sg13g2_nand2_1
X_14629_ _14629_/Y _14629_/A _19235_/C VPWR VGND sg13g2_nor2_1
XFILLER_57_1290 VPWR VGND sg13g2_decap_8
Xplace4104 _18030_/A _22999_/Q VPWR VGND sg13g2_buf_1
X_18397_ _18397_/Y _18395_/Y _18216_/B _18396_/Y VPWR VGND sg13g2_o21ai_1
XFILLER_14_690 VPWR VGND sg13g2_decap_8
Xplace4115 _12782_/A _12577_/B VPWR VGND sg13g2_buf_1
XFILLER_60_295 VPWR VGND sg13g2_decap_8
Xplace4126 _11723_/S _13708_/B VPWR VGND sg13g2_buf_1
XFILLER_33_1717 VPWR VGND sg13g2_fill_2
Xplace4137 _12146_/S _11295_/A VPWR VGND sg13g2_buf_1
X_17348_ _17348_/Y _17348_/A _17369_/B VPWR VGND sg13g2_nand2_1
Xplace3403 _17366_/S _17351_/B VPWR VGND sg13g2_buf_1
Xplace4148 _13635_/S1 _13466_/A VPWR VGND sg13g2_buf_2
Xplace4159 _13900_/S1 _13795_/S1 VPWR VGND sg13g2_buf_1
Xplace3414 _17302_/S _17300_/B VPWR VGND sg13g2_buf_1
Xplace3425 _16508_/B _16512_/B VPWR VGND sg13g2_buf_1
XFILLER_53_1198 VPWR VGND sg13g2_decap_8
Xplace3436 _17849_/C _17853_/C VPWR VGND sg13g2_buf_1
Xplace3447 _17796_/B _17721_/B VPWR VGND sg13g2_buf_1
XFILLER_31_1441 VPWR VGND sg13g2_fill_2
X_17279_ _17279_/Y _17279_/A _17291_/B VPWR VGND sg13g2_nand2_1
Xplace3458 _17092_/B _17113_/B VPWR VGND sg13g2_buf_1
Xplace3469 _16711_/A _16565_/B VPWR VGND sg13g2_buf_1
XFILLER_61_0 VPWR VGND sg13g2_decap_8
X_19018_ _19019_/C _19023_/B _23091_/Q VPWR VGND sg13g2_nand2_1
XFILLER_31_1485 VPWR VGND sg13g2_decap_4
X_20290_ _20291_/B _20290_/A _20290_/B _20292_/B VPWR VGND sg13g2_nand3_1
XFILLER_115_754 VPWR VGND sg13g2_decap_8
XFILLER_114_231 VPWR VGND sg13g2_decap_8
XFILLER_83_1840 VPWR VGND sg13g2_fill_1
XFILLER_83_1851 VPWR VGND sg13g2_decap_4
XFILLER_44_1824 VPWR VGND sg13g2_decap_8
XFILLER_29_1381 VPWR VGND sg13g2_fill_1
XFILLER_64_1272 VPWR VGND sg13g2_decap_8
X_23980_ _23980_/Q clkload36/A _23980_/D fanout2710/X VPWR VGND sg13g2_dfrbpq_1
XFILLER_112_1204 VPWR VGND sg13g2_fill_2
XFILLER_29_716 VPWR VGND sg13g2_fill_2
XFILLER_111_982 VPWR VGND sg13g2_fill_2
X_22931_ _22931_/Q _22941_/CLK _22931_/D fanout2801/X VPWR VGND sg13g2_dfrbpq_1
XFILLER_29_738 VPWR VGND sg13g2_decap_8
XFILLER_60_1158 VPWR VGND sg13g2_fill_2
XFILLER_113_14 VPWR VGND sg13g2_decap_8
XFILLER_56_546 VPWR VGND sg13g2_fill_1
XFILLER_28_248 VPWR VGND sg13g2_decap_8
XFILLER_28_259 VPWR VGND sg13g2_fill_1
XFILLER_77_1600 VPWR VGND sg13g2_fill_1
X_22862_ _22862_/Q clkload7/A _22862_/D fanout2794/X VPWR VGND sg13g2_dfrbpq_1
XFILLER_25_911 VPWR VGND sg13g2_decap_8
XFILLER_71_527 VPWR VGND sg13g2_decap_8
XFILLER_3_1085 VPWR VGND sg13g2_fill_1
XFILLER_25_922 VPWR VGND sg13g2_fill_1
XFILLER_37_782 VPWR VGND sg13g2_decap_4
X_21813_ _23903_/D _22280_/A1 _21818_/B _21812_/Y VPWR VGND sg13g2_o21ai_1
X_22793_ _22793_/Q clkload21/A _22793_/D fanout2877/X VPWR VGND sg13g2_dfrbpq_1
XFILLER_77_1655 VPWR VGND sg13g2_decap_8
XFILLER_25_944 VPWR VGND sg13g2_fill_1
XFILLER_71_549 VPWR VGND sg13g2_decap_8
XFILLER_25_955 VPWR VGND sg13g2_decap_8
XFILLER_77_1688 VPWR VGND sg13g2_decap_8
XFILLER_106_1008 VPWR VGND sg13g2_fill_1
X_21675_ _23850_/D _22033_/A1 _21674_/B _21674_/Y VPWR VGND sg13g2_o21ai_1
XFILLER_16_1926 VPWR VGND sg13g2_decap_8
X_23414_ _23414_/Q clkload54/A _23414_/D fanout2781/X VPWR VGND sg13g2_dfrbpq_1
X_20626_ _20626_/Y _23367_/Q _20638_/B VPWR VGND sg13g2_nand2_1
XFILLER_32_1216 VPWR VGND sg13g2_fill_1
XFILLER_51_1839 VPWR VGND sg13g2_fill_1
XFILLER_36_1396 VPWR VGND sg13g2_fill_2
XFILLER_32_1238 VPWR VGND sg13g2_fill_1
X_23345_ _23345_/Q clkload50/A _23345_/D fanout2662/X VPWR VGND sg13g2_dfrbpq_1
X_20557_ _20557_/Y _20557_/A _20565_/B VPWR VGND sg13g2_nand2_1
XFILLER_14_1683 VPWR VGND sg13g2_fill_2
Xplace3970 _19008_/A _19041_/A VPWR VGND sg13g2_buf_1
X_23276_ _23276_/Q _24214_/CLK _23276_/D fanout2629/X VPWR VGND sg13g2_dfrbpq_1
Xplace3981 _12922_/A2 _11824_/Y VPWR VGND sg13g2_buf_1
Xplace3992 _13801_/A1 _11484_/X VPWR VGND sg13g2_buf_2
XFILLER_88_1762 VPWR VGND sg13g2_decap_8
XFILLER_49_1713 VPWR VGND sg13g2_fill_2
XFILLER_88_1773 VPWR VGND sg13g2_fill_1
XFILLER_84_1604 VPWR VGND sg13g2_decap_4
XFILLER_4_848 VPWR VGND sg13g2_fill_2
XFILLER_3_336 VPWR VGND sg13g2_decap_8
X_22227_ _22227_/Y _22227_/A _22229_/B VPWR VGND sg13g2_nand2_1
Xhold4650 _17272_/A _22766_/Q VPWR VGND sg13g2_dlygate4sd3_1
Xhold4661 _17311_/A _22784_/Q VPWR VGND sg13g2_dlygate4sd3_1
X_22158_ _22158_/Y _22158_/A _22160_/B VPWR VGND sg13g2_nand2_1
Xhold4672 _17348_/A _22801_/Q VPWR VGND sg13g2_dlygate4sd3_1
Xhold4683 _17505_/A _22870_/Q VPWR VGND sg13g2_dlygate4sd3_1
X_21109_ _23580_/D _21309_/A1 _21108_/B _21108_/Y VPWR VGND sg13g2_o21ai_1
Xhold4694 _18135_/A _22961_/Q VPWR VGND sg13g2_dlygate4sd3_1
X_14980_ _16284_/B _22529_/Q _14990_/B VPWR VGND sg13g2_nand2_1
X_22089_ _22089_/Y _24036_/Q _22095_/B VPWR VGND sg13g2_nand2_1
XFILLER_59_351 VPWR VGND sg13g2_decap_8
XFILLER_75_800 VPWR VGND sg13g2_decap_4
XFILLER_23_1919 VPWR VGND sg13g2_decap_8
XFILLER_87_671 VPWR VGND sg13g2_decap_4
X_13931_ _13934_/A _13931_/A _13931_/B VPWR VGND sg13g2_nor2_1
XFILLER_5_1840 VPWR VGND sg13g2_decap_8
XFILLER_86_192 VPWR VGND sg13g2_decap_8
XFILLER_74_332 VPWR VGND sg13g2_fill_2
X_16650_ _16651_/B _16654_/B _16658_/C VPWR VGND sg13g2_nand2_1
XFILLER_90_803 VPWR VGND sg13g2_decap_4
X_13862_ _13864_/B _14342_/A _14704_/A VPWR VGND sg13g2_nand2_1
XFILLER_35_719 VPWR VGND sg13g2_decap_8
X_15601_ _15602_/B _22794_/Q _16007_/B VPWR VGND sg13g2_nand2_1
XFILLER_1_1748 VPWR VGND sg13g2_decap_8
XFILLER_21_1676 VPWR VGND sg13g2_fill_2
X_12813_ _12813_/X _24036_/Q _24068_/Q _12813_/S VPWR VGND sg13g2_mux2_1
XFILLER_62_527 VPWR VGND sg13g2_fill_1
X_16581_ _16589_/C _16676_/A _16594_/A VPWR VGND sg13g2_nor2_1
X_13793_ _13793_/X _24177_/Q _24209_/Q _23249_/Q _23281_/Q _13798_/B2 _13795_/S1 VPWR
+ VGND sg13g2_mux4_1
XFILLER_16_944 VPWR VGND sg13g2_fill_2
XFILLER_43_730 VPWR VGND sg13g2_decap_8
X_18320_ _18320_/Y _18355_/A _18320_/B VPWR VGND sg13g2_nor2_1
XFILLER_56_1717 VPWR VGND sg13g2_decap_4
XFILLER_103_91 VPWR VGND sg13g2_fill_1
X_15532_ _15533_/B _22725_/Q _15662_/A2 _15662_/B1 _22661_/Q VPWR VGND sg13g2_a22oi_1
XFILLER_91_1608 VPWR VGND sg13g2_decap_4
XFILLER_37_1105 VPWR VGND sg13g2_fill_2
XFILLER_95_1788 VPWR VGND sg13g2_fill_1
XFILLER_16_977 VPWR VGND sg13g2_decap_8
XFILLER_15_454 VPWR VGND sg13g2_fill_1
X_12744_ _12745_/A _12744_/A1 _12741_/X _12743_/X VPWR VGND sg13g2_o21ai_1
XFILLER_31_936 VPWR VGND sg13g2_decap_8
X_18251_ _22971_/D _18565_/B _18249_/Y _18250_/Y VPWR VGND sg13g2_o21ai_1
XFILLER_70_582 VPWR VGND sg13g2_fill_2
X_15463_ _15463_/Y _16016_/A _15463_/B VPWR VGND sg13g2_nand2_1
XFILLER_93_1490 VPWR VGND sg13g2_decap_8
XFILLER_19_1561 VPWR VGND sg13g2_fill_1
XFILLER_106_1520 VPWR VGND sg13g2_decap_8
XFILLER_30_435 VPWR VGND sg13g2_decap_4
X_17202_ _17202_/Y _17202_/A _17220_/B VPWR VGND sg13g2_nor2_1
X_18182_ _18184_/B _18385_/A _18181_/Y _18425_/B VPWR VGND sg13g2_o21ai_1
X_11626_ _11626_/X _22967_/Q _11626_/B VPWR VGND sg13g2_or2_1
X_15394_ _15396_/C _22455_/Q _15575_/B VPWR VGND sg13g2_nand2_1
XFILLER_54_1485 VPWR VGND sg13g2_decap_8
XFILLER_15_1447 VPWR VGND sg13g2_decap_8
XFILLER_50_1338 VPWR VGND sg13g2_fill_1
X_17133_ _17134_/B _17133_/A _17218_/A _17177_/A _17133_/D VPWR VGND sg13g2_nor4_1
XFILLER_11_682 VPWR VGND sg13g2_decap_8
X_14345_ _14372_/D _15262_/A _15255_/B _15257_/B VPWR VGND sg13g2_and3_1
X_11557_ _11557_/Y _11550_/Y _13925_/A1 _11554_/Y _11555_/Y _11556_/Y VPWR VGND sg13g2_a221oi_1
X_11488_ _11488_/X _23702_/Q _23766_/Q _23830_/Q _23926_/Q _11815_/S1 _11699_/S VPWR
+ VGND sg13g2_mux4_1
XFILLER_13_1182 VPWR VGND sg13g2_decap_8
XFILLER_100_1152 VPWR VGND sg13g2_decap_8
X_16015_ _16016_/D _22820_/Q _15308_/Y _16014_/Y VPWR VGND sg13g2_a21oi_1
X_13227_ _13227_/Y _23177_/Q _13924_/A2 _13924_/B1 _13226_/X VPWR VGND sg13g2_a22oi_1
XFILLER_28_1808 VPWR VGND sg13g2_fill_1
XFILLER_98_936 VPWR VGND sg13g2_fill_2
XFILLER_83_1147 VPWR VGND sg13g2_fill_2
X_13158_ _13158_/X _13156_/X _13157_/X _13158_/S VPWR VGND sg13g2_mux2_1
XFILLER_69_137 VPWR VGND sg13g2_decap_8
XFILLER_112_768 VPWR VGND sg13g2_decap_8
XFILLER_97_457 VPWR VGND sg13g2_decap_8
XFILLER_111_245 VPWR VGND sg13g2_decap_8
X_17966_ _17966_/Y _17965_/A _23034_/Q _17965_/Y VPWR VGND sg13g2_a21oi_1
X_13089_ _20147_/B _13037_/Y _13038_/Y _13055_/X VPWR VGND sg13g2_a21o_1
XFILLER_111_278 VPWR VGND sg13g2_decap_8
XFILLER_38_502 VPWR VGND sg13g2_decap_4
X_19705_ _19706_/C _19932_/A _19705_/B _19705_/C VPWR VGND sg13g2_nand3_1
X_16917_ _22693_/D _16927_/S _16915_/Y _16916_/Y VPWR VGND sg13g2_o21ai_1
XFILLER_66_822 VPWR VGND sg13g2_decap_8
XFILLER_6_1659 VPWR VGND sg13g2_decap_8
X_17897_ _17898_/B _22930_/Q _17909_/B VPWR VGND sg13g2_nand2_1
X_19636_ _19636_/Y _19874_/B _19636_/B VPWR VGND sg13g2_nor2_1
X_16848_ _16849_/A _22682_/Q VPWR VGND sg13g2_inv_1
XFILLER_81_814 VPWR VGND sg13g2_decap_8
XFILLER_53_505 VPWR VGND sg13g2_decap_8
XFILLER_66_888 VPWR VGND sg13g2_fill_2
XFILLER_65_365 VPWR VGND sg13g2_decap_8
XFILLER_53_516 VPWR VGND sg13g2_fill_2
XFILLER_78_1942 VPWR VGND sg13g2_decap_8
X_19567_ _19568_/B _19757_/A _19560_/X _19566_/X VPWR VGND sg13g2_a21oi_1
XFILLER_78_1953 VPWR VGND sg13g2_fill_2
XFILLER_53_538 VPWR VGND sg13g2_decap_8
XFILLER_65_398 VPWR VGND sg13g2_decap_8
X_16779_ _16779_/Y _16779_/A _16779_/B VPWR VGND sg13g2_nor2_1
XFILLER_81_858 VPWR VGND sg13g2_decap_8
XFILLER_94_1243 VPWR VGND sg13g2_decap_4
X_18518_ _18518_/Y _18517_/B _18071_/A _18517_/Y VPWR VGND sg13g2_o21ai_1
XFILLER_34_752 VPWR VGND sg13g2_fill_1
XFILLER_94_1276 VPWR VGND sg13g2_fill_1
XFILLER_90_1118 VPWR VGND sg13g2_fill_1
XFILLER_22_925 VPWR VGND sg13g2_fill_1
XFILLER_90_1129 VPWR VGND sg13g2_decap_8
X_18449_ _18449_/Y _18562_/C _18449_/B VPWR VGND sg13g2_nor2_1
XFILLER_21_435 VPWR VGND sg13g2_decap_8
XFILLER_72_1541 VPWR VGND sg13g2_fill_2
X_21460_ _23747_/D _21954_/A1 _21467_/B _21459_/Y VPWR VGND sg13g2_o21ai_1
Xplace3200 _22033_/A1 _20202_/X VPWR VGND sg13g2_buf_1
Xplace3211 _20052_/B _20144_/B VPWR VGND sg13g2_buf_1
X_20411_ _23269_/D _22425_/A1 _20412_/B _20410_/Y VPWR VGND sg13g2_o21ai_1
Xplace3222 _22408_/B _22402_/B VPWR VGND sg13g2_buf_1
Xplace3233 _21642_/B _21635_/B VPWR VGND sg13g2_buf_1
Xplace3244 _21188_/B _21205_/B VPWR VGND sg13g2_buf_1
XFILLER_105_1085 VPWR VGND sg13g2_decap_8
Xplace3255 _21983_/A1 _22451_/A1 VPWR VGND sg13g2_buf_1
XFILLER_102_1940 VPWR VGND sg13g2_decap_8
Xplace3266 _21346_/A0 _22177_/A1 VPWR VGND sg13g2_buf_1
X_23130_ _23130_/Q clkload5/A _23130_/D fanout2833/X VPWR VGND sg13g2_dfrbpq_1
X_20342_ _20342_/Y _20342_/A _20342_/B _20342_/C VPWR VGND sg13g2_nor3_1
Xplace3277 _22298_/A0 _20172_/Y VPWR VGND sg13g2_buf_1
XFILLER_108_14 VPWR VGND sg13g2_decap_8
Xplace3288 _22292_/A1 _20124_/Y VPWR VGND sg13g2_buf_1
Xplace3299 _21317_/A1 _19972_/Y VPWR VGND sg13g2_buf_1
XFILLER_11_1867 VPWR VGND sg13g2_decap_8
XFILLER_66_1301 VPWR VGND sg13g2_decap_4
X_23061_ _23061_/Q clkload12/A _23061_/D fanout2928/X VPWR VGND sg13g2_dfrbpq_1
X_20273_ _20273_/Y _14014_/S _19835_/Y _19837_/Y _13722_/Y _20272_/Y VPWR VGND sg13g2_a221oi_1
XFILLER_66_1323 VPWR VGND sg13g2_decap_4
XFILLER_115_551 VPWR VGND sg13g2_decap_8
XFILLER_103_702 VPWR VGND sg13g2_fill_1
X_22012_ _23999_/D _22280_/A1 _22017_/B _22011_/Y VPWR VGND sg13g2_o21ai_1
XFILLER_0_317 VPWR VGND sg13g2_decap_4
XFILLER_88_446 VPWR VGND sg13g2_fill_2
XFILLER_102_256 VPWR VGND sg13g2_decap_8
XFILLER_9_1272 VPWR VGND sg13g2_fill_2
XFILLER_25_1042 VPWR VGND sg13g2_fill_1
XFILLER_57_822 VPWR VGND sg13g2_decap_8
XFILLER_69_682 VPWR VGND sg13g2_decap_4
XFILLER_75_129 VPWR VGND sg13g2_fill_1
X_23963_ _23963_/Q _23966_/CLK _23963_/D fanout2766/X VPWR VGND sg13g2_dfrbpq_1
XFILLER_84_17 VPWR VGND sg13g2_decap_8
XFILLER_25_1064 VPWR VGND sg13g2_fill_1
X_22914_ _22914_/Q clkload22/A _22914_/D fanout2875/X VPWR VGND sg13g2_dfrbpq_1
XFILLER_57_877 VPWR VGND sg13g2_decap_4
XFILLER_99_1165 VPWR VGND sg13g2_decap_8
XFILLER_22_1952 VPWR VGND sg13g2_fill_2
X_23894_ _23894_/Q clkload46/A _23894_/D fanout2676/X VPWR VGND sg13g2_dfrbpq_1
XFILLER_44_505 VPWR VGND sg13g2_decap_8
XFILLER_84_696 VPWR VGND sg13g2_decap_8
XFILLER_16_229 VPWR VGND sg13g2_fill_2
XFILLER_72_847 VPWR VGND sg13g2_decap_8
X_22845_ _22845_/Q clkload25/A _22845_/D fanout2900/X VPWR VGND sg13g2_dfrbpq_1
XFILLER_56_398 VPWR VGND sg13g2_decap_8
XFILLER_72_869 VPWR VGND sg13g2_decap_8
X_22776_ _22776_/Q _22869_/CLK _22776_/D fanout2793/X VPWR VGND sg13g2_dfrbpq_1
XFILLER_25_774 VPWR VGND sg13g2_fill_2
XFILLER_71_379 VPWR VGND sg13g2_decap_8
XFILLER_0_1781 VPWR VGND sg13g2_decap_4
XFILLER_52_560 VPWR VGND sg13g2_fill_1
XFILLER_9_918 VPWR VGND sg13g2_fill_1
XFILLER_8_417 VPWR VGND sg13g2_fill_2
XFILLER_40_777 VPWR VGND sg13g2_decap_8
X_21658_ _23842_/D _21952_/A1 _21657_/B _21657_/Y VPWR VGND sg13g2_o21ai_1
X_12460_ _12461_/C _12460_/A _12460_/B VPWR VGND sg13g2_or2_1
XFILLER_36_1182 VPWR VGND sg13g2_decap_4
XFILLER_51_1636 VPWR VGND sg13g2_fill_2
XFILLER_103_1704 VPWR VGND sg13g2_fill_2
XFILLER_16_1767 VPWR VGND sg13g2_fill_1
XFILLER_32_1024 VPWR VGND sg13g2_decap_8
XFILLER_107_1895 VPWR VGND sg13g2_decap_8
X_11411_ _11411_/Y _23606_/Q _11752_/B VPWR VGND sg13g2_nand2b_1
XFILLER_16_1789 VPWR VGND sg13g2_fill_2
X_12391_ _12392_/B _23711_/Q _23743_/Q _23775_/Q _23807_/Q _12651_/S0 _12651_/S1 VPWR
+ VGND sg13g2_mux4_1
X_21589_ _23809_/D _21950_/A1 _21590_/B _21588_/Y VPWR VGND sg13g2_o21ai_1
X_11342_ _11342_/X _11340_/X _11341_/X _11926_/S VPWR VGND sg13g2_mux2_1
XFILLER_32_1079 VPWR VGND sg13g2_decap_4
Xrebuffer5480 _14801_/A _14407_/X VPWR VGND sg13g2_buf_1
X_14130_ _21984_/A _22973_/Q _22050_/B _22975_/Q VPWR VGND sg13g2_nor3_1
X_23328_ _23328_/Q _23682_/CLK _23328_/D fanout2722/X VPWR VGND sg13g2_dfrbpq_1
XFILLER_10_1322 VPWR VGND sg13g2_decap_4
Xrebuffer5491 _11623_/D _11569_/Y VPWR VGND sg13g2_buf_2
XFILLER_3_100 VPWR VGND sg13g2_fill_1
XFILLER_84_1401 VPWR VGND sg13g2_fill_2
XFILLER_109_0 VPWR VGND sg13g2_decap_8
XFILLER_10_1355 VPWR VGND sg13g2_decap_8
X_14061_ _14062_/B _14060_/X _13303_/A _14061_/S VPWR VGND sg13g2_mux2_1
X_23259_ _23259_/Q clkload54/A _23259_/D fanout2771/X VPWR VGND sg13g2_dfrbpq_1
XFILLER_49_1554 VPWR VGND sg13g2_decap_4
XFILLER_4_678 VPWR VGND sg13g2_decap_8
Xhold5170 _21902_/A _23947_/Q VPWR VGND sg13g2_dlygate4sd3_1
XFILLER_106_573 VPWR VGND sg13g2_decap_8
X_13012_ _13077_/C _20132_/A _13012_/B VPWR VGND sg13g2_xnor2_1
Xhold5181 _21413_/A _23726_/Q VPWR VGND sg13g2_dlygate4sd3_1
XFILLER_49_1576 VPWR VGND sg13g2_decap_8
XFILLER_49_1587 VPWR VGND sg13g2_fill_1
Xhold5192 _21590_/A _23810_/Q VPWR VGND sg13g2_dlygate4sd3_1
XFILLER_79_435 VPWR VGND sg13g2_fill_1
X_17820_ _17821_/B _22577_/Q _22578_/Q _17820_/C VPWR VGND sg13g2_nand3_1
XFILLER_58_40 VPWR VGND sg13g2_decap_4
XFILLER_114_1811 VPWR VGND sg13g2_decap_8
XFILLER_95_939 VPWR VGND sg13g2_decap_8
XFILLER_7_1946 VPWR VGND sg13g2_decap_8
XFILLER_43_1142 VPWR VGND sg13g2_fill_2
XFILLER_58_73 VPWR VGND sg13g2_fill_1
X_14963_ _14963_/Y _14982_/S _23139_/Q VPWR VGND sg13g2_nor2_1
XFILLER_62_1776 VPWR VGND sg13g2_decap_4
XFILLER_102_790 VPWR VGND sg13g2_decap_8
XFILLER_48_844 VPWR VGND sg13g2_decap_8
XFILLER_87_490 VPWR VGND sg13g2_fill_1
XFILLER_12_9 VPWR VGND sg13g2_fill_1
X_16702_ _22655_/D _15375_/Y _16707_/A _16701_/Y VPWR VGND sg13g2_a21oi_1
XFILLER_75_641 VPWR VGND sg13g2_decap_8
X_13914_ _13914_/X _24179_/Q _24211_/Q _23251_/Q _23283_/Q _13919_/S0 _13919_/S1 VPWR
+ VGND sg13g2_mux4_1
XFILLER_47_343 VPWR VGND sg13g2_fill_1
XFILLER_114_1888 VPWR VGND sg13g2_decap_8
XFILLER_78_1205 VPWR VGND sg13g2_decap_8
X_17682_ _17682_/Y _17124_/A _17382_/A _17580_/B _17681_/Y VPWR VGND sg13g2_a22oi_1
X_14894_ _14896_/B _22460_/Q _14947_/B VPWR VGND sg13g2_nand2_1
X_19421_ _19421_/Y _19953_/B _19443_/B VPWR VGND sg13g2_nand2b_1
XFILLER_63_836 VPWR VGND sg13g2_decap_8
X_16633_ _22641_/D _16154_/X _16626_/A _16632_/Y VPWR VGND sg13g2_a21oi_1
XFILLER_74_50 VPWR VGND sg13g2_decap_8
XFILLER_75_696 VPWR VGND sg13g2_decap_4
X_19352_ _19352_/Y _13512_/Y _19351_/B _19351_/Y VPWR VGND sg13g2_a21oi_1
X_16564_ _16683_/A _22627_/Q _22626_/Q _22625_/Q _16564_/D VPWR VGND sg13g2_nand4_1
X_13776_ _13776_/Y _13776_/A1 _13771_/X _13775_/Y _12048_/A VPWR VGND sg13g2_a22oi_1
XFILLER_95_1585 VPWR VGND sg13g2_fill_1
XFILLER_90_699 VPWR VGND sg13g2_fill_1
XFILLER_31_700 VPWR VGND sg13g2_decap_4
XFILLER_95_1596 VPWR VGND sg13g2_decap_8
XFILLER_91_1438 VPWR VGND sg13g2_fill_1
XFILLER_108_1637 VPWR VGND sg13g2_decap_4
X_19283_ _23201_/D _23201_/Q _20310_/A1 _19300_/S VPWR VGND sg13g2_mux2_1
X_16495_ _22609_/D _17175_/A _22609_/Q _16495_/S VPWR VGND sg13g2_mux2_1
Xinput4390 _20310_/A3 data_rdata_i[20] VPWR VGND sg13g2_buf_1
X_18234_ _18234_/Y _18232_/Y _18233_/Y _18194_/A VPWR VGND sg13g2_a21oi_1
X_15446_ _15446_/Y _22626_/Q _15323_/X _15325_/Y _22690_/Q VPWR VGND sg13g2_a22oi_1
XFILLER_90_82 VPWR VGND sg13g2_decap_8
XFILLER_15_1222 VPWR VGND sg13g2_decap_8
XFILLER_31_788 VPWR VGND sg13g2_fill_1
XFILLER_34_1845 VPWR VGND sg13g2_fill_2
X_12658_ _12658_/Y _12997_/S _24034_/Q _12657_/Y VPWR VGND sg13g2_o21ai_1
XFILLER_8_940 VPWR VGND sg13g2_decap_8
X_18165_ _18301_/A _18264_/A _18351_/B VPWR VGND sg13g2_nor2_1
XFILLER_30_298 VPWR VGND sg13g2_decap_8
X_11609_ _11634_/D _14117_/A _22978_/Q VPWR VGND sg13g2_nor2_1
XFILLER_50_1135 VPWR VGND sg13g2_fill_1
X_15377_ _15377_/Y _22454_/Q VPWR VGND sg13g2_inv_1
X_12589_ _12589_/X _13607_/A _12589_/B VPWR VGND sg13g2_or2_1
XFILLER_8_984 VPWR VGND sg13g2_fill_1
XFILLER_7_450 VPWR VGND sg13g2_decap_8
XFILLER_50_1179 VPWR VGND sg13g2_decap_8
X_14328_ _15178_/C _15165_/B _14336_/C VPWR VGND sg13g2_nand2_1
X_18096_ _18096_/Y _18339_/A _22996_/Q _18096_/C _18096_/D VPWR VGND sg13g2_nor4_1
X_14259_ _14260_/C _23193_/Q _24231_/Q _24230_/Q _14259_/D VPWR VGND sg13g2_nor4_1
XFILLER_98_700 VPWR VGND sg13g2_decap_8
XFILLER_28_1605 VPWR VGND sg13g2_decap_4
XFILLER_97_210 VPWR VGND sg13g2_decap_4
XFILLER_98_744 VPWR VGND sg13g2_decap_4
XFILLER_86_906 VPWR VGND sg13g2_fill_2
XFILLER_112_565 VPWR VGND sg13g2_decap_8
XFILLER_86_928 VPWR VGND sg13g2_fill_1
X_18998_ _18999_/B _18997_/Y _23057_/Q _19042_/S VPWR VGND sg13g2_mux2_1
XFILLER_26_1340 VPWR VGND sg13g2_fill_1
XFILLER_97_276 VPWR VGND sg13g2_fill_1
XFILLER_113_1310 VPWR VGND sg13g2_fill_1
XFILLER_97_298 VPWR VGND sg13g2_decap_8
XFILLER_80_1876 VPWR VGND sg13g2_fill_1
XFILLER_38_321 VPWR VGND sg13g2_decap_8
XFILLER_6_1478 VPWR VGND sg13g2_decap_8
XFILLER_22_1237 VPWR VGND sg13g2_decap_8
X_20960_ _20960_/Y _23525_/Q _20962_/B VPWR VGND sg13g2_nand2_1
XFILLER_6_1489 VPWR VGND sg13g2_fill_2
XFILLER_22_1259 VPWR VGND sg13g2_decap_8
XFILLER_81_600 VPWR VGND sg13g2_fill_2
XFILLER_81_633 VPWR VGND sg13g2_fill_1
X_19619_ _19619_/Y _23206_/Q _19781_/A2 _19781_/B1 _23198_/Q VPWR VGND sg13g2_a22oi_1
X_20891_ _23491_/D _21325_/A1 _20903_/B _20890_/Y VPWR VGND sg13g2_o21ai_1
XFILLER_65_195 VPWR VGND sg13g2_decap_8
XFILLER_74_1603 VPWR VGND sg13g2_fill_2
X_22630_ _22630_/Q clkload23/A _22630_/D fanout2883/X VPWR VGND sg13g2_dfrbpq_1
XFILLER_0_1055 VPWR VGND sg13g2_fill_2
XFILLER_94_1062 VPWR VGND sg13g2_decap_8
XFILLER_22_700 VPWR VGND sg13g2_fill_2
XFILLER_80_176 VPWR VGND sg13g2_decap_8
XFILLER_80_187 VPWR VGND sg13g2_fill_2
XFILLER_39_1778 VPWR VGND sg13g2_decap_4
X_22561_ _22561_/Q clkload26/A _22561_/D fanout2850/X VPWR VGND sg13g2_dfrbpq_1
XFILLER_62_891 VPWR VGND sg13g2_fill_1
XFILLER_10_917 VPWR VGND sg13g2_decap_8
X_22492_ _22492_/Q clkload18/A _22492_/D fanout2827/X VPWR VGND sg13g2_dfrbpq_1
XFILLER_10_939 VPWR VGND sg13g2_decap_8
XFILLER_21_276 VPWR VGND sg13g2_fill_1
X_21443_ _21443_/Y _21443_/A _21447_/B VPWR VGND sg13g2_nand2_1
X_24231_ _24231_/Q clkload11/A _24231_/D fanout2846/X VPWR VGND sg13g2_dfrbpq_1
Xplace3030 _22172_/B _22175_/B VPWR VGND sg13g2_buf_1
Xplace3041 _22003_/B _22001_/B VPWR VGND sg13g2_buf_1
Xplace3052 _21965_/S _21981_/S VPWR VGND sg13g2_buf_1
X_24162_ _24162_/Q clkload41/A _24162_/D fanout2714/X VPWR VGND sg13g2_dfrbpq_1
X_21374_ _21374_/Y _21374_/A _21374_/B VPWR VGND sg13g2_nand2_1
Xplace3063 _21885_/B _21900_/B VPWR VGND sg13g2_buf_1
Xplace3074 _21615_/B _21621_/B VPWR VGND sg13g2_buf_1
Xplace3085 _21508_/B _21502_/B VPWR VGND sg13g2_buf_1
Xplace3096 _21473_/B _21467_/B VPWR VGND sg13g2_buf_1
X_23113_ _23113_/Q clkload12/A _23113_/D fanout2910/X VPWR VGND sg13g2_dfrbpq_1
X_20325_ _20326_/B _19597_/X _20323_/Y _20324_/Y _13931_/A VPWR VGND sg13g2_a22oi_1
XFILLER_102_7 VPWR VGND sg13g2_decap_8
X_24093_ _24093_/Q clkload44/A _24093_/D fanout2745/X VPWR VGND sg13g2_dfrbpq_1
XFILLER_89_722 VPWR VGND sg13g2_decap_4
X_23044_ _23044_/Q clkload13/A _23044_/D fanout2907/X VPWR VGND sg13g2_dfrbpq_1
X_20256_ _20256_/Y _20255_/X _20317_/B VPWR VGND sg13g2_nand2b_1
XFILLER_27_1104 VPWR VGND sg13g2_decap_8
XFILLER_81_1618 VPWR VGND sg13g2_fill_2
XFILLER_0_125 VPWR VGND sg13g2_decap_4
XFILLER_46_1749 VPWR VGND sg13g2_fill_2
XFILLER_77_917 VPWR VGND sg13g2_fill_2
XFILLER_27_1159 VPWR VGND sg13g2_decap_8
X_20187_ _20187_/Y _20183_/Y _20184_/Y _20186_/Y VPWR VGND sg13g2_o21ai_1
XFILLER_103_576 VPWR VGND sg13g2_decap_8
XFILLER_88_276 VPWR VGND sg13g2_fill_1
XFILLER_48_107 VPWR VGND sg13g2_decap_8
XFILLER_76_438 VPWR VGND sg13g2_decap_8
XFILLER_76_449 VPWR VGND sg13g2_fill_1
XFILLER_9_1091 VPWR VGND sg13g2_decap_4
XFILLER_40_1326 VPWR VGND sg13g2_decap_8
X_11960_ _11960_/X _23866_/Q _23962_/Q _11960_/S VPWR VGND sg13g2_mux2_1
XFILLER_40_1348 VPWR VGND sg13g2_fill_2
X_23946_ _23946_/Q clkload45/A _23946_/D fanout2711/X VPWR VGND sg13g2_dfrbpq_1
XFILLER_84_460 VPWR VGND sg13g2_decap_8
XFILLER_45_814 VPWR VGND sg13g2_decap_8
XFILLER_22_1793 VPWR VGND sg13g2_decap_8
XFILLER_44_335 VPWR VGND sg13g2_fill_2
X_23877_ _23877_/Q clkload45/A _23877_/D fanout2730/X VPWR VGND sg13g2_dfrbpq_1
XFILLER_2_1876 VPWR VGND sg13g2_decap_8
X_13630_ _13630_/X _23727_/Q _23759_/Q _23791_/Q _23823_/Q _13635_/S0 _13631_/S1 VPWR
+ VGND sg13g2_mux4_1
XFILLER_77_1260 VPWR VGND sg13g2_decap_8
X_22828_ _22828_/Q _22941_/CLK _22828_/D fanout2795/X VPWR VGND sg13g2_dfrbpq_1
XFILLER_77_1282 VPWR VGND sg13g2_decap_8
XFILLER_57_1856 VPWR VGND sg13g2_decap_8
XFILLER_71_176 VPWR VGND sg13g2_decap_8
XFILLER_44_64 VPWR VGND sg13g2_fill_1
XFILLER_25_582 VPWR VGND sg13g2_decap_8
XFILLER_53_891 VPWR VGND sg13g2_fill_1
XFILLER_109_1946 VPWR VGND sg13g2_decap_8
X_13561_ _13568_/C _13641_/A _13561_/B VPWR VGND sg13g2_nor2_1
XFILLER_71_198 VPWR VGND sg13g2_decap_4
X_22759_ _22759_/Q clkload19/A _22759_/D fanout2870/X VPWR VGND sg13g2_dfrbpq_1
X_15300_ _15348_/B _15300_/A _15300_/B _15300_/C VPWR VGND sg13g2_and3_1
X_12512_ _12538_/B _12829_/B _12512_/B VPWR VGND sg13g2_nor2_1
XFILLER_13_777 VPWR VGND sg13g2_decap_8
X_16280_ _16285_/B _16289_/A _16321_/C VPWR VGND sg13g2_or2_1
X_13492_ _13493_/B _13675_/A1 _13487_/Y _13489_/Y _13675_/B2 _13491_/Y VPWR VGND sg13g2_a221oi_1
XFILLER_100_70 VPWR VGND sg13g2_decap_8
XFILLER_8_236 VPWR VGND sg13g2_decap_8
X_12443_ _12450_/A _12443_/A _12606_/A _12443_/C VPWR VGND sg13g2_nor3_1
XFILLER_51_1477 VPWR VGND sg13g2_fill_1
XFILLER_103_1556 VPWR VGND sg13g2_decap_8
X_12374_ _12379_/B _12499_/A _12374_/B VPWR VGND sg13g2_nor2_1
XFILLER_4_420 VPWR VGND sg13g2_fill_1
XFILLER_5_14 VPWR VGND sg13g2_decap_8
X_14113_ _14263_/A _14596_/A VPWR VGND sg13g2_inv_1
X_11325_ _14594_/A _15407_/A _11583_/S VPWR VGND sg13g2_nand2_1
X_19970_ _19970_/Y _19970_/A VPWR VGND sg13g2_inv_1
XFILLER_4_442 VPWR VGND sg13g2_decap_8
X_15093_ _15095_/A _22511_/Q _15113_/B _14885_/Y _22939_/Q VPWR VGND sg13g2_a22oi_1
XFILLER_68_1941 VPWR VGND sg13g2_decap_8
XFILLER_29_1903 VPWR VGND sg13g2_decap_8
XFILLER_49_1340 VPWR VGND sg13g2_decap_8
XFILLER_113_329 VPWR VGND sg13g2_decap_8
X_14044_ _14049_/C _14038_/Y _14042_/X _14043_/Y VPWR VGND sg13g2_a21oi_1
X_18921_ _18922_/B _18920_/Y _23050_/Q _18924_/C VPWR VGND sg13g2_mux2_1
XFILLER_84_1253 VPWR VGND sg13g2_decap_4
XFILLER_79_210 VPWR VGND sg13g2_decap_4
XFILLER_10_1196 VPWR VGND sg13g2_decap_4
XFILLER_4_497 VPWR VGND sg13g2_fill_2
XFILLER_79_232 VPWR VGND sg13g2_decap_8
X_18852_ _18858_/A _18851_/Y _23043_/Q VPWR VGND sg13g2_nand2b_1
X_11187_ _11314_/A _14120_/C _11315_/D _14120_/B _11316_/B VPWR VGND sg13g2_and4_2
XFILLER_67_405 VPWR VGND sg13g2_decap_8
XFILLER_7_1743 VPWR VGND sg13g2_decap_8
X_17803_ _17803_/Y _17209_/A _17810_/A2 _17810_/B1 _17802_/Y VPWR VGND sg13g2_a22oi_1
X_18783_ _18788_/A _23032_/Q _18821_/B _18821_/C VPWR VGND sg13g2_nand3_1
XFILLER_27_1682 VPWR VGND sg13g2_decap_8
XFILLER_39_129 VPWR VGND sg13g2_decap_4
XFILLER_95_758 VPWR VGND sg13g2_decap_8
XFILLER_23_1524 VPWR VGND sg13g2_fill_1
X_15995_ _15996_/B _15995_/A _15995_/B _15995_/C _15995_/D VPWR VGND sg13g2_nand4_1
XFILLER_95_769 VPWR VGND sg13g2_fill_2
XFILLER_48_641 VPWR VGND sg13g2_decap_4
XFILLER_114_1663 VPWR VGND sg13g2_fill_1
XFILLER_97_1603 VPWR VGND sg13g2_fill_2
X_17734_ _17734_/Y _23175_/Q _17734_/A2 _17706_/X _11861_/A VPWR VGND sg13g2_a22oi_1
XFILLER_36_803 VPWR VGND sg13g2_decap_4
XFILLER_47_140 VPWR VGND sg13g2_fill_1
XFILLER_97_1625 VPWR VGND sg13g2_decap_4
XFILLER_48_674 VPWR VGND sg13g2_fill_2
XFILLER_23_1579 VPWR VGND sg13g2_decap_8
XFILLER_91_920 VPWR VGND sg13g2_decap_4
XFILLER_40_1871 VPWR VGND sg13g2_decap_8
XFILLER_39_1008 VPWR VGND sg13g2_decap_8
XFILLER_75_1912 VPWR VGND sg13g2_decap_4
X_16616_ _16617_/B _22638_/Q _16616_/B VPWR VGND sg13g2_xnor2_1
X_13828_ _13828_/Y _23185_/Q _13988_/A2 _13988_/B1 _13827_/Y VPWR VGND sg13g2_a22oi_1
X_17596_ _17597_/B _17699_/B1 _17592_/Y _17595_/X _17538_/B VPWR VGND sg13g2_a22oi_1
XFILLER_90_474 VPWR VGND sg13g2_fill_2
XFILLER_16_560 VPWR VGND sg13g2_decap_4
XFILLER_56_1322 VPWR VGND sg13g2_decap_4
XFILLER_63_699 VPWR VGND sg13g2_fill_1
XFILLER_50_327 VPWR VGND sg13g2_decap_8
X_16547_ _16547_/Y _16547_/A _16547_/B VPWR VGND sg13g2_nor2_1
X_19335_ _19335_/Y _13368_/A _19430_/B _19334_/Y VPWR VGND sg13g2_a21oi_1
XFILLER_50_338 VPWR VGND sg13g2_fill_1
XFILLER_36_1929 VPWR VGND sg13g2_decap_8
X_13759_ _13759_/Y _20290_/A _13721_/B _13947_/A VPWR VGND sg13g2_o21ai_1
XFILLER_91_1268 VPWR VGND sg13g2_fill_2
XFILLER_17_1339 VPWR VGND sg13g2_fill_2
X_19266_ _19266_/Y _19266_/A VPWR VGND sg13g2_inv_1
XFILLER_56_1399 VPWR VGND sg13g2_decap_8
X_16478_ _16478_/Y _22602_/Q _16514_/B VPWR VGND sg13g2_nand2_1
Xoutput4502 data_req_o _19260_/B VPWR VGND sg13g2_buf_1
Xoutput4513 data_wdata_o[19] _14727_/X VPWR VGND sg13g2_buf_1
X_18217_ _18217_/Y _18264_/A _18517_/B VPWR VGND sg13g2_nor2_1
XFILLER_34_1653 VPWR VGND sg13g2_decap_4
X_15429_ _15434_/A _15429_/A _15429_/B VPWR VGND sg13g2_nand2_1
Xoutput4524 data_wdata_o[29] _14737_/X VPWR VGND sg13g2_buf_1
X_19197_ _19197_/Y _19197_/A _19611_/A _19200_/S VPWR VGND sg13g2_nor3_1
Xoutput4535 data_we_o _14614_/Y VPWR VGND sg13g2_buf_1
Xoutput4546 instr_addr_o[20] _15013_/Y VPWR VGND sg13g2_buf_1
XFILLER_89_1131 VPWR VGND sg13g2_decap_4
Xoutput4557 instr_addr_o[30] _15111_/X VPWR VGND sg13g2_buf_1
X_18148_ _18427_/A _18351_/A _18196_/A VPWR VGND sg13g2_nor2_1
XFILLER_7_291 VPWR VGND sg13g2_decap_8
Xclkbuf_leaf_2_clk_i _23029_/CLK clkbuf_leaf_4_clk_i/A VPWR VGND sg13g2_buf_16
X_20110_ _20110_/X _20249_/A3 _23213_/Q _20249_/A2 _20249_/A1 _19501_/A _20154_/S1
+ VPWR VGND sg13g2_mux4_1
XFILLER_113_841 VPWR VGND sg13g2_decap_8
X_20041_ _20041_/Y _20335_/A _20150_/B _20040_/Y VPWR VGND sg13g2_o21ai_1
XFILLER_113_885 VPWR VGND sg13g2_fill_1
XFILLER_100_546 VPWR VGND sg13g2_decap_8
X_23800_ _23800_/Q _24113_/CLK _23800_/D fanout2688/X VPWR VGND sg13g2_dfrbpq_1
XFILLER_80_1695 VPWR VGND sg13g2_fill_2
XFILLER_113_1151 VPWR VGND sg13g2_decap_8
X_21992_ _23990_/D _22260_/A1 _22003_/B _21991_/Y VPWR VGND sg13g2_o21ai_1
XFILLER_39_674 VPWR VGND sg13g2_decap_8
XFILLER_38_162 VPWR VGND sg13g2_decap_8
X_23731_ _23731_/Q clkload51/A _23731_/D fanout2664/X VPWR VGND sg13g2_dfrbpq_1
X_20943_ _20943_/Y _20943_/A _20945_/B VPWR VGND sg13g2_nand2_1
X_23662_ _23662_/Q clkload36/A _23662_/D fanout2641/X VPWR VGND sg13g2_dfrbpq_1
X_20874_ _20874_/Y _20874_/A _20874_/B VPWR VGND sg13g2_nand2_1
XFILLER_81_474 VPWR VGND sg13g2_decap_8
XFILLER_74_1411 VPWR VGND sg13g2_decap_8
X_22613_ _22613_/Q _22893_/CLK _22613_/D fanout2813/X VPWR VGND sg13g2_dfrbpq_1
XFILLER_74_1455 VPWR VGND sg13g2_decap_8
X_23593_ _23593_/Q clkload47/A _23593_/D fanout2679/X VPWR VGND sg13g2_dfrbpq_1
XFILLER_35_1428 VPWR VGND sg13g2_decap_8
XFILLER_22_552 VPWR VGND sg13g2_fill_1
X_22544_ _22544_/Q clkload27/A _22544_/D fanout2892/X VPWR VGND sg13g2_dfrbpq_1
XFILLER_91_1780 VPWR VGND sg13g2_fill_1
XFILLER_104_1810 VPWR VGND sg13g2_fill_1
X_22475_ _22475_/Q clkload8/A _22475_/D fanout2806/X VPWR VGND sg13g2_dfrbpq_1
X_24214_ _24214_/Q _24214_/CLK _24214_/D wire1182/A VPWR VGND sg13g2_dfrbpq_1
XFILLER_33_1174 VPWR VGND sg13g2_decap_4
XFILLER_87_1816 VPWR VGND sg13g2_decap_8
XFILLER_107_112 VPWR VGND sg13g2_decap_8
XFILLER_104_1887 VPWR VGND sg13g2_decap_8
XFILLER_33_1196 VPWR VGND sg13g2_fill_2
XFILLER_100_1729 VPWR VGND sg13g2_fill_2
XFILLER_108_657 VPWR VGND sg13g2_decap_8
XFILLER_30_55 VPWR VGND sg13g2_decap_8
X_24145_ _24145_/Q clkload50/A _24145_/D fanout2682/X VPWR VGND sg13g2_dfrbpq_1
X_21357_ _21406_/B _22318_/B _21557_/B VPWR VGND sg13g2_nand2_1
XFILLER_2_913 VPWR VGND sg13g2_fill_1
XFILLER_85_1540 VPWR VGND sg13g2_fill_1
XFILLER_30_99 VPWR VGND sg13g2_decap_8
X_20308_ _20309_/D _20308_/A _20334_/B VPWR VGND sg13g2_nor2_1
XFILLER_107_189 VPWR VGND sg13g2_decap_8
X_12090_ _12091_/D _12090_/A _12090_/B VPWR VGND sg13g2_nor2_1
Xfanout2905 fanout2905/X fanout2908/X VPWR VGND sg13g2_buf_1
XFILLER_46_1502 VPWR VGND sg13g2_decap_4
XFILLER_104_830 VPWR VGND sg13g2_fill_1
Xfanout2916 fanout2916/X fanout2918/X VPWR VGND sg13g2_buf_1
X_24076_ _24076_/Q _24210_/CLK _24076_/D fanout2637/X VPWR VGND sg13g2_dfrbpq_1
X_21288_ _23668_/D _21622_/A1 _21287_/B _21287_/Y VPWR VGND sg13g2_o21ai_1
Xfanout2927 fanout2927/X wire1182/A VPWR VGND sg13g2_buf_1
X_23027_ _23027_/Q clkload11/A _23027_/D fanout2837/X VPWR VGND sg13g2_dfrbpq_1
XFILLER_46_1546 VPWR VGND sg13g2_fill_1
XFILLER_89_563 VPWR VGND sg13g2_decap_8
XFILLER_81_1459 VPWR VGND sg13g2_decap_8
XFILLER_77_725 VPWR VGND sg13g2_decap_8
XFILLER_39_64 VPWR VGND sg13g2_fill_1
XFILLER_77_747 VPWR VGND sg13g2_fill_1
XFILLER_77_769 VPWR VGND sg13g2_fill_2
XFILLER_76_257 VPWR VGND sg13g2_decap_8
X_15780_ _15780_/Y _22568_/Q _15889_/S VPWR VGND sg13g2_nand2_1
XFILLER_58_972 VPWR VGND sg13g2_decap_4
XFILLER_4_1949 VPWR VGND sg13g2_decap_4
XFILLER_57_460 VPWR VGND sg13g2_decap_8
X_12992_ _12992_/Y _17718_/B2 _13035_/A2 _13649_/A _14649_/A _12584_/Y VPWR VGND sg13g2_a221oi_1
XFILLER_111_1836 VPWR VGND sg13g2_decap_8
XFILLER_98_1945 VPWR VGND sg13g2_decap_8
XFILLER_24_1888 VPWR VGND sg13g2_decap_4
XFILLER_85_791 VPWR VGND sg13g2_decap_4
X_14731_ _14731_/X _14683_/Y _14681_/X _14732_/S VPWR VGND sg13g2_mux2_1
XFILLER_57_482 VPWR VGND sg13g2_decap_8
X_23929_ _23929_/Q _23966_/CLK _23929_/D fanout2786/X VPWR VGND sg13g2_dfrbpq_1
X_11943_ _11946_/B _12889_/A _11943_/B VPWR VGND sg13g2_nand2_1
XFILLER_17_335 VPWR VGND sg13g2_decap_8
XFILLER_44_121 VPWR VGND sg13g2_decap_8
XFILLER_75_1208 VPWR VGND sg13g2_decap_8
X_17450_ _22843_/D _16054_/A _17475_/B _17449_/Y VPWR VGND sg13g2_o21ai_1
X_14662_ _14662_/Y _14699_/A _14701_/B VPWR VGND sg13g2_nand2_1
XFILLER_44_154 VPWR VGND sg13g2_decap_8
XFILLER_57_1620 VPWR VGND sg13g2_decap_4
XFILLER_92_1522 VPWR VGND sg13g2_fill_2
X_16401_ _22568_/D _15779_/Y _16413_/S _16400_/Y VPWR VGND sg13g2_o21ai_1
X_13613_ _13613_/X _23599_/Q _23631_/Q _23663_/Q _23695_/Q _13614_/S0 _13614_/S1 VPWR
+ VGND sg13g2_mux4_1
X_17381_ _17382_/B _22816_/Q _16879_/A _17385_/S VPWR VGND sg13g2_mux2_1
X_14593_ _24214_/D _19274_/B _14591_/Y _14592_/Y VPWR VGND sg13g2_o21ai_1
XFILLER_92_1566 VPWR VGND sg13g2_decap_8
XFILLER_53_1517 VPWR VGND sg13g2_fill_2
XFILLER_60_669 VPWR VGND sg13g2_fill_2
X_19120_ _23098_/D _23098_/Q _19120_/A1 _19124_/S VPWR VGND sg13g2_mux2_1
XFILLER_111_91 VPWR VGND sg13g2_decap_8
X_16332_ _22542_/D _16332_/A _16333_/B VPWR VGND sg13g2_nor2_1
XFILLER_41_861 VPWR VGND sg13g2_decap_8
X_13544_ _13545_/B _13736_/A _20243_/A VPWR VGND sg13g2_xnor2_1
XFILLER_38_1096 VPWR VGND sg13g2_decap_8
X_19051_ _23062_/D _23062_/Q _19050_/X _19061_/S VPWR VGND sg13g2_mux2_1
X_16263_ _16321_/A _16263_/A _16263_/B _16263_/C VPWR VGND sg13g2_nand3_1
X_13475_ _13476_/B _23725_/Q _23757_/Q _23789_/Q _23821_/Q _13606_/S0 _13606_/S1 VPWR
+ VGND sg13g2_mux4_1
XFILLER_12_1214 VPWR VGND sg13g2_fill_2
X_15214_ _15215_/B _15201_/Y _16852_/B _15213_/Y VPWR VGND sg13g2_o21ai_1
X_12426_ _12426_/Y _19928_/A _12426_/B VPWR VGND sg13g2_nand2_1
X_16194_ _22510_/D _16193_/B _16192_/Y _16193_/Y VPWR VGND sg13g2_o21ai_1
XFILLER_65_7 VPWR VGND sg13g2_fill_1
X_15145_ _15312_/A _15262_/A _15300_/B _17034_/A VPWR VGND sg13g2_nand3_1
XFILLER_103_1397 VPWR VGND sg13g2_decap_4
X_12357_ _12357_/X _23551_/Q _23999_/Q _22985_/Q VPWR VGND sg13g2_mux2_1
XFILLER_114_627 VPWR VGND sg13g2_decap_8
X_11308_ _11308_/X _11305_/Y _11307_/X _22967_/Q VPWR VGND sg13g2_a21o_1
XFILLER_113_126 VPWR VGND sg13g2_decap_8
X_19953_ _19953_/Y _19953_/A _19953_/B VPWR VGND sg13g2_nand2_1
X_15076_ _15077_/B _22478_/Q _15114_/A2 _14826_/X VPWR VGND sg13g2_a21oi_1
XFILLER_68_1771 VPWR VGND sg13g2_decap_4
XFILLER_4_283 VPWR VGND sg13g2_decap_8
XFILLER_29_1733 VPWR VGND sg13g2_fill_2
X_12288_ _12643_/B _12443_/A _12288_/B VPWR VGND sg13g2_nor2_2
XFILLER_49_1170 VPWR VGND sg13g2_fill_1
XFILLER_68_1793 VPWR VGND sg13g2_decap_8
X_14027_ _14029_/B _19346_/A _14618_/A VPWR VGND sg13g2_xnor2_1
XFILLER_84_1072 VPWR VGND sg13g2_decap_4
X_18904_ _18904_/Y _18926_/A _23080_/Q _18959_/C VPWR VGND sg13g2_nand3_1
X_11239_ _12870_/B _23193_/Q _11239_/A2 _14240_/A _11238_/Y _11222_/X VPWR VGND sg13g2_a221oi_1
X_19884_ _19884_/X _19884_/A _19884_/B VPWR VGND sg13g2_or2_1
XFILLER_110_822 VPWR VGND sg13g2_decap_8
XFILLER_96_70 VPWR VGND sg13g2_decap_8
XFILLER_67_213 VPWR VGND sg13g2_decap_8
XFILLER_68_747 VPWR VGND sg13g2_fill_1
X_18835_ _18835_/Y _18009_/A _23040_/Q _18856_/B _18010_/B VPWR VGND sg13g2_a22oi_1
XFILLER_99_1709 VPWR VGND sg13g2_decap_8
XFILLER_23_1321 VPWR VGND sg13g2_fill_2
XFILLER_114_1460 VPWR VGND sg13g2_decap_8
XFILLER_55_408 VPWR VGND sg13g2_decap_4
XFILLER_110_1302 VPWR VGND sg13g2_fill_2
X_18766_ _18766_/Y _18766_/A _18854_/A VPWR VGND sg13g2_nor2_1
X_15978_ _17215_/A _16195_/A _15978_/B VPWR VGND sg13g2_nand2b_1
XFILLER_23_1365 VPWR VGND sg13g2_fill_1
XFILLER_76_780 VPWR VGND sg13g2_decap_8
XFILLER_82_238 VPWR VGND sg13g2_decap_8
X_17717_ _17717_/Y _22565_/Q _17732_/C VPWR VGND sg13g2_xnor2_1
X_14929_ _14929_/Y _14949_/A _14929_/B _14929_/C VPWR VGND sg13g2_nand3_1
XFILLER_36_644 VPWR VGND sg13g2_decap_8
X_18697_ _18698_/B _18697_/A _18700_/A VPWR VGND sg13g2_nor2_1
XFILLER_35_132 VPWR VGND sg13g2_decap_4
XFILLER_35_143 VPWR VGND sg13g2_decap_8
XFILLER_63_463 VPWR VGND sg13g2_decap_8
X_17648_ _17648_/Y _20437_/B _17697_/A _17647_/Y VPWR VGND sg13g2_o21ai_1
XFILLER_51_614 VPWR VGND sg13g2_fill_1
XFILLER_23_327 VPWR VGND sg13g2_decap_8
XFILLER_23_338 VPWR VGND sg13g2_fill_1
XFILLER_95_1190 VPWR VGND sg13g2_fill_1
XFILLER_91_1021 VPWR VGND sg13g2_decap_8
X_17579_ _17579_/Y _23159_/Q _17734_/A2 _17706_/B _17574_/Y _17578_/Y VPWR VGND sg13g2_a221oi_1
XFILLER_17_1103 VPWR VGND sg13g2_decap_8
XFILLER_51_669 VPWR VGND sg13g2_decap_8
XFILLER_91_1043 VPWR VGND sg13g2_fill_2
XFILLER_36_1737 VPWR VGND sg13g2_fill_2
X_20590_ _20590_/Y _20590_/A _20600_/B VPWR VGND sg13g2_nand2_1
XFILLER_56_1196 VPWR VGND sg13g2_decap_8
XFILLER_31_371 VPWR VGND sg13g2_decap_8
XFILLER_104_1117 VPWR VGND sg13g2_decap_8
XFILLER_108_1297 VPWR VGND sg13g2_fill_1
X_19249_ _19249_/Y _19248_/Y _23190_/Q VPWR VGND sg13g2_nand2b_1
X_22260_ _24118_/D _22260_/A1 _22315_/S _22259_/Y VPWR VGND sg13g2_o21ai_1
X_21211_ _23629_/D _23629_/Q _21343_/A0 _21220_/S VPWR VGND sg13g2_mux2_1
X_22191_ _22191_/Y _24085_/Q _22203_/B VPWR VGND sg13g2_nand2_1
XFILLER_12_1792 VPWR VGND sg13g2_decap_8
X_21142_ _21142_/Y _23596_/Q _21151_/B VPWR VGND sg13g2_nand2_1
XFILLER_105_649 VPWR VGND sg13g2_decap_8
XFILLER_82_1702 VPWR VGND sg13g2_fill_1
XFILLER_104_126 VPWR VGND sg13g2_decap_4
XFILLER_28_1221 VPWR VGND sg13g2_fill_1
XFILLER_63_1112 VPWR VGND sg13g2_decap_8
X_21073_ _23567_/D _23567_/Q _22309_/A0 _21082_/B VPWR VGND sg13g2_mux2_1
XFILLER_115_1213 VPWR VGND sg13g2_decap_8
XFILLER_101_822 VPWR VGND sg13g2_decap_4
XFILLER_98_371 VPWR VGND sg13g2_decap_4
XFILLER_8_1337 VPWR VGND sg13g2_fill_2
XFILLER_59_736 VPWR VGND sg13g2_decap_8
XFILLER_8_1359 VPWR VGND sg13g2_decap_8
XFILLER_63_1178 VPWR VGND sg13g2_fill_2
XFILLER_100_343 VPWR VGND sg13g2_decap_8
XFILLER_58_257 VPWR VGND sg13g2_decap_8
XFILLER_74_717 VPWR VGND sg13g2_fill_2
XFILLER_101_888 VPWR VGND sg13g2_fill_2
XFILLER_86_588 VPWR VGND sg13g2_fill_2
XFILLER_39_493 VPWR VGND sg13g2_decap_8
X_21975_ _23983_/D _21975_/A0 _23983_/Q _21981_/S VPWR VGND sg13g2_mux2_1
XFILLER_92_17 VPWR VGND sg13g2_fill_1
X_23714_ _23714_/Q clkload39/A _23714_/D fanout2739/X VPWR VGND sg13g2_dfrbpq_1
X_20926_ _20926_/Y _23509_/Q _20930_/B VPWR VGND sg13g2_nand2_1
XFILLER_26_154 VPWR VGND sg13g2_fill_2
XFILLER_110_1880 VPWR VGND sg13g2_decap_8
XFILLER_26_165 VPWR VGND sg13g2_decap_8
XFILLER_58_1940 VPWR VGND sg13g2_decap_8
XFILLER_54_485 VPWR VGND sg13g2_fill_1
XFILLER_93_1853 VPWR VGND sg13g2_fill_1
X_23645_ _23645_/Q clkload53/A _23645_/D fanout2778/X VPWR VGND sg13g2_dfrbpq_1
XFILLER_39_1350 VPWR VGND sg13g2_decap_4
XFILLER_23_850 VPWR VGND sg13g2_decap_8
XFILLER_93_1886 VPWR VGND sg13g2_decap_4
XFILLER_41_157 VPWR VGND sg13g2_decap_8
XFILLER_106_1916 VPWR VGND sg13g2_decap_8
XFILLER_39_1394 VPWR VGND sg13g2_decap_8
X_23576_ _23576_/Q clkload57/A _23576_/D fanout2767/X VPWR VGND sg13g2_dfrbpq_1
X_11590_ _11590_/Y _14119_/B _11581_/Y _14080_/B _14080_/A _11589_/X VPWR VGND sg13g2_a221oi_1
XFILLER_35_1247 VPWR VGND sg13g2_decap_8
XFILLER_22_382 VPWR VGND sg13g2_fill_2
X_22527_ _22527_/Q _22941_/CLK _22527_/D fanout2803/X VPWR VGND sg13g2_dfrbpq_1
X_13260_ _13260_/Y _13260_/A1 _23466_/Q _13259_/Y VPWR VGND sg13g2_o21ai_1
XFILLER_52_1594 VPWR VGND sg13g2_fill_2
X_22458_ _22458_/Q clkload28/A _22458_/D fanout2855/X VPWR VGND sg13g2_dfrbpq_1
XFILLER_41_87 VPWR VGND sg13g2_decap_8
X_12211_ _12218_/A _12788_/B _12211_/B VPWR VGND sg13g2_nor2_1
X_21409_ _23723_/D _21677_/A1 _21422_/B _21408_/Y VPWR VGND sg13g2_o21ai_1
XFILLER_108_465 VPWR VGND sg13g2_decap_4
X_13191_ _13191_/Y _13794_/S _13190_/X _13191_/B1 VPWR VGND sg13g2_o21ai_1
X_22389_ _22389_/Y _24181_/Q _22393_/B VPWR VGND sg13g2_nand2_1
X_12142_ _12143_/B _23740_/Q _23868_/Q _12146_/S VPWR VGND sg13g2_mux2_1
XFILLER_29_1018 VPWR VGND sg13g2_decap_8
X_24128_ _24128_/Q clkload43/A _24128_/D fanout2769/X VPWR VGND sg13g2_dfrbpq_1
Xfanout2702 fanout2702/X fanout2705/X VPWR VGND sg13g2_buf_1
XFILLER_46_1310 VPWR VGND sg13g2_decap_4
Xfanout2713 fanout2713/X fanout2717/X VPWR VGND sg13g2_buf_1
XFILLER_68_1089 VPWR VGND sg13g2_decap_8
Xfanout2724 fanout2724/X fanout2743/X VPWR VGND sg13g2_buf_1
Xfanout2735 fanout2735/X fanout2737/X VPWR VGND sg13g2_buf_1
X_24059_ _24059_/Q clkload48/A _24059_/D fanout2755/X VPWR VGND sg13g2_dfrbpq_1
X_16950_ _22700_/D _16946_/S _16948_/Y _16949_/Y VPWR VGND sg13g2_o21ai_1
XFILLER_81_1223 VPWR VGND sg13g2_decap_8
Xfanout2746 fanout2746/X fanout2768/X VPWR VGND sg13g2_buf_1
Xfanout2757 fanout2757/X fanout2759/X VPWR VGND sg13g2_buf_1
Xfanout2768 fanout2768/X fanout2791/X VPWR VGND sg13g2_buf_1
XFILLER_42_1207 VPWR VGND sg13g2_fill_2
Xfanout2779 fanout2779/X fanout2780/X VPWR VGND sg13g2_buf_1
X_15901_ _15901_/Y _22742_/Q _15901_/A2 _15901_/B1 _22678_/Q VPWR VGND sg13g2_a22oi_1
X_16881_ _16907_/C _22686_/Q _22685_/Q _22684_/Q VPWR VGND sg13g2_and3_1
XFILLER_81_1267 VPWR VGND sg13g2_decap_8
XFILLER_103_181 VPWR VGND sg13g2_fill_2
XFILLER_77_544 VPWR VGND sg13g2_fill_2
XFILLER_8_1860 VPWR VGND sg13g2_decap_8
XFILLER_24_1641 VPWR VGND sg13g2_fill_1
XFILLER_106_91 VPWR VGND sg13g2_decap_8
X_18620_ _18620_/Y _18757_/A _18619_/Y _23002_/Q VPWR VGND sg13g2_a21oi_1
X_15832_ _15837_/B _15944_/A _15832_/B VPWR VGND sg13g2_or2_1
XFILLER_66_40 VPWR VGND sg13g2_decap_4
XFILLER_92_503 VPWR VGND sg13g2_fill_2
XFILLER_18_600 VPWR VGND sg13g2_decap_4
XFILLER_49_279 VPWR VGND sg13g2_decap_8
XFILLER_115_1791 VPWR VGND sg13g2_decap_8
XFILLER_4_1746 VPWR VGND sg13g2_decap_8
XFILLER_46_920 VPWR VGND sg13g2_decap_8
XFILLER_24_1696 VPWR VGND sg13g2_decap_8
XFILLER_64_238 VPWR VGND sg13g2_decap_8
X_18551_ _18551_/Y _18494_/A _18007_/Y _18479_/X VPWR VGND sg13g2_a21oi_1
X_15763_ _15773_/B _15984_/A _15763_/B VPWR VGND sg13g2_or2_1
X_12975_ _12976_/B _12971_/X _12972_/X _12973_/X _12974_/X _12126_/A _12889_/A VPWR
+ VGND sg13g2_mux4_1
XFILLER_111_1666 VPWR VGND sg13g2_decap_4
XFILLER_79_1152 VPWR VGND sg13g2_fill_1
XFILLER_73_750 VPWR VGND sg13g2_decap_8
XFILLER_61_901 VPWR VGND sg13g2_decap_4
X_14714_ _14714_/Y _14714_/A1 _14714_/A2 _14713_/Y VPWR VGND sg13g2_o21ai_1
X_17502_ _22868_/D _17920_/B2 _22868_/Q _17502_/S VPWR VGND sg13g2_mux2_1
X_11926_ _11926_/X _11923_/X _11924_/X _11926_/S VPWR VGND sg13g2_mux2_1
X_18482_ _18483_/C _18224_/B _18530_/B _18406_/A VPWR VGND sg13g2_o21ai_1
X_15694_ _15694_/X _17141_/A _22467_/Q _15694_/S VPWR VGND sg13g2_mux2_1
XFILLER_61_934 VPWR VGND sg13g2_decap_8
XFILLER_33_636 VPWR VGND sg13g2_decap_4
XFILLER_75_1038 VPWR VGND sg13g2_decap_8
X_17433_ _17433_/Y _17433_/A _17437_/B VPWR VGND sg13g2_nand2_1
X_14645_ _14645_/Y _14645_/A _14718_/B VPWR VGND sg13g2_nand2_1
XFILLER_72_1904 VPWR VGND sg13g2_decap_8
X_11857_ _11857_/Y _11857_/A _11857_/B _11857_/C _11857_/D VPWR VGND sg13g2_nor4_1
XFILLER_32_135 VPWR VGND sg13g2_fill_2
XFILLER_61_967 VPWR VGND sg13g2_fill_1
XFILLER_33_669 VPWR VGND sg13g2_decap_8
XFILLER_109_1540 VPWR VGND sg13g2_fill_2
XFILLER_14_872 VPWR VGND sg13g2_decap_4
XFILLER_20_308 VPWR VGND sg13g2_decap_8
X_17364_ _17364_/Y _17364_/A _17367_/B VPWR VGND sg13g2_nand2_1
XFILLER_60_477 VPWR VGND sg13g2_decap_8
Xplace4308 _13006_/S0 _12651_/S0 VPWR VGND sg13g2_buf_4
XFILLER_60_488 VPWR VGND sg13g2_fill_2
XFILLER_105_1404 VPWR VGND sg13g2_fill_1
Xplace4319 _11762_/B _12293_/A VPWR VGND sg13g2_buf_1
X_11788_ _11789_/B _24185_/Q _23321_/Q _11792_/S VPWR VGND sg13g2_mux2_1
Xrebuffer5309 _13579_/A _12050_/Y VPWR VGND sg13g2_buf_1
X_19103_ _23087_/D _23087_/Q _19102_/X _19115_/S VPWR VGND sg13g2_mux2_1
XFILLER_13_393 VPWR VGND sg13g2_fill_1
X_13527_ _13530_/A _13528_/A _13528_/B _13528_/C VPWR VGND sg13g2_nor3_1
Xplace3607 _16304_/A _14407_/X VPWR VGND sg13g2_buf_1
X_17295_ _17295_/Y _17295_/A _17302_/S VPWR VGND sg13g2_nand2_1
Xplace3618 _19704_/A _19708_/S VPWR VGND sg13g2_buf_1
XFILLER_9_364 VPWR VGND sg13g2_fill_2
Xrebuffer4608 _15058_/A1 _13604_/Y VPWR VGND sg13g2_buf_8
Xplace3629 _15901_/B1 _15946_/B1 VPWR VGND sg13g2_buf_1
X_19034_ _19035_/C _23060_/Q _19045_/B _19045_/C VPWR VGND sg13g2_or3_1
Xrebuffer4619 _12829_/C _12849_/B VPWR VGND sg13g2_buf_1
XFILLER_16_1180 VPWR VGND sg13g2_decap_8
X_16246_ _16248_/B _16253_/C _16250_/A VPWR VGND sg13g2_nor2b_1
XFILLER_51_1071 VPWR VGND sg13g2_decap_8
X_13458_ _13469_/B _13637_/A1 _13455_/X _13457_/X VPWR VGND sg13g2_o21ai_1
Xplace2939 _19086_/S _19078_/S VPWR VGND sg13g2_buf_1
XFILLER_86_1112 VPWR VGND sg13g2_fill_1
X_12409_ _12409_/X _23423_/Q _23455_/Q _23487_/Q _23519_/Q _13006_/S0 _12409_/S1 VPWR
+ VGND sg13g2_mux4_1
X_16177_ _16177_/Y _16177_/A _16177_/B VPWR VGND sg13g2_nand2_1
X_13389_ _13389_/X _24172_/Q _24204_/Q _23244_/Q _23276_/Q _13555_/S0 _13016_/S VPWR
+ VGND sg13g2_mux4_1
XFILLER_114_424 VPWR VGND sg13g2_decap_8
X_15128_ _15128_/Y _24230_/Q _14825_/A _24229_/D _19150_/A _24232_/Q VPWR VGND sg13g2_a221oi_1
XFILLER_47_1107 VPWR VGND sg13g2_decap_8
XFILLER_29_1530 VPWR VGND sg13g2_decap_4
X_19936_ _19936_/Y _20060_/A _19936_/B VPWR VGND sg13g2_nand2_1
X_15059_ _15060_/B _17911_/A1 _15107_/A2 _15070_/B VPWR VGND sg13g2_o21ai_1
XFILLER_64_1432 VPWR VGND sg13g2_decap_8
X_19867_ _19867_/Y _19872_/A _19867_/B VPWR VGND sg13g2_nand2_1
XFILLER_110_641 VPWR VGND sg13g2_decap_8
XFILLER_68_566 VPWR VGND sg13g2_decap_8
XFILLER_112_1419 VPWR VGND sg13g2_decap_4
XFILLER_56_717 VPWR VGND sg13g2_decap_8
X_18818_ _18820_/B _18816_/Y _18817_/Y _18824_/S VPWR VGND sg13g2_mux2_1
XFILLER_42_1752 VPWR VGND sg13g2_decap_8
XFILLER_68_577 VPWR VGND sg13g2_fill_1
X_19798_ _19798_/X _20082_/A _19793_/X _19797_/Y VPWR VGND sg13g2_a21o_1
XFILLER_49_780 VPWR VGND sg13g2_decap_8
XFILLER_55_227 VPWR VGND sg13g2_decap_8
XFILLER_37_942 VPWR VGND sg13g2_decap_4
X_18749_ _23027_/D _15960_/Y _18745_/Y _18747_/Y _18748_/Y VPWR VGND sg13g2_a22oi_1
XFILLER_3_1256 VPWR VGND sg13g2_decap_8
XFILLER_97_1252 VPWR VGND sg13g2_decap_8
XFILLER_36_441 VPWR VGND sg13g2_decap_8
XFILLER_37_997 VPWR VGND sg13g2_decap_8
Xclkbuf_leaf_20_clk_i clkload30/A clkload1/A VPWR VGND sg13g2_buf_16
XFILLER_102_49 VPWR VGND sg13g2_decap_8
XFILLER_24_625 VPWR VGND sg13g2_fill_1
XFILLER_19_1209 VPWR VGND sg13g2_decap_8
XFILLER_51_422 VPWR VGND sg13g2_decap_8
X_20711_ _23410_/D _20329_/Y _20710_/B _20710_/Y VPWR VGND sg13g2_o21ai_1
XFILLER_63_293 VPWR VGND sg13g2_decap_8
X_21691_ _23860_/D _21983_/A1 _21687_/B _21690_/Y VPWR VGND sg13g2_o21ai_1
XFILLER_23_146 VPWR VGND sg13g2_fill_1
X_23430_ _23430_/Q clkload42/A _23430_/D fanout2720/X VPWR VGND sg13g2_dfrbpq_1
XFILLER_11_319 VPWR VGND sg13g2_fill_2
X_20642_ _23376_/D _21977_/A1 _20647_/B _20641_/Y VPWR VGND sg13g2_o21ai_1
XFILLER_36_1545 VPWR VGND sg13g2_fill_1
Xclkbuf_leaf_35_clk_i clkload53/A clkbuf_leaf_42_clk_i/A VPWR VGND sg13g2_buf_16
X_20573_ _23342_/D _22442_/A1 _20572_/B _20572_/Y VPWR VGND sg13g2_o21ai_1
X_23361_ _23361_/Q _23682_/CLK _23361_/D fanout2722/X VPWR VGND sg13g2_dfrbpq_1
X_22312_ _24145_/D _22446_/A1 _24145_/Q _22315_/S VPWR VGND sg13g2_mux2_1
XFILLER_88_1900 VPWR VGND sg13g2_decap_4
XFILLER_30_1111 VPWR VGND sg13g2_fill_2
X_23292_ _23292_/Q clkload55/A _23292_/D fanout2779/X VPWR VGND sg13g2_dfrbpq_1
XFILLER_14_1865 VPWR VGND sg13g2_decap_8
XFILLER_10_1729 VPWR VGND sg13g2_fill_2
X_22243_ _24111_/D _22309_/A0 _24111_/Q _22243_/S VPWR VGND sg13g2_mux2_1
XFILLER_105_402 VPWR VGND sg13g2_decap_4
XFILLER_84_1819 VPWR VGND sg13g2_decap_4
XFILLER_69_1365 VPWR VGND sg13g2_decap_8
Xhold4810 _22039_/A _24014_/Q VPWR VGND sg13g2_dlygate4sd3_1
X_22174_ _24077_/D _24077_/Q _22440_/A1 _22183_/S VPWR VGND sg13g2_mux2_1
Xhold4821 _21738_/A _23874_/Q VPWR VGND sg13g2_dlygate4sd3_1
Xhold4832 _21396_/A _23717_/Q VPWR VGND sg13g2_dlygate4sd3_1
Xhold4843 _22023_/A _24005_/Q VPWR VGND sg13g2_dlygate4sd3_1
Xhold4854 _21177_/A _23613_/Q VPWR VGND sg13g2_dlygate4sd3_1
X_21125_ _23587_/D _21325_/A1 _21130_/B _21124_/Y VPWR VGND sg13g2_o21ai_1
Xhold4865 _21681_/A _23854_/Q VPWR VGND sg13g2_dlygate4sd3_1
Xhold4876 _22380_/A _24178_/Q VPWR VGND sg13g2_dlygate4sd3_1
Xhold4887 _22229_/A _24103_/Q VPWR VGND sg13g2_dlygate4sd3_1
XFILLER_87_831 VPWR VGND sg13g2_decap_8
XFILLER_82_1565 VPWR VGND sg13g2_fill_2
XFILLER_28_1062 VPWR VGND sg13g2_fill_2
Xhold4898 _22162_/A _24071_/Q VPWR VGND sg13g2_dlygate4sd3_1
XFILLER_8_1134 VPWR VGND sg13g2_fill_1
X_21056_ _21082_/B _21984_/A _22119_/A VPWR VGND sg13g2_and2_1
XFILLER_47_1696 VPWR VGND sg13g2_fill_2
XFILLER_86_330 VPWR VGND sg13g2_fill_2
XFILLER_87_864 VPWR VGND sg13g2_decap_8
XFILLER_43_1549 VPWR VGND sg13g2_fill_2
X_20007_ _20007_/Y _20082_/A _19737_/A _20006_/Y VPWR VGND sg13g2_o21ai_1
XFILLER_115_1065 VPWR VGND sg13g2_decap_8
XFILLER_101_663 VPWR VGND sg13g2_decap_8
XFILLER_101_674 VPWR VGND sg13g2_fill_1
XFILLER_60_1852 VPWR VGND sg13g2_fill_2
XFILLER_74_514 VPWR VGND sg13g2_decap_8
XFILLER_112_1931 VPWR VGND sg13g2_decap_8
XFILLER_101_696 VPWR VGND sg13g2_decap_4
XFILLER_60_1863 VPWR VGND sg13g2_fill_1
XFILLER_21_1825 VPWR VGND sg13g2_decap_8
XFILLER_36_43 VPWR VGND sg13g2_fill_1
XFILLER_43_912 VPWR VGND sg13g2_decap_8
XFILLER_28_997 VPWR VGND sg13g2_decap_8
X_12760_ _12761_/C _20035_/B _12632_/D _12759_/Y VPWR VGND sg13g2_o21ai_1
XFILLER_36_76 VPWR VGND sg13g2_fill_2
X_21958_ _23973_/D _21958_/A1 _21957_/B _21957_/Y VPWR VGND sg13g2_o21ai_1
XFILLER_55_783 VPWR VGND sg13g2_decap_8
XFILLER_15_625 VPWR VGND sg13g2_decap_8
XFILLER_70_720 VPWR VGND sg13g2_decap_8
X_11711_ _11716_/C _12473_/A _11711_/B VPWR VGND sg13g2_nor2_1
X_20909_ _23501_/D _22440_/A1 _23501_/Q _20918_/S VPWR VGND sg13g2_mux2_1
X_12691_ _12692_/B _12691_/A _12691_/B _12691_/C _12691_/D VPWR VGND sg13g2_nor4_1
XFILLER_15_669 VPWR VGND sg13g2_decap_8
X_21889_ _21889_/Y _21889_/A _21893_/B VPWR VGND sg13g2_nand2_1
XFILLER_70_764 VPWR VGND sg13g2_decap_8
X_14430_ _14578_/B _14430_/A _14430_/B _14430_/C _17041_/C VPWR VGND sg13g2_nor4_1
XFILLER_106_1702 VPWR VGND sg13g2_decap_8
XFILLER_19_1754 VPWR VGND sg13g2_decap_8
X_23628_ _23628_/Q clkload36/A _23628_/D fanout2710/X VPWR VGND sg13g2_dfrbpq_1
X_11642_ _14634_/B _11500_/X _11501_/X _11528_/Y VPWR VGND sg13g2_a21o_1
XFILLER_54_1645 VPWR VGND sg13g2_decap_8
XFILLER_52_64 VPWR VGND sg13g2_fill_1
XFILLER_106_1746 VPWR VGND sg13g2_fill_1
X_14361_ _14361_/Y _15393_/A _15187_/C VPWR VGND sg13g2_nor2_1
XFILLER_106_1757 VPWR VGND sg13g2_decap_8
X_23559_ _23559_/Q _24170_/CLK _23559_/D fanout2708/X VPWR VGND sg13g2_dfrbpq_1
XFILLER_11_875 VPWR VGND sg13g2_decap_8
X_16100_ _22493_/D _16209_/B _16098_/Y _16099_/Y VPWR VGND sg13g2_o21ai_1
XFILLER_89_1719 VPWR VGND sg13g2_decap_4
X_13312_ _13312_/X _23243_/Q _23275_/Q _23371_/Q _23403_/Q _13978_/S0 _13689_/S1 VPWR
+ VGND sg13g2_mux4_1
XFILLER_32_1943 VPWR VGND sg13g2_decap_8
X_17080_ _17080_/Y _17080_/A _17080_/B VPWR VGND sg13g2_nor2_1
XFILLER_10_363 VPWR VGND sg13g2_decap_4
X_14292_ _16852_/A _19346_/A _15257_/A _14336_/C VPWR VGND sg13g2_nand3_1
XFILLER_6_323 VPWR VGND sg13g2_fill_1
XFILLER_32_1954 VPWR VGND sg13g2_fill_1
XFILLER_6_345 VPWR VGND sg13g2_decap_8
X_16031_ _16031_/Y _16856_/A _16364_/B _16084_/C VPWR VGND sg13g2_nor3_1
X_13243_ _13243_/X _23434_/Q _23466_/Q _23498_/Q _23530_/Q _13243_/S0 _13243_/S1 VPWR
+ VGND sg13g2_mux4_1
XFILLER_104_1492 VPWR VGND sg13g2_decap_8
XFILLER_48_1405 VPWR VGND sg13g2_fill_2
XFILLER_108_295 VPWR VGND sg13g2_decap_8
X_13174_ _13174_/Y _23561_/Q _13975_/A2 _13173_/X _13774_/A VPWR VGND sg13g2_a22oi_1
X_12125_ _12126_/B _24156_/Q _23228_/Q _23292_/Q _23356_/Q _11797_/S _11792_/S VPWR
+ VGND sg13g2_mux4_1
X_17982_ _17982_/Y _18048_/S _17982_/B VPWR VGND sg13g2_nand2b_1
XFILLER_2_562 VPWR VGND sg13g2_decap_4
XFILLER_46_1140 VPWR VGND sg13g2_fill_2
XFILLER_78_831 VPWR VGND sg13g2_decap_8
XFILLER_61_1605 VPWR VGND sg13g2_decap_8
XFILLER_78_842 VPWR VGND sg13g2_fill_1
X_19721_ _20304_/B _19721_/A _19721_/B VPWR VGND sg13g2_nor2_1
X_16933_ _16947_/C _22696_/Q _16933_/B VPWR VGND sg13g2_nand2_1
X_12056_ _12056_/X _23419_/Q _23451_/Q _23483_/Q _23515_/Q _12246_/S _12297_/S1 VPWR
+ VGND sg13g2_mux4_1
XFILLER_6_1819 VPWR VGND sg13g2_decap_8
XFILLER_28_7 VPWR VGND sg13g2_decap_4
XFILLER_78_864 VPWR VGND sg13g2_fill_1
XFILLER_26_1769 VPWR VGND sg13g2_decap_8
XFILLER_77_352 VPWR VGND sg13g2_decap_8
XFILLER_78_886 VPWR VGND sg13g2_fill_1
X_19652_ _19652_/Y _19696_/B _19652_/B VPWR VGND sg13g2_nand2_1
XFILLER_38_728 VPWR VGND sg13g2_decap_4
X_16864_ _16864_/Y _16864_/A _17032_/B VPWR VGND sg13g2_nor2_1
XFILLER_4_1521 VPWR VGND sg13g2_decap_4
XFILLER_24_1460 VPWR VGND sg13g2_decap_8
XFILLER_20_1302 VPWR VGND sg13g2_decap_4
XFILLER_93_856 VPWR VGND sg13g2_fill_1
X_15815_ _15816_/B _15815_/A _15815_/B _15815_/C _15815_/D VPWR VGND sg13g2_and4_1
X_19583_ _19703_/B _19582_/A _19457_/Y _19582_/Y VPWR VGND sg13g2_a21oi_1
X_16795_ _16796_/D _22669_/Q _22668_/Q _22667_/Q VPWR VGND sg13g2_nand3_1
XFILLER_18_430 VPWR VGND sg13g2_decap_8
XFILLER_92_355 VPWR VGND sg13g2_decap_8
XFILLER_19_964 VPWR VGND sg13g2_decap_4
XFILLER_80_506 VPWR VGND sg13g2_fill_1
XFILLER_52_208 VPWR VGND sg13g2_fill_2
X_15746_ _15753_/A _22929_/Q _15924_/B _15745_/Y VPWR VGND sg13g2_a21oi_1
XFILLER_0_1429 VPWR VGND sg13g2_decap_4
XFILLER_4_1598 VPWR VGND sg13g2_decap_8
X_18534_ _18534_/Y _18380_/A _18527_/X _18531_/Y _18514_/A _18533_/Y VPWR VGND sg13g2_a221oi_1
XFILLER_34_912 VPWR VGND sg13g2_decap_8
X_12958_ _12958_/Y _15227_/A _19446_/A VPWR VGND sg13g2_nand2b_1
XFILLER_45_260 VPWR VGND sg13g2_fill_1
XFILLER_93_82 VPWR VGND sg13g2_decap_8
XFILLER_73_580 VPWR VGND sg13g2_decap_8
XFILLER_45_282 VPWR VGND sg13g2_decap_8
X_11909_ _11910_/C _11384_/Y _11905_/Y _11907_/Y _13234_/B2 VPWR VGND sg13g2_a22oi_1
XFILLER_33_433 VPWR VGND sg13g2_fill_1
XFILLER_61_742 VPWR VGND sg13g2_decap_8
X_15677_ _15678_/B _22732_/Q _15708_/A2 _15731_/B1 _22668_/Q VPWR VGND sg13g2_a22oi_1
X_18465_ _18465_/Y _18485_/B _18465_/B _18465_/C VPWR VGND sg13g2_nand3_1
XFILLER_33_444 VPWR VGND sg13g2_decap_8
X_12889_ _12895_/A _12889_/A _23909_/Q _12889_/C VPWR VGND sg13g2_nand3_1
XFILLER_21_617 VPWR VGND sg13g2_decap_8
X_17416_ _22827_/D _17902_/B2 _22827_/Q _17419_/B VPWR VGND sg13g2_mux2_1
XFILLER_61_786 VPWR VGND sg13g2_decap_4
X_18396_ _18396_/Y _18403_/A _18363_/Y _18406_/A VPWR VGND sg13g2_o21ai_1
XFILLER_33_488 VPWR VGND sg13g2_fill_1
XFILLER_60_274 VPWR VGND sg13g2_decap_8
XFILLER_21_639 VPWR VGND sg13g2_fill_1
Xplace4105 _14436_/A _22995_/Q VPWR VGND sg13g2_buf_1
XFILLER_33_1707 VPWR VGND sg13g2_decap_4
XFILLER_92_1193 VPWR VGND sg13g2_decap_8
XFILLER_20_127 VPWR VGND sg13g2_fill_1
Xplace4116 _12577_/B _22988_/Q VPWR VGND sg13g2_buf_1
X_17347_ _22800_/D _16136_/A _17358_/B _17346_/Y VPWR VGND sg13g2_o21ai_1
Xplace4127 _13708_/B _11456_/B VPWR VGND sg13g2_buf_2
Xplace4138 _11810_/S _11295_/A VPWR VGND sg13g2_buf_1
X_14559_ _24227_/D _14825_/A _18880_/C _14559_/C VPWR VGND sg13g2_nor3_1
Xplace3404 _17351_/B _17321_/B VPWR VGND sg13g2_buf_1
Xplace4149 _13466_/A _13645_/A VPWR VGND sg13g2_buf_2
Xplace3415 _17300_/B _17270_/B VPWR VGND sg13g2_buf_1
XFILLER_105_1256 VPWR VGND sg13g2_decap_8
XFILLER_14_1139 VPWR VGND sg13g2_decap_8
Xplace3426 _16512_/B _16517_/S VPWR VGND sg13g2_buf_1
X_17278_ _22768_/D _16136_/A _17298_/B _17277_/Y VPWR VGND sg13g2_o21ai_1
Xplace3437 _17917_/B _17869_/B VPWR VGND sg13g2_buf_1
Xplace3448 _17721_/B _17652_/B VPWR VGND sg13g2_buf_1
Xplace3459 _17021_/B _17026_/B VPWR VGND sg13g2_buf_1
X_19017_ _19019_/B _19017_/A _19039_/B VPWR VGND sg13g2_nand2_1
X_16229_ _16229_/Y _22516_/Q _16241_/C _16228_/Y VPWR VGND sg13g2_o21ai_1
XFILLER_54_0 VPWR VGND sg13g2_decap_8
XFILLER_115_733 VPWR VGND sg13g2_decap_8
XFILLER_114_210 VPWR VGND sg13g2_decap_8
XFILLER_100_1890 VPWR VGND sg13g2_decap_8
XFILLER_44_1814 VPWR VGND sg13g2_decap_4
XFILLER_64_1251 VPWR VGND sg13g2_fill_1
XFILLER_9_1454 VPWR VGND sg13g2_decap_8
XFILLER_25_1213 VPWR VGND sg13g2_decap_4
XFILLER_29_1393 VPWR VGND sg13g2_decap_8
XFILLER_44_1847 VPWR VGND sg13g2_fill_1
XFILLER_96_650 VPWR VGND sg13g2_fill_2
XFILLER_9_1476 VPWR VGND sg13g2_decap_8
XFILLER_5_1318 VPWR VGND sg13g2_fill_2
XFILLER_84_812 VPWR VGND sg13g2_decap_8
XFILLER_5_1329 VPWR VGND sg13g2_decap_8
X_22930_ _22930_/Q _22941_/CLK _22930_/D fanout2795/X VPWR VGND sg13g2_dfrbpq_1
XFILLER_111_994 VPWR VGND sg13g2_decap_8
XFILLER_96_694 VPWR VGND sg13g2_fill_2
XFILLER_28_227 VPWR VGND sg13g2_decap_8
XFILLER_68_396 VPWR VGND sg13g2_fill_1
X_22861_ _22861_/Q _22893_/CLK _22861_/D fanout2817/X VPWR VGND sg13g2_dfrbpq_1
XFILLER_56_558 VPWR VGND sg13g2_decap_8
X_21812_ _21812_/Y _21812_/A _21818_/B VPWR VGND sg13g2_nand2_1
XFILLER_83_399 VPWR VGND sg13g2_decap_8
X_22792_ _22792_/Q clkload18/A _22792_/D fanout2821/X VPWR VGND sg13g2_dfrbpq_1
XFILLER_58_1044 VPWR VGND sg13g2_decap_8
X_21743_ _23875_/D _21954_/A1 _21751_/B _21742_/Y VPWR VGND sg13g2_o21ai_1
XFILLER_52_775 VPWR VGND sg13g2_decap_8
XFILLER_90_1834 VPWR VGND sg13g2_decap_8
XFILLER_16_1905 VPWR VGND sg13g2_decap_8
XFILLER_12_639 VPWR VGND sg13g2_decap_8
X_21674_ _21674_/Y _21674_/A _21674_/B VPWR VGND sg13g2_nand2_1
XFILLER_55_1954 VPWR VGND sg13g2_fill_1
XFILLER_75_1380 VPWR VGND sg13g2_fill_1
X_23413_ _23413_/Q clkload58/A _23413_/D fanout2762/X VPWR VGND sg13g2_dfrbpq_1
X_20625_ _23366_/D _22427_/A1 _20624_/B _20624_/Y VPWR VGND sg13g2_o21ai_1
XFILLER_36_1375 VPWR VGND sg13g2_decap_8
XFILLER_7_109 VPWR VGND sg13g2_decap_8
X_23344_ _23344_/Q _24214_/CLK _23344_/D fanout2626/X VPWR VGND sg13g2_dfrbpq_1
X_20556_ _23333_/D _22425_/A1 _20565_/B _20555_/Y VPWR VGND sg13g2_o21ai_1
XFILLER_20_683 VPWR VGND sg13g2_decap_8
XFILLER_105_1790 VPWR VGND sg13g2_decap_8
Xplace3960 _17823_/A1 _17586_/A VPWR VGND sg13g2_buf_1
Xplace3971 _19041_/A _18886_/A VPWR VGND sg13g2_buf_1
X_23275_ _23275_/Q _24214_/CLK _23275_/D fanout2626/X VPWR VGND sg13g2_dfrbpq_1
Xplace3982 _14129_/A _11740_/Y VPWR VGND sg13g2_buf_2
X_20487_ _20511_/S _20649_/B _22318_/B VPWR VGND sg13g2_and2_1
Xplace3993 _13641_/A _13028_/B VPWR VGND sg13g2_buf_2
XFILLER_98_49 VPWR VGND sg13g2_decap_8
X_22226_ _24101_/D _22292_/A1 _22229_/B _22225_/Y VPWR VGND sg13g2_o21ai_1
XFILLER_79_606 VPWR VGND sg13g2_fill_1
XFILLER_3_359 VPWR VGND sg13g2_decap_8
Xhold4640 _17465_/A _22850_/Q VPWR VGND sg13g2_dlygate4sd3_1
Xhold4651 _17289_/A _22774_/Q VPWR VGND sg13g2_dlygate4sd3_1
X_22157_ _24068_/D _22356_/A1 _22168_/B _22156_/Y VPWR VGND sg13g2_o21ai_1
Xhold4662 _17300_/A _22780_/Q VPWR VGND sg13g2_dlygate4sd3_1
XFILLER_47_1460 VPWR VGND sg13g2_fill_1
Xhold4673 _17457_/A _22847_/Q VPWR VGND sg13g2_dlygate4sd3_1
Xhold4684 _17307_/A _22782_/Q VPWR VGND sg13g2_dlygate4sd3_1
X_21108_ _21108_/Y _21108_/A _21108_/B VPWR VGND sg13g2_nand2_1
Xhold4695 _17498_/A _22866_/Q VPWR VGND sg13g2_dlygate4sd3_1
XFILLER_82_1362 VPWR VGND sg13g2_decap_8
X_22088_ _24035_/D _22288_/A1 _22101_/B _22087_/Y VPWR VGND sg13g2_o21ai_1
X_13930_ _13946_/C _13930_/A _13930_/B VPWR VGND sg13g2_nand2_1
X_21039_ _23554_/D _22286_/A1 _21042_/B _21038_/Y VPWR VGND sg13g2_o21ai_1
XFILLER_25_1780 VPWR VGND sg13g2_fill_2
XFILLER_60_1660 VPWR VGND sg13g2_decap_8
XFILLER_47_558 VPWR VGND sg13g2_fill_1
X_13861_ _13861_/Y _13861_/A _20292_/A _13861_/C _13861_/D VPWR VGND sg13g2_nor4_1
XFILLER_5_1896 VPWR VGND sg13g2_decap_8
XFILLER_1_1727 VPWR VGND sg13g2_decap_8
X_15600_ _15602_/A _22890_/Q _15684_/B _15347_/Y _15599_/Y VPWR VGND sg13g2_a22oi_1
XFILLER_16_912 VPWR VGND sg13g2_fill_1
XFILLER_28_772 VPWR VGND sg13g2_fill_2
X_12812_ _12822_/B _13243_/S1 _12806_/X _12811_/Y VPWR VGND sg13g2_o21ai_1
XFILLER_41_1092 VPWR VGND sg13g2_decap_8
X_16580_ _16594_/A _22630_/Q _22629_/Q _22628_/Q VPWR VGND sg13g2_nand3_1
X_13792_ _13792_/X _23313_/Q _23345_/Q _23377_/Q _23409_/Q _13798_/B2 _13795_/S1 VPWR
+ VGND sg13g2_mux4_1
XFILLER_103_70 VPWR VGND sg13g2_decap_8
XFILLER_15_422 VPWR VGND sg13g2_decap_8
X_12743_ _12743_/X _12743_/A _12743_/B VPWR VGND sg13g2_or2_1
XFILLER_95_1778 VPWR VGND sg13g2_fill_1
XFILLER_42_230 VPWR VGND sg13g2_decap_8
XFILLER_31_915 VPWR VGND sg13g2_decap_8
XFILLER_63_63 VPWR VGND sg13g2_decap_8
X_18250_ _18250_/Y _22971_/Q _18565_/B VPWR VGND sg13g2_nand2_1
XFILLER_63_85 VPWR VGND sg13g2_decap_8
XFILLER_63_96 VPWR VGND sg13g2_fill_2
X_12674_ _12674_/Y _22988_/Q _13708_/B _12674_/C VPWR VGND sg13g2_nand3_1
XFILLER_19_1551 VPWR VGND sg13g2_fill_1
XFILLER_15_499 VPWR VGND sg13g2_fill_1
X_17201_ _17201_/Y _22743_/Q _17201_/B VPWR VGND sg13g2_xnor2_1
XFILLER_19_1573 VPWR VGND sg13g2_decap_8
X_14413_ _14472_/B _24232_/Q _18567_/B VPWR VGND sg13g2_nor2b_1
X_18181_ _18181_/Y _18498_/A _18363_/B VPWR VGND sg13g2_nand2_1
X_11625_ _13535_/A _11614_/B _11625_/B VPWR VGND sg13g2_nand2b_1
X_15393_ _15575_/B _15393_/A _15393_/B VPWR VGND sg13g2_nor2_1
XFILLER_15_1426 VPWR VGND sg13g2_decap_8
X_17132_ _17133_/A _22730_/Q VPWR VGND sg13g2_inv_1
X_11556_ _11556_/Y _11556_/A _23156_/Q VPWR VGND sg13g2_nor2b_1
XFILLER_106_1598 VPWR VGND sg13g2_decap_8
XFILLER_89_1538 VPWR VGND sg13g2_fill_2
X_17063_ _22718_/D _16879_/A _17062_/X _17080_/B VPWR VGND sg13g2_mux2_1
X_11487_ _11487_/X _23734_/Q _23798_/Q _23862_/Q _23958_/Q _11815_/S1 _11699_/S VPWR
+ VGND sg13g2_mux4_1
XFILLER_100_1131 VPWR VGND sg13g2_decap_8
XFILLER_7_698 VPWR VGND sg13g2_decap_8
X_16014_ _16014_/Y _16014_/A _16014_/B VPWR VGND sg13g2_nor2_1
X_13226_ _13226_/X _13778_/A1 _13923_/A2 _22569_/Q VPWR VGND sg13g2_a21o_1
XFILLER_87_1262 VPWR VGND sg13g2_fill_2
XFILLER_48_1213 VPWR VGND sg13g2_decap_4
X_13157_ _13157_/X _24169_/Q _24201_/Q _23241_/Q _23273_/Q _13983_/S0 _11390_/A VPWR
+ VGND sg13g2_mux4_1
XFILLER_69_105 VPWR VGND sg13g2_decap_4
XFILLER_97_414 VPWR VGND sg13g2_fill_1
XFILLER_88_82 VPWR VGND sg13g2_decap_8
XFILLER_26_1500 VPWR VGND sg13g2_fill_1
XFILLER_97_436 VPWR VGND sg13g2_decap_8
XFILLER_88_93 VPWR VGND sg13g2_fill_2
XFILLER_112_747 VPWR VGND sg13g2_decap_8
XFILLER_111_224 VPWR VGND sg13g2_decap_8
X_12108_ _12108_/Y _12966_/B _12097_/X _12105_/Y _12098_/X _12107_/X VPWR VGND sg13g2_a221oi_1
XFILLER_2_381 VPWR VGND sg13g2_fill_1
X_17965_ _17965_/Y _17965_/A _19120_/A1 VPWR VGND sg13g2_nor2b_1
X_13088_ _13098_/C _15690_/A _12948_/B _13070_/B VPWR VGND sg13g2_a21oi_1
XFILLER_111_257 VPWR VGND sg13g2_decap_4
XFILLER_61_1435 VPWR VGND sg13g2_decap_4
X_19704_ _19705_/C _19704_/A _19704_/B VPWR VGND sg13g2_nand2_1
X_16916_ _16916_/Y _17102_/A _16921_/S VPWR VGND sg13g2_nand2_1
X_12039_ _12039_/Y _12039_/A _12039_/B VPWR VGND sg13g2_nand2_2
XFILLER_78_672 VPWR VGND sg13g2_decap_8
XFILLER_22_1408 VPWR VGND sg13g2_fill_2
XFILLER_65_300 VPWR VGND sg13g2_fill_1
XFILLER_113_1536 VPWR VGND sg13g2_fill_1
XFILLER_93_620 VPWR VGND sg13g2_fill_1
X_17896_ _17898_/A _17896_/A1 _17918_/A2 _17920_/B1 _17164_/A VPWR VGND sg13g2_a22oi_1
XFILLER_26_1588 VPWR VGND sg13g2_fill_2
XFILLER_61_1468 VPWR VGND sg13g2_decap_8
X_19635_ _19635_/Y _19708_/S _19394_/B _19634_/X VPWR VGND sg13g2_a21oi_1
X_16847_ _22682_/D _16203_/A _16846_/A _16846_/Y VPWR VGND sg13g2_o21ai_1
XFILLER_93_664 VPWR VGND sg13g2_fill_1
XFILLER_20_1121 VPWR VGND sg13g2_fill_1
XFILLER_78_1921 VPWR VGND sg13g2_decap_8
XFILLER_0_1204 VPWR VGND sg13g2_fill_1
XFILLER_0_1215 VPWR VGND sg13g2_fill_2
X_19566_ _19566_/X _19869_/A _19566_/B VPWR VGND sg13g2_and2_1
X_16778_ _16785_/A _16778_/A _16790_/A _16778_/C _16778_/D VPWR VGND sg13g2_nand4_1
XFILLER_19_794 VPWR VGND sg13g2_decap_8
XFILLER_18_271 VPWR VGND sg13g2_decap_4
XFILLER_18_293 VPWR VGND sg13g2_fill_1
XFILLER_20_1187 VPWR VGND sg13g2_decap_8
X_18517_ _18517_/Y _18517_/A _18517_/B VPWR VGND sg13g2_nand2_1
XFILLER_94_1255 VPWR VGND sg13g2_fill_1
X_15729_ _15734_/B _15944_/A _15729_/B VPWR VGND sg13g2_or2_1
X_19497_ _19497_/X _24213_/Q _20071_/A VPWR VGND sg13g2_or2_1
XFILLER_33_241 VPWR VGND sg13g2_fill_1
XFILLER_59_1386 VPWR VGND sg13g2_decap_8
XFILLER_61_550 VPWR VGND sg13g2_fill_1
X_18448_ _18449_/B _18476_/A _18447_/X _18210_/B VPWR VGND sg13g2_o21ai_1
XFILLER_22_937 VPWR VGND sg13g2_decap_4
XFILLER_61_583 VPWR VGND sg13g2_fill_2
XFILLER_37_1651 VPWR VGND sg13g2_fill_2
XFILLER_18_1050 VPWR VGND sg13g2_decap_8
XFILLER_37_1673 VPWR VGND sg13g2_fill_2
X_18379_ _18381_/A _18404_/B _18379_/B VPWR VGND sg13g2_nand2_1
XFILLER_18_1094 VPWR VGND sg13g2_decap_4
Xplace3201 _22435_/A1 _20972_/A1 VPWR VGND sg13g2_buf_1
X_20410_ _20410_/Y _20410_/A _20412_/B VPWR VGND sg13g2_nand2_1
Xplace3212 _20144_/B _20269_/B VPWR VGND sg13g2_buf_1
X_21390_ _23714_/D _21952_/A1 _21389_/B _21389_/Y VPWR VGND sg13g2_o21ai_1
Xplace3223 _22402_/B _22385_/X VPWR VGND sg13g2_buf_1
Xplace3234 _21635_/B _21690_/B VPWR VGND sg13g2_buf_1
Xplace3245 _21205_/B _21209_/B VPWR VGND sg13g2_buf_1
Xplace3256 _22451_/A1 _20362_/Y VPWR VGND sg13g2_buf_1
Xplace3267 _22177_/A1 _22309_/A0 VPWR VGND sg13g2_buf_1
X_20341_ _20342_/C _20112_/A _19544_/Y _20340_/Y VPWR VGND sg13g2_o21ai_1
Xplace3278 _21898_/A0 _21964_/A0 VPWR VGND sg13g2_buf_1
XFILLER_11_1846 VPWR VGND sg13g2_decap_8
Xplace3289 _22356_/A1 _20101_/Y VPWR VGND sg13g2_buf_1
XFILLER_85_1914 VPWR VGND sg13g2_decap_4
X_23060_ _23060_/Q clkload12/A _23060_/D fanout2928/X VPWR VGND sg13g2_dfrbpq_1
X_20272_ _20272_/Y _20272_/A _20272_/B VPWR VGND sg13g2_nand2_1
XFILLER_115_530 VPWR VGND sg13g2_decap_8
XFILLER_85_1936 VPWR VGND sg13g2_decap_8
XFILLER_1_819 VPWR VGND sg13g2_fill_1
X_22011_ _22011_/Y _22011_/A _22017_/B VPWR VGND sg13g2_nand2_1
XFILLER_66_1357 VPWR VGND sg13g2_fill_1
XFILLER_88_425 VPWR VGND sg13g2_fill_1
XFILLER_102_235 VPWR VGND sg13g2_decap_8
XFILLER_57_801 VPWR VGND sg13g2_decap_4
XFILLER_102_279 VPWR VGND sg13g2_decap_8
X_23962_ _23962_/Q clkload58/A _23962_/D fanout2756/X VPWR VGND sg13g2_dfrbpq_1
XFILLER_25_1054 VPWR VGND sg13g2_fill_1
XFILLER_40_1508 VPWR VGND sg13g2_decap_8
XFILLER_9_1295 VPWR VGND sg13g2_decap_8
XFILLER_25_1076 VPWR VGND sg13g2_decap_4
XFILLER_68_182 VPWR VGND sg13g2_decap_4
XFILLER_5_1159 VPWR VGND sg13g2_decap_8
XFILLER_22_1931 VPWR VGND sg13g2_decap_8
XFILLER_25_1087 VPWR VGND sg13g2_decap_8
XFILLER_56_333 VPWR VGND sg13g2_fill_2
X_22913_ _22913_/Q _22917_/CLK _22913_/D fanout2871/X VPWR VGND sg13g2_dfrbpq_1
XFILLER_84_653 VPWR VGND sg13g2_decap_8
X_23893_ _23893_/Q clkload47/A _23893_/D fanout2680/X VPWR VGND sg13g2_dfrbpq_1
XFILLER_17_709 VPWR VGND sg13g2_fill_2
XFILLER_84_675 VPWR VGND sg13g2_fill_2
XFILLER_16_208 VPWR VGND sg13g2_decap_8
XFILLER_71_303 VPWR VGND sg13g2_decap_8
X_22844_ _22844_/Q _22917_/CLK _22844_/D fanout2896/X VPWR VGND sg13g2_dfrbpq_1
XFILLER_77_1431 VPWR VGND sg13g2_decap_8
XFILLER_71_325 VPWR VGND sg13g2_decap_8
XFILLER_25_720 VPWR VGND sg13g2_decap_8
XFILLER_25_731 VPWR VGND sg13g2_fill_2
XFILLER_71_336 VPWR VGND sg13g2_fill_2
XFILLER_17_89 VPWR VGND sg13g2_fill_1
X_22775_ _22775_/Q _22893_/CLK _22775_/D fanout2818/X VPWR VGND sg13g2_dfrbpq_1
XFILLER_77_1486 VPWR VGND sg13g2_decap_8
XFILLER_13_915 VPWR VGND sg13g2_fill_2
XFILLER_38_1448 VPWR VGND sg13g2_fill_1
X_21726_ _23870_/D _21943_/A1 _21725_/B _21725_/Y VPWR VGND sg13g2_o21ai_1
XFILLER_13_937 VPWR VGND sg13g2_decap_8
XFILLER_38_1459 VPWR VGND sg13g2_fill_1
XFILLER_40_723 VPWR VGND sg13g2_decap_8
XFILLER_24_274 VPWR VGND sg13g2_decap_8
XFILLER_55_1740 VPWR VGND sg13g2_fill_1
XFILLER_24_285 VPWR VGND sg13g2_fill_2
XFILLER_33_33 VPWR VGND sg13g2_fill_2
XFILLER_40_734 VPWR VGND sg13g2_fill_2
XFILLER_12_436 VPWR VGND sg13g2_decap_4
XFILLER_90_1664 VPWR VGND sg13g2_fill_1
XFILLER_36_1161 VPWR VGND sg13g2_decap_8
X_21657_ _21657_/Y _21657_/A _21657_/B VPWR VGND sg13g2_nand2_1
XFILLER_55_1795 VPWR VGND sg13g2_fill_1
XFILLER_107_1874 VPWR VGND sg13g2_decap_8
X_11410_ _11410_/Y _11749_/S _23478_/Q _11409_/Y VPWR VGND sg13g2_o21ai_1
XFILLER_36_1194 VPWR VGND sg13g2_fill_2
X_20608_ _23358_/D _22211_/A1 _20607_/B _20607_/Y VPWR VGND sg13g2_o21ai_1
XFILLER_21_992 VPWR VGND sg13g2_decap_8
X_12390_ _12390_/X _23839_/Q _23871_/Q _23935_/Q _23967_/Q _12651_/S0 _12457_/S1 VPWR
+ VGND sg13g2_mux4_1
X_21588_ _21588_/Y _23809_/Q _21590_/B VPWR VGND sg13g2_nand2_1
XFILLER_71_1096 VPWR VGND sg13g2_decap_8
X_11341_ _11341_/X _23415_/Q _23447_/Q _23479_/Q _23511_/Q _11416_/B _12297_/S1 VPWR
+ VGND sg13g2_mux4_1
X_23327_ _23327_/Q clkload42/A _23327_/D fanout2728/X VPWR VGND sg13g2_dfrbpq_1
XFILLER_10_1301 VPWR VGND sg13g2_decap_8
Xrebuffer5470 place3556/A _13442_/Y VPWR VGND sg13g2_buf_2
Xrebuffer5481 place3603/A _14407_/X VPWR VGND sg13g2_buf_1
X_20539_ _20539_/Y _23326_/Q _20539_/B VPWR VGND sg13g2_nand2_1
Xrebuffer5492 _13546_/A _13541_/Y VPWR VGND sg13g2_buf_1
Xplace3790 _15257_/A _14034_/B VPWR VGND sg13g2_buf_1
XFILLER_49_1522 VPWR VGND sg13g2_decap_8
X_14060_ _14060_/X _14060_/A _14060_/B VPWR VGND sg13g2_xor2_1
X_23258_ _23258_/Q clkload54/A _23258_/D fanout2751/X VPWR VGND sg13g2_dfrbpq_1
XFILLER_10_1367 VPWR VGND sg13g2_decap_8
XFILLER_4_657 VPWR VGND sg13g2_decap_8
XFILLER_106_552 VPWR VGND sg13g2_decap_8
XFILLER_88_1593 VPWR VGND sg13g2_decap_8
Xhold5160 _21075_/A _23568_/Q VPWR VGND sg13g2_dlygate4sd3_1
XFILLER_3_145 VPWR VGND sg13g2_decap_8
Xhold5171 _21541_/A _23787_/Q VPWR VGND sg13g2_dlygate4sd3_1
X_22209_ _24093_/D _19921_/Y _22210_/B _22208_/Y VPWR VGND sg13g2_o21ai_1
Xhold5182 _21437_/A _23737_/Q VPWR VGND sg13g2_dlygate4sd3_1
X_23189_ _23189_/Q clkload12/A _23189_/D fanout2913/X VPWR VGND sg13g2_dfrbpq_1
Xhold5193 _21907_/A _23950_/Q VPWR VGND sg13g2_dlygate4sd3_1
XFILLER_0_830 VPWR VGND sg13g2_fill_1
XFILLER_95_918 VPWR VGND sg13g2_decap_4
XFILLER_7_1925 VPWR VGND sg13g2_decap_8
XFILLER_66_108 VPWR VGND sg13g2_decap_8
X_14962_ _16278_/C _14962_/A _14962_/B VPWR VGND sg13g2_and2_1
X_17750_ _17750_/Y _17169_/A _17824_/A2 _17824_/B1 _17749_/Y VPWR VGND sg13g2_a22oi_1
XFILLER_0_896 VPWR VGND sg13g2_fill_1
XFILLER_48_834 VPWR VGND sg13g2_fill_1
XFILLER_75_620 VPWR VGND sg13g2_decap_8
XFILLER_43_1176 VPWR VGND sg13g2_decap_8
XFILLER_47_322 VPWR VGND sg13g2_decap_8
XFILLER_114_1867 VPWR VGND sg13g2_decap_8
X_16701_ _16701_/Y _16707_/A _16701_/B VPWR VGND sg13g2_nor2_1
X_13913_ _13913_/X _23315_/Q _23347_/Q _23379_/Q _23411_/Q _13919_/S0 _13919_/S1 VPWR
+ VGND sg13g2_mux4_1
X_14893_ _14893_/Y _14982_/S _14890_/Y _14892_/Y VPWR VGND sg13g2_a21oi_1
X_17681_ _17681_/Y _17710_/A1 _17677_/Y _17680_/Y VPWR VGND sg13g2_o21ai_1
XFILLER_21_1430 VPWR VGND sg13g2_fill_2
XFILLER_75_675 VPWR VGND sg13g2_decap_8
XFILLER_114_91 VPWR VGND sg13g2_decap_8
XFILLER_5_1693 VPWR VGND sg13g2_decap_8
X_13844_ _14672_/A _13838_/X _13843_/X _13966_/B VPWR VGND sg13g2_mux2_2
X_16632_ _16632_/Y _16637_/S _16632_/B VPWR VGND sg13g2_nor2_1
XFILLER_16_731 VPWR VGND sg13g2_decap_8
XFILLER_90_667 VPWR VGND sg13g2_fill_2
X_19351_ _19351_/Y _19351_/A _19351_/B VPWR VGND sg13g2_nor2_1
X_13775_ _13775_/Y _13770_/A _13772_/X _13774_/X VPWR VGND sg13g2_a21oi_1
XFILLER_91_1406 VPWR VGND sg13g2_decap_4
XFILLER_43_561 VPWR VGND sg13g2_decap_4
X_18302_ _18334_/A _18501_/S _18302_/B VPWR VGND sg13g2_nor2_1
XFILLER_15_263 VPWR VGND sg13g2_fill_2
X_12726_ _20066_/A _12726_/A _12838_/B VPWR VGND sg13g2_nor2b_1
X_19282_ _23200_/D _23200_/Q _20284_/A1 _19299_/S VPWR VGND sg13g2_mux2_1
XFILLER_71_892 VPWR VGND sg13g2_decap_4
XFILLER_95_7 VPWR VGND sg13g2_decap_8
XFILLER_31_734 VPWR VGND sg13g2_fill_1
XFILLER_73_1840 VPWR VGND sg13g2_decap_4
Xinput4380 _20284_/A1 data_rdata_i[11] VPWR VGND sg13g2_buf_1
X_18233_ _18233_/Y _18427_/A _18395_/A _18224_/B _18290_/C VPWR VGND sg13g2_a22oi_1
X_15445_ _15451_/B _22457_/Q _15270_/A _15317_/Y _22593_/Q VPWR VGND sg13g2_a22oi_1
XFILLER_90_61 VPWR VGND sg13g2_decap_8
Xinput4391 _20316_/A3 data_rdata_i[21] VPWR VGND sg13g2_buf_1
X_12657_ _12657_/Y _24066_/Q _12997_/S VPWR VGND sg13g2_nand2b_1
XFILLER_73_1895 VPWR VGND sg13g2_fill_1
XFILLER_12_970 VPWR VGND sg13g2_fill_2
XFILLER_50_1114 VPWR VGND sg13g2_fill_2
XFILLER_89_1302 VPWR VGND sg13g2_decap_4
X_11608_ _11608_/X _14591_/A _11608_/B _14118_/B VPWR VGND sg13g2_and3_1
XFILLER_34_1879 VPWR VGND sg13g2_decap_8
X_12588_ _12589_/B _23713_/Q _23745_/Q _23777_/Q _23809_/Q _12651_/S0 _12651_/S1 VPWR
+ VGND sg13g2_mux4_1
X_17115_ _17177_/A _22727_/Q _17115_/B VPWR VGND sg13g2_nand2_1
XFILLER_15_1289 VPWR VGND sg13g2_decap_8
X_11539_ _11539_/Y _12039_/A _11539_/B VPWR VGND sg13g2_nand2_1
X_18095_ _18096_/D _18573_/A _18569_/C _18569_/B VPWR VGND sg13g2_a21oi_1
XFILLER_32_1570 VPWR VGND sg13g2_decap_4
XFILLER_32_1581 VPWR VGND sg13g2_decap_4
XFILLER_99_70 VPWR VGND sg13g2_decap_8
X_14258_ _14259_/D _14258_/A _14609_/B VPWR VGND sg13g2_nand2_1
X_13209_ _13210_/B _24201_/Q _23337_/Q _13213_/S VPWR VGND sg13g2_mux2_1
X_14189_ _14192_/A _14189_/A _14766_/A _14189_/C VPWR VGND sg13g2_and3_1
XFILLER_112_544 VPWR VGND sg13g2_decap_8
XFILLER_80_1833 VPWR VGND sg13g2_fill_2
X_18997_ _18997_/Y _19008_/A _18997_/B _18997_/C VPWR VGND sg13g2_nand3_1
XFILLER_98_789 VPWR VGND sg13g2_decap_8
XFILLER_79_970 VPWR VGND sg13g2_fill_1
XFILLER_6_1424 VPWR VGND sg13g2_decap_8
XFILLER_80_1866 VPWR VGND sg13g2_fill_1
XFILLER_79_992 VPWR VGND sg13g2_decap_8
X_17948_ _18331_/A _18393_/S _17945_/Y _17947_/Y VPWR VGND sg13g2_o21ai_1
XFILLER_39_823 VPWR VGND sg13g2_decap_4
XFILLER_113_1322 VPWR VGND sg13g2_decap_4
XFILLER_80_1888 VPWR VGND sg13g2_decap_8
XFILLER_17_0 VPWR VGND sg13g2_decap_8
XFILLER_6_1457 VPWR VGND sg13g2_decap_8
XFILLER_22_1227 VPWR VGND sg13g2_decap_4
XFILLER_26_1396 VPWR VGND sg13g2_decap_8
X_17879_ _17880_/A _17879_/A1 _17926_/A2 _17927_/B _22924_/Q _17878_/Y VPWR VGND sg13g2_a221oi_1
XFILLER_39_889 VPWR VGND sg13g2_decap_8
XFILLER_93_472 VPWR VGND sg13g2_fill_2
X_20890_ _20890_/Y _20890_/A _20903_/B VPWR VGND sg13g2_nand2_1
XFILLER_0_70 VPWR VGND sg13g2_fill_2
X_19549_ _19549_/X _19350_/X _19357_/Y _19589_/A VPWR VGND sg13g2_mux2_1
XFILLER_55_1003 VPWR VGND sg13g2_fill_1
XFILLER_74_1626 VPWR VGND sg13g2_decap_4
XFILLER_55_1014 VPWR VGND sg13g2_fill_2
X_22560_ _22560_/Q clkload26/A _22560_/D fanout2851/X VPWR VGND sg13g2_dfrbpq_1
XFILLER_74_1659 VPWR VGND sg13g2_decap_8
XFILLER_107_1104 VPWR VGND sg13g2_decap_8
XFILLER_110_49 VPWR VGND sg13g2_decap_8
XFILLER_21_222 VPWR VGND sg13g2_decap_4
X_21511_ _23772_/D _21938_/A1 _21515_/B _21510_/Y VPWR VGND sg13g2_o21ai_1
XFILLER_55_1069 VPWR VGND sg13g2_fill_1
X_22491_ _22491_/Q clkload18/A _22491_/D fanout2827/X VPWR VGND sg13g2_dfrbpq_1
XFILLER_107_1159 VPWR VGND sg13g2_fill_2
X_24230_ _24230_/Q clkload5/A _24230_/D fanout2841/X VPWR VGND sg13g2_dfrbpq_1
X_21442_ _23739_/D _21936_/A1 _21441_/B _21441_/Y VPWR VGND sg13g2_o21ai_1
XFILLER_33_1356 VPWR VGND sg13g2_decap_8
Xplace3020 _22249_/S _22243_/S VPWR VGND sg13g2_buf_1
Xplace3031 _22168_/B _22160_/B VPWR VGND sg13g2_buf_1
Xplace3042 _22001_/B _22031_/S VPWR VGND sg13g2_buf_1
XFILLER_108_828 VPWR VGND sg13g2_decap_4
X_24161_ _24161_/Q clkload41/A _24161_/D fanout2723/X VPWR VGND sg13g2_dfrbpq_1
Xplace3053 _21976_/B _21982_/B VPWR VGND sg13g2_buf_1
X_21373_ _23706_/D _21934_/A1 _21374_/B _21372_/Y VPWR VGND sg13g2_o21ai_1
Xplace3064 _21893_/B _21900_/B VPWR VGND sg13g2_buf_1
Xplace3075 _21620_/S _21572_/B VPWR VGND sg13g2_buf_1
Xplace3086 _21502_/B _21554_/S VPWR VGND sg13g2_buf_1
X_23112_ _23112_/Q _23114_/CLK _23112_/D fanout2909/X VPWR VGND sg13g2_dfrbpq_1
Xplace3097 _21456_/B _21467_/B VPWR VGND sg13g2_buf_1
X_20324_ _20324_/Y _20324_/A _20338_/C VPWR VGND sg13g2_nor2_1
X_24092_ _24092_/Q clkload56/A _24092_/D fanout2677/X VPWR VGND sg13g2_dfrbpq_1
X_23043_ _23043_/Q clkload13/A _23043_/D fanout2905/X VPWR VGND sg13g2_dfrbpq_1
XFILLER_85_1766 VPWR VGND sg13g2_decap_8
X_20255_ _20255_/X _20255_/A0 _20255_/A1 _20255_/A2 _20255_/A3 _20343_/S0 _20350_/A
+ VPWR VGND sg13g2_mux4_1
XFILLER_115_371 VPWR VGND sg13g2_fill_2
XFILLER_46_1728 VPWR VGND sg13g2_decap_8
XFILLER_27_1127 VPWR VGND sg13g2_fill_2
X_20186_ _20186_/Y _20344_/A1 _20185_/X _20362_/A1 VPWR VGND sg13g2_o21ai_1
XFILLER_103_555 VPWR VGND sg13g2_decap_8
XFILLER_89_778 VPWR VGND sg13g2_decap_4
XFILLER_44_1430 VPWR VGND sg13g2_fill_2
XFILLER_28_11 VPWR VGND sg13g2_fill_2
XFILLER_44_1485 VPWR VGND sg13g2_fill_2
XFILLER_57_642 VPWR VGND sg13g2_decap_8
X_23945_ _23945_/Q _24113_/CLK _23945_/D fanout2684/X VPWR VGND sg13g2_dfrbpq_1
XFILLER_28_66 VPWR VGND sg13g2_fill_2
XFILLER_79_1537 VPWR VGND sg13g2_fill_2
XFILLER_56_152 VPWR VGND sg13g2_fill_1
XFILLER_44_303 VPWR VGND sg13g2_decap_8
XFILLER_56_163 VPWR VGND sg13g2_decap_8
X_11890_ _12084_/D _14041_/B _12075_/B _12959_/A VPWR VGND sg13g2_nand3_1
X_23876_ _23876_/Q clkload40/A _23876_/D fanout2729/X VPWR VGND sg13g2_dfrbpq_1
XFILLER_44_325 VPWR VGND sg13g2_fill_2
XFILLER_2_1855 VPWR VGND sg13g2_decap_8
XFILLER_44_347 VPWR VGND sg13g2_fill_1
XFILLER_71_133 VPWR VGND sg13g2_decap_8
X_22827_ _22827_/Q clkload7/A _22827_/D fanout2795/X VPWR VGND sg13g2_dfrbpq_1
XFILLER_96_1884 VPWR VGND sg13g2_fill_2
XFILLER_60_829 VPWR VGND sg13g2_decap_4
XFILLER_53_870 VPWR VGND sg13g2_decap_8
XFILLER_109_1925 VPWR VGND sg13g2_decap_8
XFILLER_13_712 VPWR VGND sg13g2_fill_1
X_13560_ _13561_/B _13558_/X _13559_/X _13560_/S VPWR VGND sg13g2_mux2_1
X_22758_ _22758_/Q clkload22/A _22758_/D fanout2876/X VPWR VGND sg13g2_dfrbpq_1
XFILLER_0_1590 VPWR VGND sg13g2_fill_2
XFILLER_44_76 VPWR VGND sg13g2_decap_8
XFILLER_73_1136 VPWR VGND sg13g2_decap_4
XFILLER_12_233 VPWR VGND sg13g2_fill_1
XFILLER_16_1510 VPWR VGND sg13g2_fill_1
X_13491_ _13491_/Y _23565_/Q _13911_/A2 _13490_/X _13919_/S1 _13115_/A VPWR VGND sg13g2_a221oi_1
XFILLER_9_727 VPWR VGND sg13g2_fill_2
X_22689_ _22689_/Q clkload23/A _22689_/D fanout2887/X VPWR VGND sg13g2_dfrbpq_1
XFILLER_13_789 VPWR VGND sg13g2_fill_2
XFILLER_8_215 VPWR VGND sg13g2_decap_8
X_15230_ _16786_/C _15447_/A _19980_/B _15447_/C VPWR VGND sg13g2_nor3_1
XFILLER_40_586 VPWR VGND sg13g2_fill_1
XFILLER_90_1483 VPWR VGND sg13g2_fill_2
X_12442_ _12443_/C _23424_/Q _23456_/Q _23488_/Q _23520_/Q _13006_/S0 _12651_/S1 VPWR
+ VGND sg13g2_mux4_1
XFILLER_16_1565 VPWR VGND sg13g2_fill_1
XFILLER_103_1535 VPWR VGND sg13g2_decap_8
XFILLER_16_1587 VPWR VGND sg13g2_fill_1
XFILLER_51_1467 VPWR VGND sg13g2_fill_2
X_15161_ _16441_/A _17034_/C _16518_/C VPWR VGND sg13g2_nor2b_1
X_12373_ _12374_/B _24191_/Q _23327_/Q _12377_/S VPWR VGND sg13g2_mux2_1
XFILLER_86_1508 VPWR VGND sg13g2_decap_4
X_14112_ _19523_/B _14068_/X _14078_/Y _14111_/Y VPWR VGND sg13g2_a21oi_1
X_11324_ _11583_/S _22977_/Q VPWR VGND sg13g2_inv_1
XFILLER_68_1920 VPWR VGND sg13g2_decap_8
XFILLER_114_809 VPWR VGND sg13g2_decap_8
XFILLER_5_955 VPWR VGND sg13g2_decap_8
X_15092_ _15092_/X _23152_/Q _15090_/X _15120_/S VPWR VGND sg13g2_mux2_1
XFILLER_113_308 VPWR VGND sg13g2_fill_2
XFILLER_10_1164 VPWR VGND sg13g2_decap_4
XFILLER_5_59 VPWR VGND sg13g2_decap_8
XFILLER_109_91 VPWR VGND sg13g2_decap_8
XFILLER_101_1292 VPWR VGND sg13g2_decap_8
X_14043_ _14043_/Y _12002_/A _14043_/A2 _12001_/C _12001_/D VPWR VGND sg13g2_a22oi_1
XFILLER_84_1232 VPWR VGND sg13g2_decap_8
X_18920_ _18920_/Y _18953_/A _18920_/B _18920_/C VPWR VGND sg13g2_nand3_1
XFILLER_5_999 VPWR VGND sg13g2_decap_8
XFILLER_107_883 VPWR VGND sg13g2_decap_8
XFILLER_79_200 VPWR VGND sg13g2_fill_1
X_11255_ _14342_/B _11614_/A _11255_/B VPWR VGND sg13g2_nor2_2
XFILLER_49_1374 VPWR VGND sg13g2_fill_1
XFILLER_69_73 VPWR VGND sg13g2_decap_8
X_18851_ _18851_/Y _18884_/B _18766_/A _18857_/S _18771_/Y VPWR VGND sg13g2_a22oi_1
XFILLER_94_203 VPWR VGND sg13g2_fill_1
XFILLER_27_1661 VPWR VGND sg13g2_decap_8
X_17802_ _17802_/Y _17809_/A1 _17800_/Y _17801_/Y VPWR VGND sg13g2_o21ai_1
XFILLER_67_417 VPWR VGND sg13g2_fill_2
XFILLER_23_1503 VPWR VGND sg13g2_fill_1
X_18782_ _23031_/D _18782_/A _18782_/B _18782_/C VPWR VGND sg13g2_nand3_1
XFILLER_48_620 VPWR VGND sg13g2_fill_1
X_15994_ _15995_/D _15667_/B _15988_/Y _15993_/Y VPWR VGND sg13g2_a21oi_1
X_17733_ _17733_/Y _17739_/A _17739_/B VPWR VGND sg13g2_xnor2_1
XFILLER_85_61 VPWR VGND sg13g2_fill_2
X_14945_ _16278_/A _22526_/Q _16304_/A VPWR VGND sg13g2_nor2_1
XFILLER_7_1799 VPWR VGND sg13g2_decap_8
XFILLER_47_152 VPWR VGND sg13g2_decap_8
XFILLER_76_984 VPWR VGND sg13g2_fill_2
XFILLER_78_1014 VPWR VGND sg13g2_decap_8
XFILLER_48_697 VPWR VGND sg13g2_decap_8
XFILLER_1_1321 VPWR VGND sg13g2_fill_1
X_17664_ _17664_/Y _22560_/Q _17675_/B VPWR VGND sg13g2_xnor2_1
XFILLER_47_174 VPWR VGND sg13g2_fill_1
X_14876_ _16250_/B _14870_/Y _14828_/A _14871_/Y _14875_/X VPWR VGND sg13g2_a22oi_1
XFILLER_35_325 VPWR VGND sg13g2_decap_8
XFILLER_40_1894 VPWR VGND sg13g2_decap_4
XFILLER_78_1069 VPWR VGND sg13g2_decap_8
X_16615_ _16616_/B _16635_/A _16628_/D VPWR VGND sg13g2_nand2_1
X_13827_ _13827_/Y _22577_/Q _13987_/B VPWR VGND sg13g2_nand2b_1
X_17595_ _17595_/X _22553_/Q _17624_/D VPWR VGND sg13g2_xor2_1
XFILLER_62_155 VPWR VGND sg13g2_decap_8
X_19334_ _19334_/Y _20009_/B _19430_/B VPWR VGND sg13g2_nor2_1
X_16546_ _16547_/B _22624_/Q _16546_/B VPWR VGND sg13g2_xnor2_1
XFILLER_36_1919 VPWR VGND sg13g2_decap_4
X_13758_ _13758_/Y _14005_/A _14004_/B _13758_/B1 VPWR VGND sg13g2_a21oi_1
XFILLER_91_1247 VPWR VGND sg13g2_decap_8
XFILLER_17_1318 VPWR VGND sg13g2_decap_8
X_12709_ _12712_/B _12709_/A _12709_/B VPWR VGND sg13g2_nor2_1
X_19265_ _23193_/D _19265_/A _19265_/B _19265_/C VPWR VGND sg13g2_nor3_1
X_13689_ _13689_/X _24176_/Q _24208_/Q _23312_/Q _23344_/Q _13978_/S0 _13689_/S1 VPWR
+ VGND sg13g2_mux4_1
X_16477_ _22601_/D _17878_/A _16512_/B _16476_/Y VPWR VGND sg13g2_o21ai_1
Xoutput4503 data_wdata_o[0] _14647_/X VPWR VGND sg13g2_buf_1
X_18216_ _18219_/C _18288_/A _18216_/B _18216_/C VPWR VGND sg13g2_nand3_1
X_15428_ _15429_/B _22456_/Q _15575_/B _17303_/A _22787_/Q VPWR VGND sg13g2_a22oi_1
Xoutput4514 data_wdata_o[1] _14652_/X VPWR VGND sg13g2_buf_1
Xoutput4525 data_wdata_o[2] _14658_/X VPWR VGND sg13g2_buf_1
X_19196_ _23156_/D _23156_/Q _19200_/S _19195_/Y VPWR VGND sg13g2_a21o_1
Xoutput4536 instr_addr_o[10] _14911_/X VPWR VGND sg13g2_buf_1
XFILLER_30_1518 VPWR VGND sg13g2_decap_8
Xoutput4547 instr_addr_o[21] _15023_/X VPWR VGND sg13g2_buf_1
XFILLER_30_1529 VPWR VGND sg13g2_fill_2
Xoutput4558 instr_addr_o[31] _15120_/X VPWR VGND sg13g2_buf_1
X_15359_ _15359_/Y _15359_/A _15478_/D VPWR VGND sg13g2_nor2_1
XFILLER_7_270 VPWR VGND sg13g2_fill_2
XFILLER_89_1176 VPWR VGND sg13g2_fill_2
XFILLER_89_1198 VPWR VGND sg13g2_fill_1
XFILLER_67_1441 VPWR VGND sg13g2_fill_2
XFILLER_113_820 VPWR VGND sg13g2_decap_8
XFILLER_98_531 VPWR VGND sg13g2_decap_4
XFILLER_28_1436 VPWR VGND sg13g2_decap_8
X_20040_ _20040_/Y _20040_/A _20040_/B _20040_/C VPWR VGND sg13g2_nor3_1
XFILLER_59_907 VPWR VGND sg13g2_decap_4
XFILLER_98_553 VPWR VGND sg13g2_decap_8
XFILLER_98_564 VPWR VGND sg13g2_fill_1
XFILLER_115_1417 VPWR VGND sg13g2_decap_8
XFILLER_115_1428 VPWR VGND sg13g2_fill_2
XFILLER_112_363 VPWR VGND sg13g2_decap_8
XFILLER_80_1641 VPWR VGND sg13g2_fill_1
XFILLER_100_525 VPWR VGND sg13g2_decap_8
XFILLER_58_439 VPWR VGND sg13g2_fill_1
XFILLER_45_1783 VPWR VGND sg13g2_decap_8
XFILLER_105_49 VPWR VGND sg13g2_decap_8
XFILLER_85_236 VPWR VGND sg13g2_fill_2
XFILLER_41_1647 VPWR VGND sg13g2_decap_8
XFILLER_61_1073 VPWR VGND sg13g2_decap_8
XFILLER_67_962 VPWR VGND sg13g2_decap_8
X_21991_ _21991_/Y _21991_/A _22003_/B VPWR VGND sg13g2_nand2_1
XFILLER_61_1084 VPWR VGND sg13g2_decap_8
XFILLER_22_1046 VPWR VGND sg13g2_decap_8
XFILLER_27_826 VPWR VGND sg13g2_decap_8
XFILLER_38_152 VPWR VGND sg13g2_fill_1
X_23730_ _23730_/Q clkload32/A _23730_/D fanout2652/X VPWR VGND sg13g2_dfrbpq_1
XFILLER_66_483 VPWR VGND sg13g2_decap_8
XFILLER_38_185 VPWR VGND sg13g2_fill_1
XFILLER_66_494 VPWR VGND sg13g2_fill_1
XFILLER_82_954 VPWR VGND sg13g2_decap_8
XFILLER_38_196 VPWR VGND sg13g2_decap_4
X_23661_ _23661_/Q clkload51/A _23661_/D fanout2659/X VPWR VGND sg13g2_dfrbpq_1
XFILLER_81_453 VPWR VGND sg13g2_decap_4
X_20873_ _23483_/D _21307_/A1 _20879_/B _20872_/Y VPWR VGND sg13g2_o21ai_1
XFILLER_53_155 VPWR VGND sg13g2_decap_8
X_22612_ _22612_/Q clkload8/A _22612_/D fanout2798/X VPWR VGND sg13g2_dfrbpq_1
XFILLER_35_892 VPWR VGND sg13g2_fill_1
X_23592_ _23592_/Q clkload31/A _23592_/D fanout2654/X VPWR VGND sg13g2_dfrbpq_1
XFILLER_39_1565 VPWR VGND sg13g2_fill_1
X_22543_ _22543_/Q clkload6/A _22543_/D fanout2833/X VPWR VGND sg13g2_dfrbpq_1
XFILLER_14_57 VPWR VGND sg13g2_fill_2
XFILLER_50_884 VPWR VGND sg13g2_decap_8
X_22474_ _22474_/Q clkload8/A _22474_/D fanout2800/X VPWR VGND sg13g2_dfrbpq_1
XFILLER_17_1885 VPWR VGND sg13g2_decap_8
XFILLER_72_1191 VPWR VGND sg13g2_decap_8
X_24213_ _24213_/Q clkload35/A _24213_/D wire1182/A VPWR VGND sg13g2_dfrbpq_1
XFILLER_52_1787 VPWR VGND sg13g2_decap_4
XFILLER_104_1866 VPWR VGND sg13g2_decap_8
XFILLER_108_636 VPWR VGND sg13g2_decap_8
X_24144_ _24144_/Q _24210_/CLK _24144_/D fanout2634/X VPWR VGND sg13g2_dfrbpq_1
XFILLER_68_1227 VPWR VGND sg13g2_decap_4
XFILLER_107_168 VPWR VGND sg13g2_decap_8
X_20307_ _20309_/C _20307_/A _20307_/B VPWR VGND sg13g2_nor2_1
X_24075_ _24075_/Q _24212_/CLK _24075_/D fanout2634/X VPWR VGND sg13g2_dfrbpq_1
Xfanout2906 fanout2906/X fanout2907/X VPWR VGND sg13g2_buf_1
X_21287_ _21287_/Y _21287_/A _21287_/B VPWR VGND sg13g2_nand2_1
Xfanout2917 fanout2917/X fanout2918/X VPWR VGND sg13g2_buf_1
Xfanout2928 fanout2928/X wire1182/A VPWR VGND sg13g2_buf_1
XFILLER_2_969 VPWR VGND sg13g2_fill_2
X_23026_ _23026_/Q clkload11/A _23026_/D fanout2836/X VPWR VGND sg13g2_dfrbpq_1
XFILLER_77_715 VPWR VGND sg13g2_decap_4
XFILLER_89_597 VPWR VGND sg13g2_decap_8
XFILLER_49_428 VPWR VGND sg13g2_decap_8
XFILLER_76_214 VPWR VGND sg13g2_decap_8
X_20169_ _20169_/Y _24264_/A _20318_/B _20168_/Y VPWR VGND sg13g2_a21oi_1
XFILLER_76_225 VPWR VGND sg13g2_fill_2
XFILLER_39_76 VPWR VGND sg13g2_decap_8
XFILLER_58_951 VPWR VGND sg13g2_decap_8
XFILLER_4_1928 VPWR VGND sg13g2_decap_8
XFILLER_111_1815 VPWR VGND sg13g2_decap_8
XFILLER_98_1924 VPWR VGND sg13g2_decap_8
XFILLER_92_729 VPWR VGND sg13g2_fill_1
XFILLER_73_910 VPWR VGND sg13g2_decap_8
X_11942_ _11943_/B _23418_/Q _23450_/Q _23482_/Q _23514_/Q _12128_/A _11797_/S VPWR
+ VGND sg13g2_mux4_1
XFILLER_17_314 VPWR VGND sg13g2_fill_2
X_14730_ _14730_/X _14678_/Y _14676_/Y _14732_/S VPWR VGND sg13g2_mux2_1
XFILLER_44_100 VPWR VGND sg13g2_decap_8
XFILLER_55_31 VPWR VGND sg13g2_fill_2
X_23928_ _23928_/Q clkload52/A _23928_/D fanout2690/X VPWR VGND sg13g2_dfrbpq_1
XFILLER_17_325 VPWR VGND sg13g2_fill_1
XFILLER_29_185 VPWR VGND sg13g2_decap_4
XFILLER_18_859 VPWR VGND sg13g2_decap_4
X_14661_ _14661_/Y _14659_/Y _14714_/A2 _14660_/X VPWR VGND sg13g2_a21oi_1
X_23859_ _23859_/Q clkload51/A _23859_/D fanout2664/X VPWR VGND sg13g2_dfrbpq_1
XFILLER_33_818 VPWR VGND sg13g2_fill_1
XFILLER_72_464 VPWR VGND sg13g2_decap_8
XFILLER_60_615 VPWR VGND sg13g2_decap_8
XFILLER_72_475 VPWR VGND sg13g2_fill_1
X_13612_ _13625_/B _12445_/A _13609_/X _13611_/X VPWR VGND sg13g2_o21ai_1
X_16400_ _16400_/Y _22568_/Q _16413_/S VPWR VGND sg13g2_nand2_1
XFILLER_26_892 VPWR VGND sg13g2_decap_8
X_14592_ _14592_/Y _24214_/Q _19274_/B VPWR VGND sg13g2_nand2_1
XFILLER_60_648 VPWR VGND sg13g2_fill_2
X_17380_ _22815_/D _14814_/Y _17388_/B _17379_/Y VPWR VGND sg13g2_o21ai_1
XFILLER_38_1042 VPWR VGND sg13g2_decap_8
XFILLER_111_70 VPWR VGND sg13g2_decap_8
XFILLER_109_1755 VPWR VGND sg13g2_fill_2
X_16331_ _16333_/B _16331_/A _16331_/B _16331_/C VPWR VGND sg13g2_and3_2
X_13543_ _20245_/B _13543_/A VPWR VGND sg13g2_inv_2
XFILLER_105_1619 VPWR VGND sg13g2_decap_8
X_16262_ _16263_/C _16262_/A _16265_/A VPWR VGND sg13g2_nor2_1
X_19050_ _19050_/X _19116_/A1 _23094_/Q _19054_/S VPWR VGND sg13g2_mux2_1
XFILLER_71_85 VPWR VGND sg13g2_decap_4
X_13474_ _13474_/X _23853_/Q _23885_/Q _23949_/Q _23981_/Q _13606_/S0 _13606_/S1 VPWR
+ VGND sg13g2_mux4_1
XFILLER_90_1280 VPWR VGND sg13g2_decap_4
XFILLER_107_1490 VPWR VGND sg13g2_fill_1
XFILLER_31_1827 VPWR VGND sg13g2_decap_8
X_15213_ _15213_/Y _15204_/Y _16334_/A _16161_/A _22483_/Q _15212_/X VPWR VGND sg13g2_a221oi_1
X_12425_ _12425_/Y _19930_/A _12422_/Y _12429_/C _12424_/X VPWR VGND sg13g2_a22oi_1
XFILLER_31_1838 VPWR VGND sg13g2_fill_2
X_16193_ _16193_/Y _16193_/A _16193_/B VPWR VGND sg13g2_nand2_1
XFILLER_51_1275 VPWR VGND sg13g2_decap_8
XFILLER_51_1297 VPWR VGND sg13g2_decap_4
X_15144_ _15300_/B _16784_/A _15257_/B VPWR VGND sg13g2_nor2b_1
XFILLER_5_741 VPWR VGND sg13g2_decap_8
XFILLER_114_606 VPWR VGND sg13g2_decap_8
XFILLER_58_7 VPWR VGND sg13g2_fill_1
XFILLER_86_1349 VPWR VGND sg13g2_decap_8
X_11307_ _11307_/X _22966_/Q _11626_/B VPWR VGND sg13g2_or2_1
XFILLER_113_105 VPWR VGND sg13g2_decap_8
X_15075_ _15077_/A _22509_/Q _14998_/B _15075_/B1 _22937_/Q VPWR VGND sg13g2_a22oi_1
X_12287_ _12287_/X _24158_/Q _24190_/Q _23230_/Q _23262_/Q _12459_/S0 _12457_/S1 VPWR
+ VGND sg13g2_mux4_1
XFILLER_64_1614 VPWR VGND sg13g2_fill_2
X_14026_ _15218_/A _14026_/A VPWR VGND sg13g2_inv_1
X_18903_ _18903_/Y _18899_/A _18903_/B _18903_/C VPWR VGND sg13g2_nand3b_1
X_11238_ _11238_/Y _14121_/A _19360_/A VPWR VGND sg13g2_nand2_1
X_19883_ _19884_/B _23212_/Q _20130_/B _19850_/A VPWR VGND sg13g2_a21oi_1
XFILLER_110_801 VPWR VGND sg13g2_decap_8
XFILLER_45_1035 VPWR VGND sg13g2_decap_8
XFILLER_45_1046 VPWR VGND sg13g2_fill_1
XFILLER_95_512 VPWR VGND sg13g2_decap_8
X_18834_ _18834_/Y _18866_/A _18834_/B VPWR VGND sg13g2_nand2_1
XFILLER_23_1300 VPWR VGND sg13g2_decap_8
XFILLER_114_1450 VPWR VGND sg13g2_decap_4
XFILLER_110_878 VPWR VGND sg13g2_decap_4
X_18765_ _18765_/Y _18822_/A _18765_/B VPWR VGND sg13g2_nand2_1
XFILLER_23_1344 VPWR VGND sg13g2_fill_2
X_15977_ _15978_/B _20322_/A _15996_/A _15977_/C VPWR VGND sg13g2_nand3_1
XFILLER_49_995 VPWR VGND sg13g2_decap_4
X_14928_ _14929_/C _22494_/Q _15113_/B VPWR VGND sg13g2_nand2_1
X_18696_ _18700_/A _23017_/Q _18696_/B VPWR VGND sg13g2_nand2_1
XFILLER_97_1467 VPWR VGND sg13g2_fill_2
XFILLER_40_1680 VPWR VGND sg13g2_decap_4
XFILLER_63_442 VPWR VGND sg13g2_decap_8
XFILLER_36_667 VPWR VGND sg13g2_fill_1
X_17647_ _17647_/Y _17697_/A _22958_/Q VPWR VGND sg13g2_nand2_1
X_14859_ _16241_/B _14845_/Y _16244_/B _14858_/Y VPWR VGND sg13g2_a21oi_2
XFILLER_35_155 VPWR VGND sg13g2_fill_1
XFILLER_91_784 VPWR VGND sg13g2_fill_1
XFILLER_90_261 VPWR VGND sg13g2_decap_4
XFILLER_75_1732 VPWR VGND sg13g2_decap_8
XFILLER_17_881 VPWR VGND sg13g2_fill_2
XFILLER_51_637 VPWR VGND sg13g2_decap_4
XFILLER_63_497 VPWR VGND sg13g2_decap_8
XFILLER_36_1705 VPWR VGND sg13g2_fill_2
X_17578_ _17578_/Y _17586_/A _17593_/B _17578_/C VPWR VGND sg13g2_nor3_1
XFILLER_32_840 VPWR VGND sg13g2_fill_1
XFILLER_108_1276 VPWR VGND sg13g2_decap_8
XFILLER_84_0 VPWR VGND sg13g2_decap_8
XFILLER_17_1159 VPWR VGND sg13g2_decap_8
X_19248_ _19248_/Y _19243_/B _19247_/Y _19268_/A VPWR VGND sg13g2_a21oi_1
X_19179_ _23149_/D _23149_/Q _15064_/X _19185_/S VPWR VGND sg13g2_mux2_1
XFILLER_30_1326 VPWR VGND sg13g2_fill_1
X_21210_ _23628_/D _21342_/A1 _21209_/B _21209_/Y VPWR VGND sg13g2_o21ai_1
XFILLER_69_1558 VPWR VGND sg13g2_fill_2
XFILLER_105_628 VPWR VGND sg13g2_decap_8
XFILLER_104_105 VPWR VGND sg13g2_decap_8
X_21141_ _23595_/D _21677_/A1 _21154_/B _21140_/Y VPWR VGND sg13g2_o21ai_1
XFILLER_47_1823 VPWR VGND sg13g2_decap_8
XFILLER_47_1834 VPWR VGND sg13g2_decap_8
XFILLER_63_1102 VPWR VGND sg13g2_fill_1
X_21072_ _23566_/D _22308_/A1 _21079_/B _21071_/Y VPWR VGND sg13g2_o21ai_1
XFILLER_98_350 VPWR VGND sg13g2_decap_8
XFILLER_63_1135 VPWR VGND sg13g2_decap_8
XFILLER_86_512 VPWR VGND sg13g2_decap_8
XFILLER_58_203 VPWR VGND sg13g2_fill_2
XFILLER_113_694 VPWR VGND sg13g2_decap_8
XFILLER_112_182 VPWR VGND sg13g2_decap_8
XFILLER_86_545 VPWR VGND sg13g2_decap_4
XFILLER_86_556 VPWR VGND sg13g2_decap_4
XFILLER_115_1269 VPWR VGND sg13g2_decap_8
XFILLER_101_867 VPWR VGND sg13g2_decap_8
XFILLER_86_567 VPWR VGND sg13g2_decap_8
XFILLER_86_578 VPWR VGND sg13g2_decap_4
XFILLER_39_450 VPWR VGND sg13g2_fill_2
XFILLER_6_1062 VPWR VGND sg13g2_decap_8
XFILLER_73_206 VPWR VGND sg13g2_fill_1
XFILLER_73_217 VPWR VGND sg13g2_fill_2
XFILLER_6_1084 VPWR VGND sg13g2_fill_2
XFILLER_73_228 VPWR VGND sg13g2_decap_4
XFILLER_41_1488 VPWR VGND sg13g2_fill_1
X_21974_ _23982_/D _21974_/A1 _21976_/B _21973_/Y VPWR VGND sg13g2_o21ai_1
X_23713_ _23713_/Q clkload39/A _23713_/D fanout2739/X VPWR VGND sg13g2_dfrbpq_1
XFILLER_54_453 VPWR VGND sg13g2_fill_2
XFILLER_81_250 VPWR VGND sg13g2_fill_2
XFILLER_54_475 VPWR VGND sg13g2_fill_2
XFILLER_42_626 VPWR VGND sg13g2_decap_8
X_23644_ _23644_/Q clkload59/A _23644_/D fanout2784/X VPWR VGND sg13g2_dfrbpq_1
XFILLER_109_1029 VPWR VGND sg13g2_decap_8
XFILLER_14_339 VPWR VGND sg13g2_decap_8
XFILLER_25_56 VPWR VGND sg13g2_fill_2
XFILLER_26_199 VPWR VGND sg13g2_fill_2
XFILLER_41_136 VPWR VGND sg13g2_decap_8
XFILLER_42_659 VPWR VGND sg13g2_fill_1
XFILLER_19_1947 VPWR VGND sg13g2_decap_8
XFILLER_39_1373 VPWR VGND sg13g2_decap_8
X_23575_ _23575_/Q clkload58/A _23575_/D fanout2758/X VPWR VGND sg13g2_dfrbpq_1
XFILLER_35_1237 VPWR VGND sg13g2_fill_1
XFILLER_50_681 VPWR VGND sg13g2_decap_4
X_22526_ _22526_/Q _22941_/CLK _22526_/D fanout2803/X VPWR VGND sg13g2_dfrbpq_1
XFILLER_22_394 VPWR VGND sg13g2_decap_8
XFILLER_52_1551 VPWR VGND sg13g2_fill_2
XFILLER_13_1524 VPWR VGND sg13g2_fill_1
X_22457_ _22457_/Q clkload28/A _22457_/D fanout2829/X VPWR VGND sg13g2_dfrbpq_1
XFILLER_100_1505 VPWR VGND sg13g2_fill_2
XFILLER_104_1685 VPWR VGND sg13g2_fill_2
X_12210_ _12211_/B _23581_/Q _23645_/Q _12216_/S VPWR VGND sg13g2_mux2_1
X_21408_ _21408_/Y _21408_/A _21422_/B VPWR VGND sg13g2_nand2_1
X_13190_ _13190_/X _24041_/Q _24073_/Q _24105_/Q _24137_/Q _13961_/S0 _13645_/A VPWR
+ VGND sg13g2_mux4_1
XFILLER_68_1024 VPWR VGND sg13g2_fill_2
XFILLER_100_1549 VPWR VGND sg13g2_fill_1
X_12141_ _12148_/A _13208_/A _12141_/B VPWR VGND sg13g2_nor2_1
X_24127_ _24127_/Q clkload43/A _24127_/D fanout2769/X VPWR VGND sg13g2_dfrbpq_1
XFILLER_11_1281 VPWR VGND sg13g2_decap_8
X_21339_ _21339_/Y _21339_/A _21347_/B VPWR VGND sg13g2_nand2_1
XFILLER_11_1292 VPWR VGND sg13g2_fill_1
XFILLER_65_1912 VPWR VGND sg13g2_decap_4
XFILLER_68_1068 VPWR VGND sg13g2_decap_8
Xfanout2703 fanout2703/X fanout2704/X VPWR VGND sg13g2_buf_1
Xfanout2714 fanout2714/X fanout2717/X VPWR VGND sg13g2_buf_1
X_24058_ _24058_/Q clkload48/A _24058_/D fanout2686/X VPWR VGND sg13g2_dfrbpq_1
Xfanout2725 fanout2725/X fanout2727/X VPWR VGND sg13g2_buf_1
XFILLER_1_243 VPWR VGND sg13g2_decap_8
Xfanout2736 fanout2736/X fanout2737/X VPWR VGND sg13g2_buf_1
Xfanout2747 fanout2747/X fanout2748/X VPWR VGND sg13g2_buf_1
XFILLER_77_501 VPWR VGND sg13g2_fill_1
Xfanout2758 fanout2758/X fanout2759/X VPWR VGND sg13g2_buf_1
XFILLER_89_361 VPWR VGND sg13g2_decap_8
XFILLER_110_119 VPWR VGND sg13g2_decap_8
XFILLER_81_1246 VPWR VGND sg13g2_decap_8
X_15900_ _15904_/C _22477_/Q _15900_/A2 _15992_/B1 _22808_/Q VPWR VGND sg13g2_a22oi_1
X_23009_ _23009_/Q clkload26/A _23009_/D fanout2850/X VPWR VGND sg13g2_dfrbpq_1
XFILLER_46_1366 VPWR VGND sg13g2_decap_8
XFILLER_104_683 VPWR VGND sg13g2_decap_8
Xfanout2769 fanout2769/X fanout2770/X VPWR VGND sg13g2_buf_1
X_16880_ _22686_/D _16895_/S _16878_/Y _16879_/Y VPWR VGND sg13g2_o21ai_1
XFILLER_106_70 VPWR VGND sg13g2_decap_8
XFILLER_2_49 VPWR VGND sg13g2_fill_1
X_15831_ _15832_/B _22707_/Q _15898_/A2 _15898_/B1 _22643_/Q VPWR VGND sg13g2_a22oi_1
XFILLER_115_1770 VPWR VGND sg13g2_decap_8
XFILLER_4_1725 VPWR VGND sg13g2_decap_8
XFILLER_64_217 VPWR VGND sg13g2_decap_8
XFILLER_17_100 VPWR VGND sg13g2_decap_8
X_18550_ _18550_/Y _18485_/B _18549_/X _17978_/A VPWR VGND sg13g2_a21oi_1
X_12974_ _12974_/X _12974_/A _23910_/Q VPWR VGND sg13g2_and2_1
XFILLER_59_1705 VPWR VGND sg13g2_fill_1
X_15762_ _15763_/B _22736_/Q _15901_/A2 _15901_/B1 _22672_/Q VPWR VGND sg13g2_a22oi_1
XFILLER_18_645 VPWR VGND sg13g2_decap_8
XFILLER_57_280 VPWR VGND sg13g2_fill_1
X_17501_ _22867_/D _17917_/A _17502_/S _17500_/Y VPWR VGND sg13g2_o21ai_1
X_14713_ _14713_/Y _14713_/A _19195_/B VPWR VGND sg13g2_nand2_1
XFILLER_94_1629 VPWR VGND sg13g2_fill_2
X_18481_ _18483_/B _18541_/A1 _18473_/X _18479_/X VPWR VGND sg13g2_o21ai_1
Xclkbuf_leaf_1_clk_i clkload8/A clkbuf_leaf_4_clk_i/A VPWR VGND sg13g2_buf_16
X_15693_ _17141_/A _15693_/A VPWR VGND sg13g2_inv_1
X_17432_ _22836_/D _17929_/B2 _22836_/Q _17432_/S VPWR VGND sg13g2_mux2_1
XFILLER_2_1493 VPWR VGND sg13g2_fill_2
X_11856_ _11857_/D _12249_/A1 _11855_/X _12039_/B VPWR VGND sg13g2_o21ai_1
XFILLER_57_1440 VPWR VGND sg13g2_decap_8
XFILLER_53_1304 VPWR VGND sg13g2_decap_8
XFILLER_92_1364 VPWR VGND sg13g2_decap_4
X_17363_ _22808_/D _16504_/Y _17367_/B _17362_/Y VPWR VGND sg13g2_o21ai_1
X_14575_ _17044_/B _14575_/A _14575_/B _14575_/C _16774_/B VPWR VGND sg13g2_nand4_1
XFILLER_109_1563 VPWR VGND sg13g2_fill_2
X_11787_ _11794_/A _12774_/B _11787_/B VPWR VGND sg13g2_nor2_1
XFILLER_18_1457 VPWR VGND sg13g2_decap_4
Xplace4309 _12651_/S0 _12819_/S0 VPWR VGND sg13g2_buf_8
XFILLER_13_372 VPWR VGND sg13g2_decap_8
X_19102_ _19102_/X _18973_/B _23119_/Q _19114_/S VPWR VGND sg13g2_mux2_1
XFILLER_53_1348 VPWR VGND sg13g2_fill_2
X_16314_ _16318_/B _16314_/A _16314_/B _16314_/C _16324_/C VPWR VGND sg13g2_or4_1
X_13526_ _13950_/B _13526_/A _13526_/B _13526_/C _13526_/D VPWR VGND sg13g2_nor4_2
X_17294_ _22776_/D _16504_/Y _17293_/B _17293_/Y VPWR VGND sg13g2_o21ai_1
Xplace3608 _14949_/A _14407_/X VPWR VGND sg13g2_buf_1
Xplace3619 _19638_/S _19714_/S VPWR VGND sg13g2_buf_1
X_19033_ _19035_/B _19030_/Y _19044_/B VPWR VGND sg13g2_nand2b_1
Xrebuffer4609 _12697_/A _12664_/Y VPWR VGND sg13g2_buf_2
X_13457_ _13457_/X _13636_/A _13457_/B VPWR VGND sg13g2_or2_1
XFILLER_12_1012 VPWR VGND sg13g2_decap_8
X_16245_ _22518_/D _16244_/B _16238_/Y _16243_/X _16244_/Y VPWR VGND sg13g2_a22oi_1
XFILLER_31_1646 VPWR VGND sg13g2_decap_8
X_12408_ _12408_/X _23583_/Q _23615_/Q _23647_/Q _23679_/Q _12651_/S0 _12651_/S1 VPWR
+ VGND sg13g2_mux4_1
X_16176_ _16176_/Y _22506_/Q _16156_/B _16175_/Y VPWR VGND sg13g2_a21oi_1
X_13388_ _13403_/A _13276_/A _13385_/X _13387_/X VPWR VGND sg13g2_o21ai_1
XFILLER_115_915 VPWR VGND sg13g2_decap_8
XFILLER_86_1124 VPWR VGND sg13g2_decap_4
XFILLER_114_403 VPWR VGND sg13g2_decap_8
XFILLER_5_560 VPWR VGND sg13g2_fill_2
X_15127_ _15131_/B _24231_/Q _14825_/A _24229_/D _15121_/X _24233_/Q VPWR VGND sg13g2_a221oi_1
XFILLER_86_1168 VPWR VGND sg13g2_decap_8
XFILLER_99_136 VPWR VGND sg13g2_decap_8
XFILLER_64_1411 VPWR VGND sg13g2_decap_8
X_19935_ _19935_/Y _19987_/A _19933_/Y _19934_/Y VPWR VGND sg13g2_a21oi_1
X_15058_ _15060_/A _15058_/A1 _15025_/B _15057_/Y VPWR VGND sg13g2_a21oi_1
X_14009_ _14427_/C _13999_/X _14008_/X _24274_/A VPWR VGND sg13g2_a21oi_1
XFILLER_110_620 VPWR VGND sg13g2_decap_8
X_19866_ _19866_/Y _20033_/A1 _19865_/Y _19663_/X VPWR VGND sg13g2_a21oi_1
XFILLER_60_1308 VPWR VGND sg13g2_decap_8
XFILLER_95_331 VPWR VGND sg13g2_decap_8
XFILLER_68_545 VPWR VGND sg13g2_decap_8
X_18817_ _18817_/Y _18053_/S _23037_/Q _18823_/B1 _19123_/A1 VPWR VGND sg13g2_a22oi_1
XFILLER_83_504 VPWR VGND sg13g2_decap_8
X_19797_ _19797_/Y _20082_/A _19797_/B VPWR VGND sg13g2_nor2_1
XFILLER_7_1371 VPWR VGND sg13g2_fill_2
XFILLER_37_910 VPWR VGND sg13g2_decap_8
XFILLER_49_770 VPWR VGND sg13g2_fill_2
XFILLER_95_386 VPWR VGND sg13g2_decap_8
XFILLER_83_526 VPWR VGND sg13g2_decap_8
XFILLER_110_697 VPWR VGND sg13g2_decap_8
XFILLER_110_1111 VPWR VGND sg13g2_fill_1
XFILLER_3_1235 VPWR VGND sg13g2_decap_8
X_18748_ _18748_/Y _18748_/A VPWR VGND sg13g2_inv_1
XFILLER_110_1122 VPWR VGND sg13g2_decap_8
XFILLER_97_1231 VPWR VGND sg13g2_decap_8
XFILLER_37_965 VPWR VGND sg13g2_decap_4
XFILLER_102_28 VPWR VGND sg13g2_decap_8
XFILLER_110_1166 VPWR VGND sg13g2_fill_2
X_18679_ _18679_/Y _24261_/A _18679_/A2 _14969_/Y VPWR VGND sg13g2_a21oi_1
XFILLER_97_1286 VPWR VGND sg13g2_decap_8
XFILLER_24_615 VPWR VGND sg13g2_fill_2
XFILLER_64_784 VPWR VGND sg13g2_fill_2
X_20710_ _20710_/Y _23410_/Q _20710_/B VPWR VGND sg13g2_nand2_1
XFILLER_36_497 VPWR VGND sg13g2_decap_8
XFILLER_52_946 VPWR VGND sg13g2_fill_1
X_21690_ _21690_/Y _21690_/A _21690_/B VPWR VGND sg13g2_nand2_1
XFILLER_23_158 VPWR VGND sg13g2_decap_8
X_20641_ _20641_/Y _23376_/Q _20647_/B VPWR VGND sg13g2_nand2_1
XFILLER_71_1448 VPWR VGND sg13g2_decap_4
X_23360_ _23360_/Q _23682_/CLK _23360_/D fanout2722/X VPWR VGND sg13g2_dfrbpq_1
XFILLER_108_1073 VPWR VGND sg13g2_decap_8
X_20572_ _20572_/Y _20572_/A _20572_/B VPWR VGND sg13g2_nand2_1
XFILLER_53_1860 VPWR VGND sg13g2_fill_1
XFILLER_31_191 VPWR VGND sg13g2_fill_2
X_22311_ _24144_/D _22311_/A1 _22310_/B _22310_/Y VPWR VGND sg13g2_o21ai_1
XFILLER_14_1844 VPWR VGND sg13g2_decap_8
XFILLER_34_1281 VPWR VGND sg13g2_fill_2
X_23291_ _23291_/Q _24131_/CLK _23291_/D fanout2769/X VPWR VGND sg13g2_dfrbpq_1
XFILLER_11_14 VPWR VGND sg13g2_decap_8
XFILLER_10_1708 VPWR VGND sg13g2_decap_8
X_22242_ _24110_/D _22308_/A1 _22241_/B _22241_/Y VPWR VGND sg13g2_o21ai_1
Xhold4800 _21887_/A _23939_/Q VPWR VGND sg13g2_dlygate4sd3_1
Xhold4811 _18116_/A _22952_/Q VPWR VGND sg13g2_dlygate4sd3_1
X_22173_ _24076_/D _22305_/A1 _22172_/B _22172_/Y VPWR VGND sg13g2_o21ai_1
Xhold4822 _21676_/A _23851_/Q VPWR VGND sg13g2_dlygate4sd3_1
Xhold4833 _21054_/A _23559_/Q VPWR VGND sg13g2_dlygate4sd3_1
Xhold4844 _21102_/A _23577_/Q VPWR VGND sg13g2_dlygate4sd3_1
X_21124_ _21124_/Y _23587_/Q _21130_/B VPWR VGND sg13g2_nand2_1
Xhold4855 _20692_/A _23399_/Q VPWR VGND sg13g2_dlygate4sd3_1
Xhold4866 _17242_/A _22752_/Q VPWR VGND sg13g2_dlygate4sd3_1
XFILLER_28_1041 VPWR VGND sg13g2_fill_2
XFILLER_47_1664 VPWR VGND sg13g2_fill_2
Xhold4877 _21209_/A _23628_/Q VPWR VGND sg13g2_dlygate4sd3_1
Xhold4888 _21365_/A _23703_/Q VPWR VGND sg13g2_dlygate4sd3_1
Xhold4899 _20414_/A _23271_/Q VPWR VGND sg13g2_dlygate4sd3_1
X_21055_ _23559_/D _20156_/Y _21071_/B _21054_/Y VPWR VGND sg13g2_o21ai_1
XFILLER_86_320 VPWR VGND sg13g2_decap_8
XFILLER_59_534 VPWR VGND sg13g2_decap_8
XFILLER_113_491 VPWR VGND sg13g2_decap_8
XFILLER_115_1044 VPWR VGND sg13g2_decap_8
XFILLER_101_642 VPWR VGND sg13g2_decap_8
X_20006_ _20006_/Y _20004_/Y _20005_/Y _20082_/A VPWR VGND sg13g2_o21ai_1
XFILLER_86_353 VPWR VGND sg13g2_decap_8
XFILLER_112_1910 VPWR VGND sg13g2_decap_8
XFILLER_59_578 VPWR VGND sg13g2_fill_2
XFILLER_100_152 VPWR VGND sg13g2_decap_4
XFILLER_47_729 VPWR VGND sg13g2_decap_4
XFILLER_98_1028 VPWR VGND sg13g2_fill_2
XFILLER_41_1252 VPWR VGND sg13g2_decap_4
XFILLER_86_397 VPWR VGND sg13g2_decap_8
XFILLER_112_1954 VPWR VGND sg13g2_fill_1
XFILLER_1_1909 VPWR VGND sg13g2_decap_8
XFILLER_27_420 VPWR VGND sg13g2_decap_8
XFILLER_41_1285 VPWR VGND sg13g2_fill_2
XFILLER_27_464 VPWR VGND sg13g2_fill_2
X_21957_ _21957_/Y _21957_/A _21957_/B VPWR VGND sg13g2_nand2_1
XFILLER_55_773 VPWR VGND sg13g2_fill_1
XFILLER_76_1315 VPWR VGND sg13g2_fill_1
X_11710_ _11711_/B _23416_/Q _23480_/Q _12134_/S VPWR VGND sg13g2_mux2_1
XFILLER_82_592 VPWR VGND sg13g2_decap_8
X_20908_ _23500_/D _21342_/A1 _20913_/B _20907_/Y VPWR VGND sg13g2_o21ai_1
X_12690_ _12691_/D _12740_/A _12690_/B VPWR VGND sg13g2_nor2_1
XFILLER_43_957 VPWR VGND sg13g2_decap_8
XFILLER_14_136 VPWR VGND sg13g2_decap_8
X_21888_ _23939_/D _21954_/A1 _21893_/B _21887_/Y VPWR VGND sg13g2_o21ai_1
XFILLER_19_1722 VPWR VGND sg13g2_decap_4
XFILLER_43_979 VPWR VGND sg13g2_decap_8
X_11641_ _11641_/Y _15257_/A _14021_/B _14028_/B VPWR VGND sg13g2_o21ai_1
XFILLER_14_158 VPWR VGND sg13g2_fill_1
X_23627_ _23627_/Q clkload49/A _23627_/D fanout2670/X VPWR VGND sg13g2_dfrbpq_1
XFILLER_93_1684 VPWR VGND sg13g2_fill_2
X_20839_ _20839_/Y _20839_/A _20847_/B VPWR VGND sg13g2_nand2_1
XFILLER_70_787 VPWR VGND sg13g2_decap_8
XFILLER_52_54 VPWR VGND sg13g2_decap_4
X_23558_ _23558_/Q clkload37/A _23558_/D fanout2713/X VPWR VGND sg13g2_dfrbpq_1
X_11572_ _14119_/B _11595_/A _14461_/A _14461_/B _11596_/C VPWR VGND sg13g2_nor4_2
XFILLER_32_1911 VPWR VGND sg13g2_decap_8
XFILLER_7_814 VPWR VGND sg13g2_decap_4
X_13311_ _13311_/Y _13311_/A VPWR VGND sg13g2_inv_1
X_22509_ _22509_/Q _22869_/CLK _22509_/D fanout2796/X VPWR VGND sg13g2_dfrbpq_1
XFILLER_13_1332 VPWR VGND sg13g2_decap_8
XFILLER_7_847 VPWR VGND sg13g2_fill_2
X_23489_ _23489_/Q _23682_/CLK _23489_/D fanout2725/X VPWR VGND sg13g2_dfrbpq_1
XFILLER_52_1381 VPWR VGND sg13g2_decap_8
XFILLER_109_742 VPWR VGND sg13g2_decap_8
XFILLER_109_753 VPWR VGND sg13g2_fill_1
XFILLER_10_397 VPWR VGND sg13g2_fill_2
X_13242_ _13242_/X _23594_/Q _23626_/Q _23658_/Q _23690_/Q _12921_/S _13242_/S1 VPWR
+ VGND sg13g2_mux4_1
X_16030_ _16084_/C _14765_/A _14187_/C _16029_/Y VPWR VGND sg13g2_a21oi_1
X_13173_ _13173_/X _24041_/Q _24073_/Q _13173_/S VPWR VGND sg13g2_mux2_1
XFILLER_48_1439 VPWR VGND sg13g2_decap_8
X_12124_ _12124_/Y _12122_/Y _12119_/Y _12123_/Y _11457_/Y _13343_/B VPWR VGND sg13g2_a221oi_1
XFILLER_97_618 VPWR VGND sg13g2_fill_2
X_17981_ _17981_/Y _18048_/S _23045_/Q VPWR VGND sg13g2_nand2_1
XFILLER_85_1190 VPWR VGND sg13g2_decap_8
XFILLER_65_1764 VPWR VGND sg13g2_fill_2
X_19720_ _20306_/B _20092_/A2 _19707_/Y _19719_/Y VPWR VGND sg13g2_a21oi_1
X_12055_ _12055_/X _23579_/Q _23611_/Q _23643_/Q _23675_/Q _12235_/S _12297_/S1 VPWR
+ VGND sg13g2_mux4_1
X_16932_ _22696_/D _16927_/S _16930_/Y _16931_/Y VPWR VGND sg13g2_o21ai_1
XFILLER_26_1748 VPWR VGND sg13g2_fill_2
XFILLER_65_1797 VPWR VGND sg13g2_fill_2
XFILLER_77_62 VPWR VGND sg13g2_fill_2
XFILLER_46_1196 VPWR VGND sg13g2_fill_2
X_19651_ _19651_/Y _19696_/B _19410_/Y _19650_/Y VPWR VGND sg13g2_a21oi_1
X_16863_ _16864_/A _22684_/Q _16893_/A VPWR VGND sg13g2_xnor2_1
XFILLER_78_898 VPWR VGND sg13g2_fill_2
XFILLER_19_910 VPWR VGND sg13g2_decap_8
X_18602_ _18757_/A _18602_/A _18602_/B VPWR VGND sg13g2_nand2_1
XFILLER_24_1472 VPWR VGND sg13g2_fill_2
X_15814_ _15815_/D _22609_/Q _15992_/A2 _15813_/Y VPWR VGND sg13g2_a21oi_1
X_19582_ _19582_/Y _19582_/A _19582_/B VPWR VGND sg13g2_nor2_1
XFILLER_19_943 VPWR VGND sg13g2_decap_4
X_16794_ _16796_/A _22670_/Q VPWR VGND sg13g2_inv_1
XFILLER_59_1502 VPWR VGND sg13g2_decap_4
XFILLER_111_1453 VPWR VGND sg13g2_decap_8
XFILLER_18_442 VPWR VGND sg13g2_decap_8
XFILLER_4_1577 VPWR VGND sg13g2_decap_8
XFILLER_46_751 VPWR VGND sg13g2_fill_1
XFILLER_4_1588 VPWR VGND sg13g2_fill_1
X_18533_ _18533_/Y _18544_/A _18533_/B VPWR VGND sg13g2_nor2_1
XFILLER_93_61 VPWR VGND sg13g2_decap_8
XFILLER_92_378 VPWR VGND sg13g2_fill_1
XFILLER_80_518 VPWR VGND sg13g2_decap_4
XFILLER_19_987 VPWR VGND sg13g2_fill_2
X_15745_ _15745_/Y _15745_/A _15745_/B _15745_/C _15745_/D VPWR VGND sg13g2_nand4_1
X_12957_ _12964_/A _12963_/A _12957_/B VPWR VGND sg13g2_nand2_1
XFILLER_33_412 VPWR VGND sg13g2_decap_8
XFILLER_34_935 VPWR VGND sg13g2_fill_1
XFILLER_34_946 VPWR VGND sg13g2_fill_2
X_18464_ _18464_/Y _18464_/A _18544_/A VPWR VGND sg13g2_nor2_1
X_15676_ _16126_/A _23014_/Q _22564_/Q _15982_/S VPWR VGND sg13g2_mux2_1
X_12888_ _12888_/X _23301_/Q _23333_/Q _23365_/Q _23397_/Q _12983_/A _12986_/S1 VPWR
+ VGND sg13g2_mux4_1
XFILLER_37_1811 VPWR VGND sg13g2_decap_4
XFILLER_37_1822 VPWR VGND sg13g2_fill_1
X_17415_ _22826_/D _17899_/A _17419_/B _17414_/Y VPWR VGND sg13g2_o21ai_1
X_14627_ _14627_/X _14615_/Y _14616_/Y _14699_/B VPWR VGND sg13g2_mux2_1
XFILLER_76_1893 VPWR VGND sg13g2_decap_4
X_11839_ _11839_/Y _23513_/Q _11843_/S VPWR VGND sg13g2_nand2b_1
X_18395_ _18395_/Y _18395_/A VPWR VGND sg13g2_inv_1
XFILLER_14_670 VPWR VGND sg13g2_decap_4
XFILLER_72_1746 VPWR VGND sg13g2_fill_2
XFILLER_18_1243 VPWR VGND sg13g2_decap_8
Xplace4106 _14438_/B _22994_/Q VPWR VGND sg13g2_buf_1
Xplace4117 _14441_/A _13960_/S1 VPWR VGND sg13g2_buf_1
X_17346_ _17346_/Y _17346_/A _17358_/B VPWR VGND sg13g2_nand2_1
Xplace4128 _13559_/S1 _13702_/A VPWR VGND sg13g2_buf_1
XFILLER_14_1107 VPWR VGND sg13g2_decap_8
X_14558_ _14559_/C _18446_/S _18771_/B _19054_/S VPWR VGND sg13g2_a21oi_1
XFILLER_72_1779 VPWR VGND sg13g2_decap_8
Xplace4139 _11295_/A _11699_/S VPWR VGND sg13g2_buf_2
XFILLER_9_140 VPWR VGND sg13g2_decap_8
Xplace3405 _17341_/B _17371_/S VPWR VGND sg13g2_buf_1
Xplace3416 _17270_/B _17266_/B VPWR VGND sg13g2_buf_1
X_13509_ _13522_/A _13509_/A _13932_/B _13932_/C _13509_/D VPWR VGND sg13g2_and4_1
Xplace3427 _16517_/S _16456_/B VPWR VGND sg13g2_buf_1
X_17277_ _17277_/Y _17277_/A _17293_/B VPWR VGND sg13g2_nand2_1
Xplace3438 _17869_/B _17853_/C VPWR VGND sg13g2_buf_1
X_14489_ _14491_/C _22592_/Q _23003_/Q VPWR VGND sg13g2_xor2_1
Xplace3449 _17652_/B _17642_/B VPWR VGND sg13g2_buf_1
X_19016_ _23058_/D _19010_/Y _19013_/Y _19014_/Y _19015_/Y VPWR VGND sg13g2_a22oi_1
XFILLER_31_1454 VPWR VGND sg13g2_decap_4
X_16228_ _16228_/Y _22516_/Q _16237_/D VPWR VGND sg13g2_nand2_1
XFILLER_115_712 VPWR VGND sg13g2_decap_8
X_16159_ _22503_/D _16145_/B _16157_/Y _16158_/Y VPWR VGND sg13g2_o21ai_1
XFILLER_103_907 VPWR VGND sg13g2_decap_8
XFILLER_88_607 VPWR VGND sg13g2_fill_2
XFILLER_47_0 VPWR VGND sg13g2_decap_8
XFILLER_115_789 VPWR VGND sg13g2_decap_8
XFILLER_114_266 VPWR VGND sg13g2_decap_8
XFILLER_69_810 VPWR VGND sg13g2_fill_2
XFILLER_102_428 VPWR VGND sg13g2_decap_4
XFILLER_29_1372 VPWR VGND sg13g2_decap_8
XFILLER_69_832 VPWR VGND sg13g2_decap_8
X_19918_ _19918_/Y _19918_/A VPWR VGND sg13g2_inv_1
XFILLER_83_1897 VPWR VGND sg13g2_fill_2
XFILLER_5_1308 VPWR VGND sg13g2_fill_2
XFILLER_68_342 VPWR VGND sg13g2_decap_8
X_19849_ _19850_/B _19886_/A1 _20343_/A0 _19509_/Y _23219_/Q VPWR VGND sg13g2_a22oi_1
XFILLER_28_206 VPWR VGND sg13g2_decap_8
XFILLER_56_526 VPWR VGND sg13g2_decap_8
XFILLER_68_386 VPWR VGND sg13g2_fill_1
XFILLER_84_846 VPWR VGND sg13g2_fill_1
XFILLER_110_494 VPWR VGND sg13g2_decap_8
X_22860_ _22860_/Q _22869_/CLK _22860_/D fanout2797/X VPWR VGND sg13g2_dfrbpq_1
XFILLER_113_49 VPWR VGND sg13g2_decap_8
XFILLER_83_356 VPWR VGND sg13g2_decap_8
X_21811_ _23902_/D _22211_/A1 _21818_/B _21810_/Y VPWR VGND sg13g2_o21ai_1
XFILLER_3_1065 VPWR VGND sg13g2_fill_2
XFILLER_37_762 VPWR VGND sg13g2_decap_8
X_22791_ _22791_/Q clkload18/A _22791_/D fanout2828/X VPWR VGND sg13g2_dfrbpq_1
XFILLER_24_401 VPWR VGND sg13g2_fill_2
XFILLER_64_570 VPWR VGND sg13g2_decap_8
XFILLER_20_1870 VPWR VGND sg13g2_fill_1
XFILLER_25_935 VPWR VGND sg13g2_fill_1
XFILLER_0_1942 VPWR VGND sg13g2_decap_8
XFILLER_0_1953 VPWR VGND sg13g2_fill_2
XFILLER_38_1619 VPWR VGND sg13g2_decap_4
X_21742_ _21742_/Y _21742_/A _21751_/B VPWR VGND sg13g2_nand2_1
XFILLER_52_732 VPWR VGND sg13g2_fill_1
XFILLER_24_434 VPWR VGND sg13g2_decap_8
XFILLER_51_231 VPWR VGND sg13g2_fill_2
XFILLER_24_467 VPWR VGND sg13g2_fill_2
XFILLER_12_618 VPWR VGND sg13g2_decap_8
XFILLER_40_927 VPWR VGND sg13g2_decap_8
XFILLER_58_1089 VPWR VGND sg13g2_fill_1
X_21673_ _23849_/D _23849_/Q _21965_/A0 _21689_/S VPWR VGND sg13g2_mux2_1
XFILLER_51_275 VPWR VGND sg13g2_fill_2
X_23412_ _23412_/Q _24214_/CLK _23412_/D fanout2628/X VPWR VGND sg13g2_dfrbpq_1
X_20624_ _20624_/Y _20624_/A _20624_/B VPWR VGND sg13g2_nand2_1
XFILLER_36_1354 VPWR VGND sg13g2_decap_8
XFILLER_90_1879 VPWR VGND sg13g2_fill_2
XFILLER_36_1398 VPWR VGND sg13g2_fill_1
X_23343_ _23343_/Q clkload31/A _23343_/D fanout2646/X VPWR VGND sg13g2_dfrbpq_1
X_20555_ _20555_/Y _20555_/A _20565_/B VPWR VGND sg13g2_nand2_1
XFILLER_53_1690 VPWR VGND sg13g2_decap_8
XFILLER_101_1611 VPWR VGND sg13g2_fill_2
Xplace3950 _20317_/B _20352_/A VPWR VGND sg13g2_buf_1
X_23274_ _23274_/Q clkload34/A _23274_/D fanout2697/X VPWR VGND sg13g2_dfrbpq_1
Xplace3961 _14872_/A _14854_/B VPWR VGND sg13g2_buf_1
Xplace3972 _18886_/A _18771_/B VPWR VGND sg13g2_buf_1
Xplace3983 _12318_/A _14439_/A VPWR VGND sg13g2_buf_1
XFILLER_101_1655 VPWR VGND sg13g2_decap_4
XFILLER_98_28 VPWR VGND sg13g2_decap_8
XFILLER_49_1715 VPWR VGND sg13g2_fill_1
X_22225_ _22225_/Y _24101_/Q _22229_/B VPWR VGND sg13g2_nand2_1
Xplace3994 _13028_/B _12738_/B VPWR VGND sg13g2_buf_2
XFILLER_69_1152 VPWR VGND sg13g2_decap_8
XFILLER_49_1737 VPWR VGND sg13g2_fill_2
Xhold4641 _18140_/A _22963_/Q VPWR VGND sg13g2_dlygate4sd3_1
X_22156_ _22156_/Y _24068_/Q _22160_/B VPWR VGND sg13g2_nand2_1
XFILLER_79_629 VPWR VGND sg13g2_decap_4
Xhold4652 _17503_/A _22869_/Q VPWR VGND sg13g2_dlygate4sd3_1
Xhold4663 _17326_/A _22791_/Q VPWR VGND sg13g2_dlygate4sd3_1
Xhold4674 _17324_/A _22790_/Q VPWR VGND sg13g2_dlygate4sd3_1
XFILLER_82_1330 VPWR VGND sg13g2_decap_8
XFILLER_105_288 VPWR VGND sg13g2_decap_8
X_21107_ _23579_/D _21307_/A1 _21112_/B _21106_/Y VPWR VGND sg13g2_o21ai_1
XFILLER_78_139 VPWR VGND sg13g2_fill_2
Xhold4685 _17266_/A _22763_/Q VPWR VGND sg13g2_dlygate4sd3_1
Xhold4696 _17244_/A _22753_/Q VPWR VGND sg13g2_dlygate4sd3_1
XFILLER_59_320 VPWR VGND sg13g2_decap_4
X_22087_ _22087_/Y _22087_/A _22101_/B VPWR VGND sg13g2_nand2_1
XFILLER_102_940 VPWR VGND sg13g2_fill_2
XFILLER_59_331 VPWR VGND sg13g2_decap_8
X_21038_ _21038_/Y _21038_/A _21042_/B VPWR VGND sg13g2_nand2_1
XFILLER_47_504 VPWR VGND sg13g2_fill_2
XFILLER_75_835 VPWR VGND sg13g2_fill_2
XFILLER_47_537 VPWR VGND sg13g2_decap_8
XFILLER_75_846 VPWR VGND sg13g2_fill_2
XFILLER_19_239 VPWR VGND sg13g2_fill_2
XFILLER_47_65 VPWR VGND sg13g2_decap_8
X_13860_ _13860_/Y _14104_/A _20292_/A _13860_/C _13860_/D VPWR VGND sg13g2_nor4_1
XFILLER_74_334 VPWR VGND sg13g2_fill_1
XFILLER_75_857 VPWR VGND sg13g2_decap_4
XFILLER_1_1706 VPWR VGND sg13g2_decap_8
XFILLER_5_1875 VPWR VGND sg13g2_decap_8
XFILLER_21_1645 VPWR VGND sg13g2_decap_8
XFILLER_41_1071 VPWR VGND sg13g2_decap_8
X_12811_ _12811_/Y _13595_/B2 _12808_/Y _12810_/Y _13678_/A1 _13419_/A VPWR VGND sg13g2_a221oi_1
XFILLER_90_827 VPWR VGND sg13g2_decap_8
X_13791_ _13791_/Y _13794_/S _13788_/X _13790_/X VPWR VGND sg13g2_a21oi_1
XFILLER_90_838 VPWR VGND sg13g2_fill_2
XFILLER_15_401 VPWR VGND sg13g2_decap_8
XFILLER_21_1678 VPWR VGND sg13g2_fill_1
X_22989_ _22989_/Q _23187_/CLK _22989_/D fanout2917/X VPWR VGND sg13g2_dfrbpq_1
XFILLER_27_272 VPWR VGND sg13g2_decap_4
XFILLER_95_1757 VPWR VGND sg13g2_decap_8
XFILLER_55_592 VPWR VGND sg13g2_decap_8
X_12742_ _12743_/B _23459_/Q _23523_/Q _23619_/Q _23683_/Q _12733_/S _12982_/S1 VPWR
+ VGND sg13g2_mux4_1
XFILLER_27_294 VPWR VGND sg13g2_decap_8
XFILLER_37_1107 VPWR VGND sg13g2_fill_1
XFILLER_63_42 VPWR VGND sg13g2_fill_2
XFILLER_70_551 VPWR VGND sg13g2_decap_8
XFILLER_43_776 VPWR VGND sg13g2_fill_1
X_15461_ _16016_/A _15319_/C _15461_/B VPWR VGND sg13g2_nand2b_1
XFILLER_42_264 VPWR VGND sg13g2_decap_8
X_12673_ _12676_/A _23842_/Q _23874_/Q _23938_/Q _23970_/Q _13275_/S0 _12884_/B VPWR
+ VGND sg13g2_mux4_1
XFILLER_54_1421 VPWR VGND sg13g2_fill_1
XFILLER_70_584 VPWR VGND sg13g2_fill_1
X_17200_ _17201_/B _17218_/A _17218_/B _17205_/B VPWR VGND sg13g2_nor3_1
X_18180_ _18359_/B _18415_/B _18259_/B VPWR VGND sg13g2_nor2_1
X_15392_ _15396_/B _22754_/Q _17234_/A _17303_/A _22786_/Q VPWR VGND sg13g2_a22oi_1
XFILLER_106_1555 VPWR VGND sg13g2_fill_1
X_17131_ _22730_/D _17141_/B _17129_/Y _17130_/Y VPWR VGND sg13g2_a21oi_1
X_14343_ _15257_/B _14295_/A _12151_/Y _14342_/Y VPWR VGND sg13g2_a21o_1
XFILLER_32_1730 VPWR VGND sg13g2_decap_8
X_11555_ _11555_/Y _14129_/C _13186_/B _20272_/A VPWR VGND sg13g2_nor3_1
XFILLER_10_172 VPWR VGND sg13g2_decap_8
X_17062_ _17062_/X _22718_/Q _17062_/B VPWR VGND sg13g2_xor2_1
X_14274_ _14279_/A _14274_/A _14196_/B VPWR VGND sg13g2_nor2b_1
XFILLER_100_1110 VPWR VGND sg13g2_decap_8
XFILLER_87_1241 VPWR VGND sg13g2_decap_8
X_16013_ _16014_/B _22747_/Q _16013_/A2 _16013_/B1 _22683_/Q VPWR VGND sg13g2_a22oi_1
X_13225_ _13225_/Y _13225_/A _14045_/B VPWR VGND sg13g2_xnor2_1
XFILLER_109_594 VPWR VGND sg13g2_decap_8
XFILLER_67_1837 VPWR VGND sg13g2_decap_8
XFILLER_83_1116 VPWR VGND sg13g2_decap_4
XFILLER_100_1187 VPWR VGND sg13g2_decap_8
X_13156_ _13156_/X _23305_/Q _23337_/Q _23369_/Q _23401_/Q _13983_/S0 _11390_/A VPWR
+ VGND sg13g2_mux4_1
XFILLER_40_7 VPWR VGND sg13g2_decap_8
XFILLER_48_1247 VPWR VGND sg13g2_decap_4
XFILLER_88_72 VPWR VGND sg13g2_fill_1
XFILLER_112_726 VPWR VGND sg13g2_decap_8
XFILLER_111_203 VPWR VGND sg13g2_decap_8
XFILLER_3_883 VPWR VGND sg13g2_decap_8
X_12107_ _12107_/X _12965_/A _12965_/B _12966_/A VPWR VGND sg13g2_and3_1
XFILLER_65_1550 VPWR VGND sg13g2_fill_2
XFILLER_26_1512 VPWR VGND sg13g2_decap_4
X_13087_ _13087_/Y _14104_/A _13087_/B VPWR VGND sg13g2_xnor2_1
X_19703_ _19705_/B _19703_/A _19703_/B VPWR VGND sg13g2_nand2_1
X_16915_ _16915_/Y _22693_/Q _16915_/B VPWR VGND sg13g2_xnor2_1
X_12038_ _12099_/A _12824_/B1 _12036_/X _12037_/Y VPWR VGND sg13g2_a21o_1
XFILLER_84_109 VPWR VGND sg13g2_fill_2
X_17895_ _22929_/D _17895_/A _17895_/B VPWR VGND sg13g2_nand2_1
XFILLER_61_1458 VPWR VGND sg13g2_decap_4
Xclkbuf_leaf_34_clk_i clkload59/A clkload4/A VPWR VGND sg13g2_buf_16
XFILLER_77_161 VPWR VGND sg13g2_decap_8
X_19634_ _19634_/X _19634_/A _19634_/B VPWR VGND sg13g2_and2_1
XFILLER_77_183 VPWR VGND sg13g2_decap_8
X_16846_ _16846_/Y _16846_/A _16846_/B VPWR VGND sg13g2_nand2_1
XFILLER_65_334 VPWR VGND sg13g2_decap_4
XFILLER_77_194 VPWR VGND sg13g2_fill_2
XFILLER_4_1341 VPWR VGND sg13g2_fill_1
XFILLER_38_559 VPWR VGND sg13g2_fill_1
XFILLER_65_356 VPWR VGND sg13g2_decap_4
X_19565_ _19566_/B _19562_/Y _19564_/Y _19712_/B VPWR VGND sg13g2_mux2_1
XFILLER_93_687 VPWR VGND sg13g2_fill_1
XFILLER_19_773 VPWR VGND sg13g2_fill_2
XFILLER_25_209 VPWR VGND sg13g2_fill_1
XFILLER_92_164 VPWR VGND sg13g2_decap_8
X_16777_ _16778_/D _16776_/C _15247_/Y _15246_/B VPWR VGND sg13g2_o21ai_1
XFILLER_18_250 VPWR VGND sg13g2_decap_4
XFILLER_4_1385 VPWR VGND sg13g2_fill_1
X_13989_ _16017_/A _13989_/A1 _13986_/Y _13988_/Y VPWR VGND sg13g2_a21o_1
XFILLER_92_186 VPWR VGND sg13g2_decap_8
X_18516_ _18516_/Y _18254_/A _18334_/A _18509_/X _18301_/B VPWR VGND sg13g2_a22oi_1
XFILLER_34_743 VPWR VGND sg13g2_decap_8
X_15728_ _15729_/B _22702_/Q _15898_/A2 _15898_/B1 _22638_/Q VPWR VGND sg13g2_a22oi_1
Xclkbuf_leaf_49_clk_i clkload45/A clkload2/A VPWR VGND sg13g2_buf_16
XFILLER_22_916 VPWR VGND sg13g2_fill_2
XFILLER_94_1289 VPWR VGND sg13g2_decap_8
X_18447_ _18447_/X _18052_/X _18816_/B _18538_/S VPWR VGND sg13g2_mux2_1
XFILLER_107_1308 VPWR VGND sg13g2_fill_1
X_15659_ _15661_/A _22855_/Q _15989_/A2 _15684_/B _22893_/Q VPWR VGND sg13g2_a22oi_1
XFILLER_33_286 VPWR VGND sg13g2_decap_8
XFILLER_37_1663 VPWR VGND sg13g2_fill_2
X_18378_ _18382_/C _18539_/B _18334_/A _18375_/Y _18377_/X _18269_/A VPWR VGND sg13g2_a221oi_1
XFILLER_72_1576 VPWR VGND sg13g2_decap_8
Xplace3202 _20972_/A1 _20202_/X VPWR VGND sg13g2_buf_1
Xplace3213 _20269_/B _20300_/B VPWR VGND sg13g2_buf_1
X_17329_ _17329_/Y _17329_/A _17366_/S VPWR VGND sg13g2_nand2_1
Xplace3224 _21725_/B _21716_/B VPWR VGND sg13g2_buf_1
Xplace3235 _21690_/B _21687_/B VPWR VGND sg13g2_buf_1
XFILLER_88_1016 VPWR VGND sg13g2_decap_8
Xplace3246 _21154_/B _21151_/B VPWR VGND sg13g2_buf_1
Xplace3257 _22449_/A1 _22315_/A0 VPWR VGND sg13g2_buf_1
X_20340_ _20340_/Y _13940_/X _20319_/B _20356_/B _20339_/Y _15996_/B VPWR VGND sg13g2_a221oi_1
XFILLER_11_1825 VPWR VGND sg13g2_decap_8
Xplace3268 _22309_/A0 _20280_/Y VPWR VGND sg13g2_buf_1
Xplace3279 _21335_/A0 _21964_/A0 VPWR VGND sg13g2_buf_1
X_20271_ _20272_/B _20271_/A _20271_/B _20319_/B VPWR VGND sg13g2_nand3_1
XFILLER_108_49 VPWR VGND sg13g2_decap_8
XFILLER_88_404 VPWR VGND sg13g2_decap_8
XFILLER_115_586 VPWR VGND sg13g2_decap_8
XFILLER_102_214 VPWR VGND sg13g2_decap_8
XFILLER_88_437 VPWR VGND sg13g2_decap_4
XFILLER_9_1230 VPWR VGND sg13g2_decap_8
XFILLER_48_1781 VPWR VGND sg13g2_decap_4
XFILLER_103_759 VPWR VGND sg13g2_fill_1
XFILLER_88_459 VPWR VGND sg13g2_decap_8
XFILLER_25_1033 VPWR VGND sg13g2_decap_8
X_23961_ _23961_/Q _23966_/CLK _23961_/D fanout2765/X VPWR VGND sg13g2_dfrbpq_1
XFILLER_44_1667 VPWR VGND sg13g2_fill_2
XFILLER_64_1093 VPWR VGND sg13g2_decap_8
XFILLER_96_470 VPWR VGND sg13g2_decap_8
XFILLER_68_161 VPWR VGND sg13g2_decap_8
XFILLER_96_481 VPWR VGND sg13g2_fill_1
XFILLER_22_1910 VPWR VGND sg13g2_decap_8
XFILLER_56_312 VPWR VGND sg13g2_decap_8
XFILLER_84_632 VPWR VGND sg13g2_fill_2
X_22912_ _22912_/Q clkload21/A _22912_/D fanout2875/X VPWR VGND sg13g2_dfrbpq_1
XFILLER_57_857 VPWR VGND sg13g2_decap_4
XFILLER_110_280 VPWR VGND sg13g2_fill_1
XFILLER_83_120 VPWR VGND sg13g2_fill_2
X_23892_ _23892_/Q clkload29/A _23892_/D fanout2669/X VPWR VGND sg13g2_dfrbpq_1
XFILLER_68_194 VPWR VGND sg13g2_decap_8
XFILLER_83_142 VPWR VGND sg13g2_decap_8
XFILLER_22_1954 VPWR VGND sg13g2_fill_1
XFILLER_17_24 VPWR VGND sg13g2_fill_1
XFILLER_83_153 VPWR VGND sg13g2_fill_1
X_22843_ _22843_/Q clkload18/A _22843_/D fanout2828/X VPWR VGND sg13g2_dfrbpq_1
XFILLER_56_378 VPWR VGND sg13g2_decap_8
XFILLER_83_186 VPWR VGND sg13g2_decap_4
XFILLER_65_890 VPWR VGND sg13g2_decap_4
X_22774_ _22774_/Q _22869_/CLK _22774_/D fanout2793/X VPWR VGND sg13g2_dfrbpq_1
XFILLER_24_231 VPWR VGND sg13g2_decap_8
X_21725_ _21725_/Y _23870_/Q _21725_/B VPWR VGND sg13g2_nand2_1
XFILLER_25_787 VPWR VGND sg13g2_decap_8
XFILLER_52_584 VPWR VGND sg13g2_decap_8
X_21656_ _23841_/D _21950_/A1 _21657_/B _21655_/Y VPWR VGND sg13g2_o21ai_1
XFILLER_107_1853 VPWR VGND sg13g2_decap_8
XFILLER_8_419 VPWR VGND sg13g2_fill_1
XFILLER_103_1706 VPWR VGND sg13g2_fill_1
X_20607_ _20607_/Y _23358_/Q _20607_/B VPWR VGND sg13g2_nand2_1
X_21587_ _23808_/D _21587_/A1 _21590_/B _21586_/Y VPWR VGND sg13g2_o21ai_1
XFILLER_20_481 VPWR VGND sg13g2_fill_2
X_11340_ _11340_/X _23575_/Q _23607_/Q _23639_/Q _23671_/Q _11924_/S0 _11538_/S1 VPWR
+ VGND sg13g2_mux4_1
Xrebuffer5460 _12743_/A place3976/A VPWR VGND sg13g2_buf_1
X_23326_ _23326_/Q _24190_/CLK _23326_/D fanout2775/X VPWR VGND sg13g2_dfrbpq_1
Xrebuffer5471 _12096_/B _11994_/Y VPWR VGND sg13g2_buf_2
X_20538_ _23325_/D _21178_/A1 _20539_/B _20537_/Y VPWR VGND sg13g2_o21ai_1
XFILLER_14_1482 VPWR VGND sg13g2_fill_2
Xrebuffer5482 _14875_/A _14407_/X VPWR VGND sg13g2_buf_1
XFILLER_14_1493 VPWR VGND sg13g2_decap_4
Xrebuffer5493 _13499_/B _20243_/B VPWR VGND sg13g2_buf_1
Xplace3780 _12852_/A _13854_/A VPWR VGND sg13g2_buf_1
XFILLER_101_1452 VPWR VGND sg13g2_fill_1
Xplace3791 _15186_/A _19605_/A VPWR VGND sg13g2_buf_1
X_11271_ _12668_/A _11502_/A _11502_/B _11502_/C _11502_/D VPWR VGND sg13g2_and4_1
X_23257_ _23257_/Q _24190_/CLK _23257_/D fanout2770/X VPWR VGND sg13g2_dfrbpq_1
XFILLER_106_531 VPWR VGND sg13g2_decap_8
X_20469_ _20469_/Y _23296_/Q _20473_/B VPWR VGND sg13g2_nand2_1
XFILLER_88_1583 VPWR VGND sg13g2_decap_4
XFILLER_3_124 VPWR VGND sg13g2_decap_8
Xhold5150 _21302_/A _23673_/Q VPWR VGND sg13g2_dlygate4sd3_1
X_13010_ _13010_/Y _12994_/Y _12995_/Y _13009_/Y _13989_/A1 VPWR VGND sg13g2_a22oi_1
Xhold5161 _21885_/A _23938_/Q VPWR VGND sg13g2_dlygate4sd3_1
X_22208_ _22208_/Y _22208_/A _22210_/B VPWR VGND sg13g2_nand2_1
Xhold5172 _21162_/A _23606_/Q VPWR VGND sg13g2_dlygate4sd3_1
X_23188_ _23188_/Q _24214_/CLK _23188_/D fanout2928/X VPWR VGND sg13g2_dfrbpq_1
Xhold5183 _20866_/A _23480_/Q VPWR VGND sg13g2_dlygate4sd3_1
XFILLER_3_179 VPWR VGND sg13g2_fill_2
Xhold5194 _20458_/A _23291_/Q VPWR VGND sg13g2_dlygate4sd3_1
XFILLER_58_20 VPWR VGND sg13g2_decap_8
X_22139_ _24060_/D _22272_/A1 _22142_/B _22138_/Y VPWR VGND sg13g2_o21ai_1
XFILLER_7_1904 VPWR VGND sg13g2_decap_8
XFILLER_43_1144 VPWR VGND sg13g2_fill_1
XFILLER_48_813 VPWR VGND sg13g2_decap_8
XFILLER_102_770 VPWR VGND sg13g2_fill_2
XFILLER_114_1846 VPWR VGND sg13g2_decap_8
XFILLER_23_1729 VPWR VGND sg13g2_fill_1
X_16700_ _16701_/B _22655_/Q _16709_/C VPWR VGND sg13g2_xnor2_1
XFILLER_59_172 VPWR VGND sg13g2_decap_8
X_13912_ _13912_/Y _13912_/A VPWR VGND sg13g2_inv_1
XFILLER_101_280 VPWR VGND sg13g2_fill_1
X_17680_ _17680_/Y _23169_/Q _17590_/B _17699_/B1 _17679_/Y VPWR VGND sg13g2_a22oi_1
XFILLER_43_1188 VPWR VGND sg13g2_decap_8
X_14892_ _14892_/Y _14982_/S _23132_/Q VPWR VGND sg13g2_nor2_1
XFILLER_114_70 VPWR VGND sg13g2_decap_8
XFILLER_5_1661 VPWR VGND sg13g2_decap_4
XFILLER_63_816 VPWR VGND sg13g2_decap_8
XFILLER_90_602 VPWR VGND sg13g2_decap_8
XFILLER_60_1491 VPWR VGND sg13g2_fill_2
X_16631_ _16632_/B _22641_/Q _16631_/B VPWR VGND sg13g2_xnor2_1
XFILLER_21_1453 VPWR VGND sg13g2_decap_8
X_13843_ _13843_/X _13839_/X _13840_/X _13841_/X _13842_/X _18444_/A1 _13141_/B VPWR
+ VGND sg13g2_mux4_1
XFILLER_1_1547 VPWR VGND sg13g2_decap_8
XFILLER_95_1543 VPWR VGND sg13g2_decap_4
X_19350_ _19350_/X _19928_/A _13440_/B _19448_/B VPWR VGND sg13g2_mux2_1
XFILLER_90_646 VPWR VGND sg13g2_decap_8
XFILLER_28_592 VPWR VGND sg13g2_decap_8
XFILLER_74_197 VPWR VGND sg13g2_fill_2
X_16562_ _22627_/D _17854_/A1 _16561_/A _16561_/Y VPWR VGND sg13g2_a21oi_1
X_13774_ _13774_/X _13774_/A _13774_/B VPWR VGND sg13g2_and2_1
XFILLER_43_540 VPWR VGND sg13g2_decap_8
XFILLER_15_242 VPWR VGND sg13g2_decap_8
X_18301_ _18301_/Y _18301_/A _18301_/B _18301_/C VPWR VGND sg13g2_nand3_1
X_15513_ _17858_/A _19428_/A _15335_/B _15510_/Y _15512_/Y VPWR VGND sg13g2_a22oi_1
XFILLER_71_871 VPWR VGND sg13g2_decap_8
XFILLER_16_787 VPWR VGND sg13g2_fill_2
X_19281_ _23199_/D _23199_/Q _20278_/A1 _19298_/S VPWR VGND sg13g2_mux2_1
X_12725_ _12725_/Y _13692_/A _13692_/B _12725_/C _12725_/D VPWR VGND sg13g2_nand4_1
XFILLER_31_724 VPWR VGND sg13g2_fill_2
X_16493_ _22608_/D _16154_/X _16495_/S _16492_/Y VPWR VGND sg13g2_o21ai_1
XFILLER_30_212 VPWR VGND sg13g2_fill_1
XFILLER_43_595 VPWR VGND sg13g2_decap_8
XFILLER_90_40 VPWR VGND sg13g2_decap_8
Xinput4370 _17920_/A1 boot_addr_i[28] VPWR VGND sg13g2_buf_1
X_18232_ _18232_/Y _18297_/B _18232_/B VPWR VGND sg13g2_nand2_1
Xinput4381 _20310_/A1 data_rdata_i[12] VPWR VGND sg13g2_buf_1
X_15444_ _15451_/A _22756_/Q _15312_/Y _15306_/B _22546_/Q VPWR VGND sg13g2_a22oi_1
Xinput4392 _20343_/A3 data_rdata_i[22] VPWR VGND sg13g2_buf_1
X_12656_ _12656_/Y _12997_/S _24098_/Q _12655_/Y VPWR VGND sg13g2_o21ai_1
X_18163_ _18332_/B _18562_/C _18416_/A VPWR VGND sg13g2_nor2_1
X_11607_ _11607_/Y _11305_/Y _11605_/Y _11606_/X VPWR VGND sg13g2_o21ai_1
X_15375_ _15375_/Y _19728_/B _15785_/B _15374_/X VPWR VGND sg13g2_a21oi_1
X_12587_ _12587_/X _23841_/Q _23873_/Q _23937_/Q _23969_/Q _12651_/S0 _12651_/S1 VPWR
+ VGND sg13g2_mux4_1
X_17114_ _22727_/D _17113_/B _17112_/Y _17113_/Y VPWR VGND sg13g2_a21oi_1
X_14326_ _15424_/A _19980_/B _14369_/D VPWR VGND sg13g2_and2_1
XFILLER_8_975 VPWR VGND sg13g2_decap_8
X_11538_ _11539_/B _23285_/Q _23317_/Q _23349_/Q _23381_/Q _11923_/S0 _11538_/S1 VPWR
+ VGND sg13g2_mux4_1
X_18094_ _18569_/B _22997_/Q _24226_/Q VPWR VGND sg13g2_and2_1
X_17045_ _17144_/B _17045_/A _17045_/B _17045_/C VPWR VGND sg13g2_nand3_1
X_11469_ _11953_/A _12128_/A _11792_/S VPWR VGND sg13g2_nor2_1
X_13208_ _13215_/A _13208_/A _13208_/B VPWR VGND sg13g2_nor2_1
XFILLER_98_724 VPWR VGND sg13g2_fill_2
XFILLER_28_1618 VPWR VGND sg13g2_fill_2
X_14188_ _24220_/D _14188_/A _11171_/A VPWR VGND sg13g2_nor2b_1
XFILLER_112_523 VPWR VGND sg13g2_decap_8
XFILLER_48_1066 VPWR VGND sg13g2_decap_8
X_13139_ _13140_/B _23848_/Q _23880_/Q _23944_/Q _23976_/Q _13635_/S0 _13631_/S1 VPWR
+ VGND sg13g2_mux4_1
XFILLER_97_245 VPWR VGND sg13g2_fill_2
X_18996_ _18997_/C _19003_/A _23089_/Q VPWR VGND sg13g2_nand2_1
XFILLER_86_919 VPWR VGND sg13g2_decap_8
XFILLER_6_1414 VPWR VGND sg13g2_decap_8
XFILLER_39_802 VPWR VGND sg13g2_decap_8
X_17947_ _17947_/Y _18358_/S _17947_/B VPWR VGND sg13g2_nand2_1
XFILLER_85_429 VPWR VGND sg13g2_decap_8
X_17878_ _17878_/Y _17878_/A _17917_/B VPWR VGND sg13g2_nor2_1
XFILLER_93_440 VPWR VGND sg13g2_decap_8
XFILLER_93_451 VPWR VGND sg13g2_fill_2
XFILLER_65_142 VPWR VGND sg13g2_fill_2
XFILLER_65_153 VPWR VGND sg13g2_fill_1
XFILLER_66_687 VPWR VGND sg13g2_fill_2
X_16829_ _16830_/B _22678_/Q _16829_/B VPWR VGND sg13g2_xnor2_1
XFILLER_81_624 VPWR VGND sg13g2_decap_8
XFILLER_93_484 VPWR VGND sg13g2_fill_2
XFILLER_53_326 VPWR VGND sg13g2_fill_2
XFILLER_81_646 VPWR VGND sg13g2_decap_8
X_19548_ _19548_/X _19372_/Y _19352_/Y _19589_/A VPWR VGND sg13g2_mux2_1
XFILLER_78_1763 VPWR VGND sg13g2_fill_1
XFILLER_111_1091 VPWR VGND sg13g2_decap_8
XFILLER_0_93 VPWR VGND sg13g2_decap_4
XFILLER_78_1796 VPWR VGND sg13g2_decap_8
XFILLER_22_702 VPWR VGND sg13g2_fill_1
XFILLER_74_1638 VPWR VGND sg13g2_decap_8
XFILLER_110_28 VPWR VGND sg13g2_decap_8
XFILLER_34_573 VPWR VGND sg13g2_fill_2
XFILLER_22_724 VPWR VGND sg13g2_decap_4
XFILLER_55_1037 VPWR VGND sg13g2_decap_4
XFILLER_91_1941 VPWR VGND sg13g2_decap_8
X_21510_ _21510_/Y _23772_/Q _21515_/B VPWR VGND sg13g2_nand2_1
XFILLER_22_746 VPWR VGND sg13g2_decap_8
XFILLER_107_1138 VPWR VGND sg13g2_decap_8
X_22490_ _22490_/Q clkload18/A _22490_/D fanout2829/X VPWR VGND sg13g2_dfrbpq_1
XFILLER_72_1340 VPWR VGND sg13g2_decap_8
XFILLER_22_779 VPWR VGND sg13g2_fill_1
XFILLER_21_267 VPWR VGND sg13g2_decap_8
X_21441_ _21441_/Y _23739_/Q _21441_/B VPWR VGND sg13g2_nand2_1
Xplace3010 _22269_/B _22263_/B VPWR VGND sg13g2_buf_1
XFILLER_21_289 VPWR VGND sg13g2_decap_8
Xplace3021 _22241_/B _22250_/B VPWR VGND sg13g2_buf_1
Xplace3032 _22151_/B _22160_/B VPWR VGND sg13g2_buf_1
X_24160_ _24160_/Q clkload41/A _24160_/D fanout2724/X VPWR VGND sg13g2_dfrbpq_1
X_21372_ _21372_/Y _23706_/Q _21374_/B VPWR VGND sg13g2_nand2_1
Xplace3043 _22031_/S _22047_/S VPWR VGND sg13g2_buf_1
Xplace3054 _21951_/B _21957_/B VPWR VGND sg13g2_buf_1
Xplace3065 _21900_/B _21916_/B VPWR VGND sg13g2_buf_1
Xplace3076 _21574_/B _21572_/B VPWR VGND sg13g2_buf_1
X_23111_ _23111_/Q _23114_/CLK _23111_/D fanout2907/X VPWR VGND sg13g2_dfrbpq_1
XFILLER_107_339 VPWR VGND sg13g2_decap_8
X_20323_ _20323_/Y _20322_/A _20320_/Y _20322_/Y VPWR VGND sg13g2_o21ai_1
X_24091_ _24091_/Q clkload52/A _24091_/D fanout2691/X VPWR VGND sg13g2_dfrbpq_1
Xplace3087 _21554_/S _21555_/B VPWR VGND sg13g2_buf_1
Xplace3098 _21467_/B _21486_/B VPWR VGND sg13g2_buf_1
XFILLER_85_1745 VPWR VGND sg13g2_fill_2
X_23042_ _23042_/Q clkload13/A _23042_/D fanout2907/X VPWR VGND sg13g2_dfrbpq_1
XFILLER_115_350 VPWR VGND sg13g2_decap_8
XFILLER_46_1707 VPWR VGND sg13g2_decap_8
X_20254_ _23245_/D _20251_/Y _23245_/Q _20283_/S VPWR VGND sg13g2_mux2_1
XFILLER_1_628 VPWR VGND sg13g2_decap_4
XFILLER_46_1718 VPWR VGND sg13g2_fill_1
XFILLER_115_383 VPWR VGND sg13g2_decap_8
XFILLER_103_534 VPWR VGND sg13g2_decap_8
XFILLER_89_757 VPWR VGND sg13g2_decap_8
X_20185_ _20185_/X _20310_/A3 _23217_/Q _20310_/A2 _20310_/A1 _20350_/A _20310_/S0
+ VPWR VGND sg13g2_mux4_1
XFILLER_77_919 VPWR VGND sg13g2_fill_1
XFILLER_0_149 VPWR VGND sg13g2_decap_4
XFILLER_76_418 VPWR VGND sg13g2_decap_8
XFILLER_69_481 VPWR VGND sg13g2_decap_8
XFILLER_40_1317 VPWR VGND sg13g2_decap_4
X_23944_ _23944_/Q clkload31/A _23944_/D fanout2653/X VPWR VGND sg13g2_dfrbpq_1
XFILLER_29_334 VPWR VGND sg13g2_decap_4
XFILLER_57_654 VPWR VGND sg13g2_decap_4
XFILLER_85_996 VPWR VGND sg13g2_decap_8
XFILLER_2_1834 VPWR VGND sg13g2_decap_8
XFILLER_22_1762 VPWR VGND sg13g2_fill_1
X_23875_ _23875_/Q clkload45/A _23875_/D fanout2730/X VPWR VGND sg13g2_dfrbpq_1
XFILLER_44_337 VPWR VGND sg13g2_fill_1
X_22826_ _22826_/Q clkload7/A _22826_/D wire1183/A VPWR VGND sg13g2_dfrbpq_1
XFILLER_44_359 VPWR VGND sg13g2_fill_2
XFILLER_109_1904 VPWR VGND sg13g2_decap_8
XFILLER_38_1224 VPWR VGND sg13g2_fill_1
XFILLER_25_562 VPWR VGND sg13g2_decap_8
X_22757_ _22757_/Q clkload24/A _22757_/D fanout2898/X VPWR VGND sg13g2_dfrbpq_1
XFILLER_92_1749 VPWR VGND sg13g2_fill_1
XFILLER_12_212 VPWR VGND sg13g2_decap_8
XFILLER_38_1257 VPWR VGND sg13g2_decap_8
XFILLER_40_521 VPWR VGND sg13g2_fill_1
XFILLER_52_381 VPWR VGND sg13g2_decap_8
XFILLER_38_1279 VPWR VGND sg13g2_decap_8
X_12510_ _12538_/A _12829_/B _12512_/B VPWR VGND sg13g2_and2_1
X_13490_ _13490_/X _23917_/Q _24013_/Q _13617_/B VPWR VGND sg13g2_mux2_1
X_22688_ _22688_/Q clkload24/A _22688_/D fanout2890/X VPWR VGND sg13g2_dfrbpq_1
XFILLER_90_1462 VPWR VGND sg13g2_fill_2
X_12441_ _24255_/A _14059_/A VPWR VGND sg13g2_inv_2
XFILLER_103_1503 VPWR VGND sg13g2_decap_4
X_21639_ _23833_/D _21932_/A1 _21648_/B _21638_/Y VPWR VGND sg13g2_o21ai_1
XFILLER_103_1514 VPWR VGND sg13g2_decap_8
XFILLER_16_1577 VPWR VGND sg13g2_fill_1
XFILLER_21_790 VPWR VGND sg13g2_fill_1
X_12372_ _12379_/A _12774_/B _12372_/B VPWR VGND sg13g2_nor2_1
XFILLER_33_1880 VPWR VGND sg13g2_decap_8
XFILLER_60_87 VPWR VGND sg13g2_decap_4
XFILLER_114_0 VPWR VGND sg13g2_decap_8
Xrebuffer5290 _12340_/C _12260_/Y VPWR VGND sg13g2_buf_2
XFILLER_4_411 VPWR VGND sg13g2_decap_8
X_11323_ _15407_/A _22976_/Q VPWR VGND sg13g2_inv_1
X_14111_ _14111_/Y _19545_/A _14111_/B VPWR VGND sg13g2_nand2b_1
X_23309_ _23309_/Q clkload31/A _23309_/D fanout2646/X VPWR VGND sg13g2_dfrbpq_1
XFILLER_109_70 VPWR VGND sg13g2_decap_8
XFILLER_107_862 VPWR VGND sg13g2_decap_8
XFILLER_88_1380 VPWR VGND sg13g2_fill_2
X_14042_ _14042_/X _14042_/A _14042_/B VPWR VGND sg13g2_or2_1
X_11254_ _11254_/Y _14146_/B _11237_/Y _11241_/Y _11245_/X _13350_/A VPWR VGND sg13g2_a221oi_1
XFILLER_69_30 VPWR VGND sg13g2_decap_8
XFILLER_29_1927 VPWR VGND sg13g2_fill_1
XFILLER_106_383 VPWR VGND sg13g2_fill_2
X_18850_ _23042_/D _18850_/A _18850_/B _18850_/C VPWR VGND sg13g2_nand3_1
X_11185_ _11315_/D _11250_/A _22966_/Q VPWR VGND sg13g2_nor2b_2
XFILLER_68_919 VPWR VGND sg13g2_decap_8
X_17801_ _17801_/Y _23184_/Q _17801_/A2 _17822_/B1 _22992_/Q VPWR VGND sg13g2_a22oi_1
XFILLER_114_1610 VPWR VGND sg13g2_decap_8
X_18781_ _18782_/C _23063_/Q _18825_/B VPWR VGND sg13g2_nand2_1
XFILLER_62_1542 VPWR VGND sg13g2_fill_1
X_15993_ _15993_/Y _15993_/A _15993_/B _15993_/C _15993_/D VPWR VGND sg13g2_nand4_1
XFILLER_67_429 VPWR VGND sg13g2_decap_8
XFILLER_23_1515 VPWR VGND sg13g2_decap_4
XFILLER_62_1575 VPWR VGND sg13g2_decap_8
X_17732_ _17739_/B _22566_/Q _22565_/Q _17732_/C VPWR VGND sg13g2_nand3_1
XFILLER_48_632 VPWR VGND sg13g2_decap_4
X_14944_ _14944_/X _23137_/Q _14944_/A1 _14982_/S VPWR VGND sg13g2_mux2_1
XFILLER_7_1778 VPWR VGND sg13g2_decap_8
XFILLER_97_1605 VPWR VGND sg13g2_fill_1
XFILLER_63_602 VPWR VGND sg13g2_decap_8
XFILLER_97_1638 VPWR VGND sg13g2_decap_4
X_17663_ _17675_/B _22559_/Q _17663_/B VPWR VGND sg13g2_and2_1
X_14875_ _14875_/X _14875_/A _14875_/B _14875_/C VPWR VGND sg13g2_and3_1
XFILLER_47_186 VPWR VGND sg13g2_decap_8
X_19402_ _19764_/A _19777_/A _19477_/B VPWR VGND sg13g2_xnor2_1
XFILLER_21_1272 VPWR VGND sg13g2_fill_1
XFILLER_63_646 VPWR VGND sg13g2_decap_8
XFILLER_90_443 VPWR VGND sg13g2_decap_8
X_13826_ _13826_/Y _11861_/A _13819_/X _13825_/Y VPWR VGND sg13g2_o21ai_1
XFILLER_63_657 VPWR VGND sg13g2_decap_8
XFILLER_90_454 VPWR VGND sg13g2_fill_2
XFILLER_90_476 VPWR VGND sg13g2_fill_1
XFILLER_50_307 VPWR VGND sg13g2_fill_2
X_16545_ _16546_/B _16559_/C _16549_/B VPWR VGND sg13g2_nand2_1
XFILLER_44_882 VPWR VGND sg13g2_decap_8
XFILLER_62_178 VPWR VGND sg13g2_decap_8
X_13757_ _13757_/Y _13757_/A _13757_/B _13932_/C _14005_/A VPWR VGND sg13g2_nand4_1
XFILLER_91_1237 VPWR VGND sg13g2_decap_4
X_19264_ _19265_/C _19263_/A _14587_/Y _19263_/Y VPWR VGND sg13g2_a21oi_1
X_12708_ _12709_/B _24163_/Q _24195_/Q _23299_/Q _23331_/Q _13001_/S0 _12452_/A VPWR
+ VGND sg13g2_mux4_1
XFILLER_34_1611 VPWR VGND sg13g2_fill_1
X_16476_ _16476_/Y _22601_/Q _16495_/S VPWR VGND sg13g2_nand2_1
X_13688_ _13688_/X _23248_/Q _23280_/Q _23376_/Q _23408_/Q _13978_/S0 _13689_/S1 VPWR
+ VGND sg13g2_mux4_1
X_18215_ _18216_/C _18322_/C _18423_/B VPWR VGND sg13g2_nor2b_1
X_15427_ _15429_/A _22755_/Q _17234_/A _15391_/A VPWR VGND sg13g2_a21oi_1
Xoutput4504 data_wdata_o[10] _14698_/X VPWR VGND sg13g2_buf_1
XFILLER_73_1693 VPWR VGND sg13g2_fill_1
Xoutput4515 data_wdata_o[20] _14728_/X VPWR VGND sg13g2_buf_1
XFILLER_31_598 VPWR VGND sg13g2_decap_4
X_19195_ _19195_/Y _19197_/A _19195_/B _19200_/S VPWR VGND sg13g2_nor3_1
X_12639_ _12699_/C _12635_/Y _12638_/X _12639_/S VPWR VGND sg13g2_mux2_1
XFILLER_89_1100 VPWR VGND sg13g2_decap_4
Xoutput4526 data_wdata_o[30] _14738_/X VPWR VGND sg13g2_buf_1
Xoutput4537 instr_addr_o[11] _14922_/Y VPWR VGND sg13g2_buf_1
Xoutput4548 instr_addr_o[22] _15033_/X VPWR VGND sg13g2_buf_1
X_18146_ _18379_/B _18264_/A _18196_/A VPWR VGND sg13g2_nor2_1
XFILLER_106_1193 VPWR VGND sg13g2_decap_4
Xoutput4559 instr_addr_o[3] _14824_/X VPWR VGND sg13g2_buf_1
XFILLER_34_1699 VPWR VGND sg13g2_fill_1
X_15358_ _15365_/B _22753_/Q _15991_/A2 _15945_/B1 _22785_/Q VPWR VGND sg13g2_a22oi_1
XFILLER_69_1707 VPWR VGND sg13g2_decap_8
XFILLER_8_783 VPWR VGND sg13g2_decap_4
X_14309_ _15247_/A _19728_/A _14336_/C VPWR VGND sg13g2_nand2_1
XFILLER_12_1953 VPWR VGND sg13g2_fill_2
X_18077_ _18351_/B _18358_/S _18028_/Y _18030_/Y VPWR VGND sg13g2_a21o_1
X_15289_ _15289_/X _15289_/A _15289_/B _15346_/A VPWR VGND sg13g2_and3_1
XFILLER_85_1019 VPWR VGND sg13g2_decap_8
X_17028_ _17052_/C _22714_/Q _17028_/B VPWR VGND sg13g2_and2_1
XFILLER_113_876 VPWR VGND sg13g2_decap_8
XFILLER_100_504 VPWR VGND sg13g2_decap_8
XFILLER_98_576 VPWR VGND sg13g2_fill_1
XFILLER_98_587 VPWR VGND sg13g2_decap_4
XFILLER_58_418 VPWR VGND sg13g2_decap_4
XFILLER_105_28 VPWR VGND sg13g2_decap_8
XFILLER_39_610 VPWR VGND sg13g2_decap_8
XFILLER_86_749 VPWR VGND sg13g2_decap_4
X_18979_ _18980_/C _19045_/B _23055_/Q _19001_/C VPWR VGND sg13g2_or3_1
XFILLER_41_1604 VPWR VGND sg13g2_decap_4
XFILLER_67_930 VPWR VGND sg13g2_fill_2
XFILLER_61_1052 VPWR VGND sg13g2_decap_8
XFILLER_26_1183 VPWR VGND sg13g2_fill_2
X_21990_ _23989_/D _19526_/Y _22031_/S _21989_/Y VPWR VGND sg13g2_o21ai_1
XFILLER_39_654 VPWR VGND sg13g2_fill_1
XFILLER_27_805 VPWR VGND sg13g2_decap_8
XFILLER_66_462 VPWR VGND sg13g2_decap_8
XFILLER_67_985 VPWR VGND sg13g2_fill_2
XFILLER_96_1115 VPWR VGND sg13g2_fill_2
X_20941_ _23516_/D _21309_/A1 _20945_/B _20940_/Y VPWR VGND sg13g2_o21ai_1
XFILLER_82_922 VPWR VGND sg13g2_decap_8
XFILLER_113_1186 VPWR VGND sg13g2_fill_1
XFILLER_96_1126 VPWR VGND sg13g2_fill_2
X_20872_ _20872_/Y _23483_/Q _20879_/B VPWR VGND sg13g2_nand2_1
XFILLER_42_808 VPWR VGND sg13g2_decap_8
X_23660_ _23660_/Q clkload36/A _23660_/D fanout2710/X VPWR VGND sg13g2_dfrbpq_1
XFILLER_39_1511 VPWR VGND sg13g2_decap_4
XFILLER_42_819 VPWR VGND sg13g2_decap_8
X_22611_ _22611_/Q clkload10/A _22611_/D fanout2813/X VPWR VGND sg13g2_dfrbpq_1
X_23591_ _23591_/Q _24170_/CLK _23591_/D fanout2697/X VPWR VGND sg13g2_dfrbpq_1
XFILLER_22_532 VPWR VGND sg13g2_fill_2
XFILLER_35_1408 VPWR VGND sg13g2_fill_2
X_22542_ _22542_/Q clkload6/A _22542_/D fanout2832/X VPWR VGND sg13g2_dfrbpq_1
XFILLER_39_1588 VPWR VGND sg13g2_decap_8
XFILLER_33_1110 VPWR VGND sg13g2_fill_1
X_22473_ _22473_/Q _23029_/CLK _22473_/D fanout2806/X VPWR VGND sg13g2_dfrbpq_1
XFILLER_17_1864 VPWR VGND sg13g2_decap_8
XFILLER_52_1766 VPWR VGND sg13g2_decap_8
XFILLER_104_1845 VPWR VGND sg13g2_decap_8
X_24212_ _24212_/Q _24212_/CLK _24212_/D fanout2625/X VPWR VGND sg13g2_dfrbpq_1
X_21424_ _21486_/B _22119_/A _21557_/B VPWR VGND sg13g2_nand2_1
XFILLER_108_615 VPWR VGND sg13g2_decap_8
X_24143_ _24143_/Q _24205_/CLK _24143_/D fanout2651/X VPWR VGND sg13g2_dfrbpq_1
XFILLER_11_1430 VPWR VGND sg13g2_decap_8
X_21355_ _21557_/B _22050_/A _22050_/B _22050_/C VPWR VGND sg13g2_and3_1
XFILLER_107_147 VPWR VGND sg13g2_decap_8
XFILLER_30_68 VPWR VGND sg13g2_fill_2
X_20306_ _20309_/B _20335_/A _20306_/B VPWR VGND sg13g2_nor2_1
X_24074_ _24074_/Q clkload37/A _24074_/D fanout2708/X VPWR VGND sg13g2_dfrbpq_1
X_21286_ _23667_/D _22249_/A0 _23667_/Q _21286_/S VPWR VGND sg13g2_mux2_1
XFILLER_104_821 VPWR VGND sg13g2_fill_2
Xfanout2907 fanout2907/X fanout2908/X VPWR VGND sg13g2_buf_1
XFILLER_89_532 VPWR VGND sg13g2_decap_8
X_23025_ _23025_/Q clkload11/A _23025_/D fanout2836/X VPWR VGND sg13g2_dfrbpq_1
Xfanout2918 fanout2918/X fanout2923/X VPWR VGND sg13g2_buf_1
Xfanout2929 wire1182/A fanout2934/X VPWR VGND sg13g2_buf_1
X_20237_ _20237_/Y _20362_/A1 _20226_/Y _20236_/Y _20201_/B VPWR VGND sg13g2_a22oi_1
XFILLER_85_1586 VPWR VGND sg13g2_decap_8
XFILLER_81_1428 VPWR VGND sg13g2_decap_8
XFILLER_1_469 VPWR VGND sg13g2_decap_8
XFILLER_39_55 VPWR VGND sg13g2_decap_8
X_20168_ _20168_/Y _20168_/A _20168_/B _20168_/C VPWR VGND sg13g2_nand3_1
XFILLER_58_930 VPWR VGND sg13g2_decap_8
XFILLER_115_1952 VPWR VGND sg13g2_fill_2
XFILLER_4_1907 VPWR VGND sg13g2_decap_8
XFILLER_98_1903 VPWR VGND sg13g2_decap_8
XFILLER_92_708 VPWR VGND sg13g2_decap_8
XFILLER_92_719 VPWR VGND sg13g2_fill_2
X_20099_ _20099_/Y _20099_/A VPWR VGND sg13g2_inv_1
X_12990_ _14649_/A _12990_/A VPWR VGND sg13g2_inv_2
XFILLER_40_1125 VPWR VGND sg13g2_decap_8
XFILLER_40_1136 VPWR VGND sg13g2_fill_2
XFILLER_45_602 VPWR VGND sg13g2_decap_8
X_23927_ _23927_/Q clkload52/A _23927_/D fanout2689/X VPWR VGND sg13g2_dfrbpq_1
XFILLER_84_270 VPWR VGND sg13g2_decap_8
XFILLER_59_1909 VPWR VGND sg13g2_decap_8
XFILLER_72_410 VPWR VGND sg13g2_fill_1
XFILLER_22_1570 VPWR VGND sg13g2_fill_1
XFILLER_45_635 VPWR VGND sg13g2_decap_4
XFILLER_2_1642 VPWR VGND sg13g2_fill_2
XFILLER_73_955 VPWR VGND sg13g2_decap_8
X_14660_ _14660_/X _14660_/A _14718_/B VPWR VGND sg13g2_and2_1
X_11872_ _19437_/A _11983_/B _11983_/C VPWR VGND sg13g2_nor2_1
X_23858_ _23858_/Q clkload29/A _23858_/D fanout2669/X VPWR VGND sg13g2_dfrbpq_1
XFILLER_55_98 VPWR VGND sg13g2_fill_2
X_13611_ _13611_/X _13611_/A _13611_/B VPWR VGND sg13g2_or2_1
X_22809_ _22809_/Q clkload10/A _22809_/D fanout2812/X VPWR VGND sg13g2_dfrbpq_1
XFILLER_38_1021 VPWR VGND sg13g2_decap_8
X_14591_ _14591_/Y _14591_/A _14591_/B VPWR VGND sg13g2_nand2_1
X_23789_ _23789_/Q clkload30/A _23789_/D fanout2657/X VPWR VGND sg13g2_dfrbpq_1
XFILLER_53_690 VPWR VGND sg13g2_decap_4
X_16330_ _16332_/A _16331_/B _16331_/C _16330_/B1 VPWR VGND sg13g2_a21oi_1
XFILLER_41_841 VPWR VGND sg13g2_fill_2
XFILLER_53_1519 VPWR VGND sg13g2_fill_1
XFILLER_57_1688 VPWR VGND sg13g2_fill_1
Xclkbuf_4_7__f_clk_i clkload1/A clkbuf_3_3_0_clk_i/X VPWR VGND sg13g2_buf_8
XFILLER_105_1609 VPWR VGND sg13g2_decap_4
XFILLER_16_1330 VPWR VGND sg13g2_fill_2
XFILLER_9_525 VPWR VGND sg13g2_fill_2
X_16261_ _22523_/D _16265_/A _16261_/B VPWR VGND sg13g2_xor2_1
XFILLER_40_384 VPWR VGND sg13g2_decap_8
XFILLER_71_97 VPWR VGND sg13g2_decap_4
X_18000_ _18451_/B _18560_/S _17980_/X _17983_/Y VPWR VGND sg13g2_a21oi_1
XFILLER_103_1322 VPWR VGND sg13g2_fill_2
X_15212_ _15212_/X _22841_/Q _17439_/A VPWR VGND sg13g2_and2_1
X_12424_ _12424_/X _12429_/A _14387_/B VPWR VGND sg13g2_and2_1
XFILLER_12_1216 VPWR VGND sg13g2_fill_1
X_16192_ _16192_/Y _17920_/B2 _16161_/X _16191_/X VPWR VGND sg13g2_a21oi_1
XFILLER_16_1396 VPWR VGND sg13g2_decap_8
XFILLER_12_1249 VPWR VGND sg13g2_decap_4
X_12355_ _24254_/A _12355_/A _12355_/B VPWR VGND sg13g2_and2_1
XFILLER_4_230 VPWR VGND sg13g2_fill_1
X_11306_ _11626_/B _22969_/Q _11311_/A VPWR VGND sg13g2_nor2b_1
XFILLER_99_329 VPWR VGND sg13g2_decap_8
X_15074_ _15074_/Y _16318_/A _15073_/A _15073_/Y VPWR VGND sg13g2_o21ai_1
X_19951_ _23230_/D _19950_/B _22409_/A1 _19950_/Y VPWR VGND sg13g2_o21ai_1
XFILLER_29_1735 VPWR VGND sg13g2_fill_1
X_14025_ _14025_/Y _14023_/Y _14024_/X _14026_/A VPWR VGND sg13g2_o21ai_1
X_18902_ _18903_/C _18926_/A _23048_/Q _18924_/C VPWR VGND sg13g2_or3_1
X_11237_ _11237_/Y _11681_/A _12550_/A VPWR VGND sg13g2_nor2b_1
XFILLER_9_1829 VPWR VGND sg13g2_decap_8
X_19882_ _19882_/Y _19850_/A _23204_/Q _20344_/A1 VPWR VGND sg13g2_a21oi_1
XFILLER_68_705 VPWR VGND sg13g2_decap_8
XFILLER_29_1779 VPWR VGND sg13g2_fill_1
XFILLER_68_716 VPWR VGND sg13g2_fill_2
X_18833_ _18838_/A _23040_/Q _18865_/B _18865_/C VPWR VGND sg13g2_nand3_1
XFILLER_42_1913 VPWR VGND sg13g2_decap_4
XFILLER_7_1531 VPWR VGND sg13g2_fill_2
XFILLER_110_857 VPWR VGND sg13g2_decap_8
XFILLER_95_557 VPWR VGND sg13g2_decap_8
X_18764_ _18776_/A _23030_/Q _18821_/B _18821_/C VPWR VGND sg13g2_nand3_1
XFILLER_27_1492 VPWR VGND sg13g2_fill_1
X_15976_ _15977_/C _15976_/A _15976_/B _15976_/C _15976_/D VPWR VGND sg13g2_nand4_1
XFILLER_49_963 VPWR VGND sg13g2_fill_2
X_17715_ _17732_/C _22564_/Q _22563_/Q _17715_/C VPWR VGND sg13g2_and3_1
XFILLER_48_462 VPWR VGND sg13g2_fill_1
XFILLER_64_911 VPWR VGND sg13g2_decap_8
XFILLER_97_1424 VPWR VGND sg13g2_fill_2
X_18695_ _23017_/D _18692_/B _18694_/Y _15000_/Y VPWR VGND sg13g2_a21oi_1
XFILLER_35_101 VPWR VGND sg13g2_decap_4
X_17646_ _20437_/B _22050_/B VPWR VGND sg13g2_inv_1
XFILLER_64_966 VPWR VGND sg13g2_decap_8
X_14858_ _14858_/Y _24250_/A _14879_/A _14857_/Y VPWR VGND sg13g2_a21oi_2
XFILLER_90_251 VPWR VGND sg13g2_decap_8
XFILLER_79_1891 VPWR VGND sg13g2_fill_1
X_13809_ _13810_/A _13861_/A _13854_/B VPWR VGND sg13g2_xnor2_1
XFILLER_35_189 VPWR VGND sg13g2_fill_1
X_17577_ _17578_/C _22551_/Q _17567_/A VPWR VGND sg13g2_nor2b_1
X_14789_ _14848_/B _14885_/B _14789_/B VPWR VGND sg13g2_nor2_1
XFILLER_75_1755 VPWR VGND sg13g2_decap_4
XFILLER_90_295 VPWR VGND sg13g2_decap_4
X_19316_ _20283_/S _22430_/A _22186_/A VPWR VGND sg13g2_nand2b_1
X_16528_ _16530_/A _22620_/Q _16559_/C VPWR VGND sg13g2_xor2_1
XFILLER_32_852 VPWR VGND sg13g2_decap_8
XFILLER_50_159 VPWR VGND sg13g2_decap_8
XFILLER_75_1788 VPWR VGND sg13g2_fill_2
XFILLER_31_340 VPWR VGND sg13g2_fill_1
XFILLER_17_1138 VPWR VGND sg13g2_decap_8
XFILLER_31_351 VPWR VGND sg13g2_decap_4
XFILLER_32_885 VPWR VGND sg13g2_decap_8
X_19247_ _19247_/Y _19257_/B _19245_/Y _19263_/A VPWR VGND sg13g2_o21ai_1
XFILLER_32_896 VPWR VGND sg13g2_fill_1
X_16459_ _22593_/D _16067_/A _16472_/B _16458_/Y VPWR VGND sg13g2_o21ai_1
XFILLER_73_1490 VPWR VGND sg13g2_fill_2
XFILLER_77_0 VPWR VGND sg13g2_decap_8
X_19178_ _23148_/D _23148_/Q _15053_/X _19185_/S VPWR VGND sg13g2_mux2_1
X_18129_ _18129_/Y _18129_/A _18471_/S VPWR VGND sg13g2_nand2_1
XFILLER_69_1526 VPWR VGND sg13g2_fill_1
XFILLER_69_1537 VPWR VGND sg13g2_decap_8
XFILLER_105_607 VPWR VGND sg13g2_decap_8
XFILLER_86_1840 VPWR VGND sg13g2_fill_1
X_21140_ _21140_/Y _23595_/Q _21154_/B VPWR VGND sg13g2_nand2_1
XFILLER_47_1802 VPWR VGND sg13g2_decap_4
XFILLER_82_1726 VPWR VGND sg13g2_decap_4
X_21071_ _21071_/Y _21071_/A _21071_/B VPWR VGND sg13g2_nand2_1
XFILLER_99_874 VPWR VGND sg13g2_decap_4
XFILLER_82_1748 VPWR VGND sg13g2_fill_2
XFILLER_59_705 VPWR VGND sg13g2_decap_8
XFILLER_67_1294 VPWR VGND sg13g2_fill_2
XFILLER_82_1759 VPWR VGND sg13g2_decap_8
X_20022_ _20022_/Y _20266_/B2 _20016_/Y _20021_/Y VPWR VGND sg13g2_a21oi_1
XFILLER_47_1879 VPWR VGND sg13g2_decap_8
XFILLER_113_673 VPWR VGND sg13g2_decap_8
XFILLER_8_1339 VPWR VGND sg13g2_fill_1
XFILLER_112_161 VPWR VGND sg13g2_decap_8
XFILLER_115_1248 VPWR VGND sg13g2_decap_8
XFILLER_45_1581 VPWR VGND sg13g2_decap_4
XFILLER_6_1041 VPWR VGND sg13g2_decap_8
XFILLER_100_389 VPWR VGND sg13g2_decap_4
XFILLER_39_484 VPWR VGND sg13g2_decap_4
XFILLER_54_410 VPWR VGND sg13g2_fill_2
X_21973_ _21973_/Y _21973_/A _21976_/B VPWR VGND sg13g2_nand2_1
XFILLER_27_657 VPWR VGND sg13g2_decap_4
X_23712_ _23712_/Q _24190_/CLK _23712_/D fanout2773/X VPWR VGND sg13g2_dfrbpq_1
XFILLER_70_914 VPWR VGND sg13g2_decap_8
XFILLER_82_785 VPWR VGND sg13g2_decap_4
XFILLER_82_796 VPWR VGND sg13g2_fill_2
XFILLER_25_35 VPWR VGND sg13g2_decap_8
X_23643_ _23643_/Q clkload59/A _23643_/D fanout2789/X VPWR VGND sg13g2_dfrbpq_1
X_20855_ _20919_/B _22186_/A _20921_/B VPWR VGND sg13g2_nand2_1
XFILLER_93_1844 VPWR VGND sg13g2_decap_8
XFILLER_41_115 VPWR VGND sg13g2_decap_8
XFILLER_19_1926 VPWR VGND sg13g2_decap_8
XFILLER_54_1828 VPWR VGND sg13g2_decap_8
X_23574_ _23574_/Q clkload54/A _23574_/D fanout2764/X VPWR VGND sg13g2_dfrbpq_1
X_20786_ _20847_/B _22119_/A _20921_/B VPWR VGND sg13g2_nand2_1
XFILLER_50_660 VPWR VGND sg13g2_decap_8
XFILLER_23_885 VPWR VGND sg13g2_decap_8
XFILLER_74_1287 VPWR VGND sg13g2_decap_8
X_22525_ _22525_/Q clkload6/A _22525_/D fanout2834/X VPWR VGND sg13g2_dfrbpq_1
XFILLER_22_384 VPWR VGND sg13g2_fill_1
XFILLER_13_1503 VPWR VGND sg13g2_decap_8
XFILLER_109_924 VPWR VGND sg13g2_decap_8
XFILLER_104_1653 VPWR VGND sg13g2_decap_8
X_22456_ _22456_/Q clkload28/A _22456_/D fanout2855/X VPWR VGND sg13g2_dfrbpq_1
XFILLER_52_1596 VPWR VGND sg13g2_fill_1
XFILLER_87_1615 VPWR VGND sg13g2_decap_8
XFILLER_109_968 VPWR VGND sg13g2_fill_1
XFILLER_100_1517 VPWR VGND sg13g2_fill_2
X_21407_ _23722_/D _21606_/A1 _21406_/B _21406_/Y VPWR VGND sg13g2_o21ai_1
XFILLER_108_445 VPWR VGND sg13g2_decap_8
XFILLER_68_1014 VPWR VGND sg13g2_fill_1
X_12140_ _12141_/B _23708_/Q _23836_/Q _12146_/S VPWR VGND sg13g2_mux2_1
XFILLER_68_1036 VPWR VGND sg13g2_decap_4
X_21338_ _23690_/D _21606_/A1 _21337_/B _21337_/Y VPWR VGND sg13g2_o21ai_1
X_24126_ _24126_/Q clkload44/A _24126_/D fanout2747/X VPWR VGND sg13g2_dfrbpq_1
Xfanout2704 fanout2704/X fanout2705/X VPWR VGND sg13g2_buf_1
Xfanout2715 fanout2715/X fanout2717/X VPWR VGND sg13g2_buf_1
X_21269_ _23656_/D _21335_/A0 _23656_/Q _21286_/S VPWR VGND sg13g2_mux2_1
X_24057_ _24057_/Q clkload46/A _24057_/D fanout2755/X VPWR VGND sg13g2_dfrbpq_1
Xfanout2726 fanout2726/X fanout2727/X VPWR VGND sg13g2_buf_1
XFILLER_65_1946 VPWR VGND sg13g2_decap_8
XFILLER_46_1334 VPWR VGND sg13g2_decap_8
Xfanout2737 fanout2737/X fanout2742/X VPWR VGND sg13g2_buf_1
Xfanout2748 fanout2748/X fanout2768/X VPWR VGND sg13g2_buf_1
Xfanout2759 fanout2759/X fanout2760/X VPWR VGND sg13g2_buf_1
XFILLER_104_673 VPWR VGND sg13g2_fill_1
X_23008_ _23008_/Q clkload26/A _23008_/D fanout2850/X VPWR VGND sg13g2_dfrbpq_1
XFILLER_2_28 VPWR VGND sg13g2_decap_8
X_15830_ _15837_/A _22933_/Q _15897_/A2 _15829_/Y VPWR VGND sg13g2_a21oi_1
XFILLER_24_1632 VPWR VGND sg13g2_fill_2
XFILLER_4_1704 VPWR VGND sg13g2_decap_8
XFILLER_92_505 VPWR VGND sg13g2_fill_1
XFILLER_8_1895 VPWR VGND sg13g2_decap_8
XFILLER_66_64 VPWR VGND sg13g2_decap_8
XFILLER_79_1110 VPWR VGND sg13g2_fill_1
X_15761_ _15773_/A _22471_/Q _15970_/A2 _15991_/A2 _22770_/Q VPWR VGND sg13g2_a22oi_1
X_12973_ _12973_/X _23558_/Q _24006_/Q _12974_/A VPWR VGND sg13g2_mux2_1
X_17500_ _17500_/Y _17500_/A _17502_/S VPWR VGND sg13g2_nand2_1
XFILLER_73_741 VPWR VGND sg13g2_decap_4
XFILLER_18_657 VPWR VGND sg13g2_decap_8
X_14712_ _14712_/X _14709_/X _14711_/Y _14739_/S VPWR VGND sg13g2_mux2_1
X_11924_ _11924_/X _23706_/Q _23738_/Q _23770_/Q _23802_/Q _11924_/S0 _12171_/S1 VPWR
+ VGND sg13g2_mux4_1
XFILLER_45_443 VPWR VGND sg13g2_fill_2
XFILLER_79_1187 VPWR VGND sg13g2_decap_8
X_17431_ _22835_/D _16203_/A _17432_/S _17430_/Y VPWR VGND sg13g2_o21ai_1
X_14643_ _14643_/Y _14686_/A _14642_/B _14642_/Y VPWR VGND sg13g2_a21oi_1
X_11855_ _11855_/X _23929_/Q _23961_/Q _11855_/S VPWR VGND sg13g2_mux2_1
XFILLER_60_435 VPWR VGND sg13g2_decap_8
X_17362_ _17362_/Y _17362_/A _17367_/B VPWR VGND sg13g2_nand2_1
XFILLER_18_1436 VPWR VGND sg13g2_decap_8
X_14574_ _14575_/C _24276_/A _14574_/B VPWR VGND sg13g2_nand2_1
XFILLER_72_1939 VPWR VGND sg13g2_decap_8
X_11786_ _11787_/B _24153_/Q _23289_/Q _11792_/S VPWR VGND sg13g2_mux2_1
XFILLER_9_300 VPWR VGND sg13g2_decap_8
X_19101_ _23086_/D _23086_/Q _19100_/X _19115_/S VPWR VGND sg13g2_mux2_1
XFILLER_9_311 VPWR VGND sg13g2_fill_2
X_16313_ _16314_/B _16323_/B VPWR VGND sg13g2_inv_1
XFILLER_41_682 VPWR VGND sg13g2_fill_1
X_13525_ _13950_/A _13526_/D _13525_/B VPWR VGND sg13g2_nor2_1
X_17293_ _17293_/Y _17293_/A _17293_/B VPWR VGND sg13g2_nand2_1
Xplace3609 _18651_/B _18602_/A VPWR VGND sg13g2_buf_1
X_19032_ _19032_/Y _19043_/A _19032_/B VPWR VGND sg13g2_nand2_1
X_16244_ _16244_/Y _22518_/Q _16244_/B VPWR VGND sg13g2_nand2_1
X_13456_ _13457_/B _23309_/Q _23341_/Q _23373_/Q _23405_/Q _13133_/A _13635_/S1 VPWR
+ VGND sg13g2_mux4_1
XFILLER_35_1794 VPWR VGND sg13g2_decap_8
XFILLER_70_7 VPWR VGND sg13g2_decap_8
XFILLER_51_1062 VPWR VGND sg13g2_decap_4
XFILLER_103_1152 VPWR VGND sg13g2_decap_4
X_12407_ _12412_/C _12403_/Y _12406_/Y _11355_/Y VPWR VGND sg13g2_a21oi_1
XFILLER_86_1103 VPWR VGND sg13g2_decap_8
X_16175_ _16175_/Y _16175_/A _16187_/B VPWR VGND sg13g2_nor2_1
XFILLER_31_1669 VPWR VGND sg13g2_decap_4
XFILLER_51_1095 VPWR VGND sg13g2_fill_2
X_13387_ _13387_/X _13552_/A _13387_/B VPWR VGND sg13g2_or2_1
X_15126_ _24231_/D _18567_/B _15126_/B VPWR VGND sg13g2_nor2_1
X_12338_ _14340_/A _14341_/B _14296_/A2 _12151_/Y VPWR VGND sg13g2_a21o_1
XFILLER_115_949 VPWR VGND sg13g2_decap_8
XFILLER_99_115 VPWR VGND sg13g2_decap_8
XFILLER_5_572 VPWR VGND sg13g2_fill_2
XFILLER_114_459 VPWR VGND sg13g2_decap_8
X_19934_ _19934_/Y _20030_/S _19934_/B VPWR VGND sg13g2_nor2_1
X_15057_ _15057_/Y _15057_/A _15057_/B VPWR VGND sg13g2_nand2_1
X_12269_ _15491_/A _19861_/A VPWR VGND sg13g2_inv_2
XFILLER_96_811 VPWR VGND sg13g2_decap_8
X_14008_ _14008_/X _14008_/A _14008_/B _14008_/C _14008_/D VPWR VGND sg13g2_and4_1
X_19865_ _19865_/Y _19399_/A _19824_/A _19541_/A VPWR VGND sg13g2_a21oi_1
XFILLER_95_310 VPWR VGND sg13g2_decap_8
XFILLER_9_1659 VPWR VGND sg13g2_decap_8
XFILLER_68_524 VPWR VGND sg13g2_decap_8
XFILLER_64_1478 VPWR VGND sg13g2_fill_2
XFILLER_68_535 VPWR VGND sg13g2_fill_2
X_18816_ _18816_/Y _18866_/A _18816_/B VPWR VGND sg13g2_nand2_1
XFILLER_23_1120 VPWR VGND sg13g2_fill_2
X_19796_ _19797_/B _19661_/Y _19795_/Y _19987_/A VPWR VGND sg13g2_mux2_1
XFILLER_110_676 VPWR VGND sg13g2_decap_8
XFILLER_7_1383 VPWR VGND sg13g2_fill_2
XFILLER_62_1191 VPWR VGND sg13g2_fill_1
X_15959_ _22479_/D _16025_/A _15954_/Y _15958_/Y VPWR VGND sg13g2_a21oi_1
XFILLER_23_1164 VPWR VGND sg13g2_decap_8
X_18747_ _18747_/Y _16417_/B _18753_/B _18602_/A VPWR VGND sg13g2_o21ai_1
XFILLER_97_1221 VPWR VGND sg13g2_fill_1
XFILLER_114_1292 VPWR VGND sg13g2_decap_4
X_18678_ _18678_/X _23014_/Q _18678_/B VPWR VGND sg13g2_xor2_1
XFILLER_63_284 VPWR VGND sg13g2_decap_4
X_17629_ _17629_/Y _17858_/A _17629_/B VPWR VGND sg13g2_nor2_1
XFILLER_75_1530 VPWR VGND sg13g2_fill_2
XFILLER_75_1541 VPWR VGND sg13g2_decap_8
XFILLER_17_690 VPWR VGND sg13g2_decap_8
XFILLER_23_137 VPWR VGND sg13g2_decap_8
X_20640_ _23375_/D _22177_/A1 _23375_/Q _20640_/S VPWR VGND sg13g2_mux2_1
XFILLER_51_457 VPWR VGND sg13g2_fill_1
XFILLER_71_1427 VPWR VGND sg13g2_decap_8
X_20571_ _23341_/D _23341_/Q _20251_/Y _20580_/S VPWR VGND sg13g2_mux2_1
XFILLER_31_170 VPWR VGND sg13g2_decap_8
XFILLER_14_1823 VPWR VGND sg13g2_decap_8
XFILLER_105_1940 VPWR VGND sg13g2_decap_8
XFILLER_20_866 VPWR VGND sg13g2_decap_8
X_22310_ _22310_/Y _22310_/A _22310_/B VPWR VGND sg13g2_nand2_1
X_23290_ _23290_/Q clkload44/A _23290_/D fanout2750/X VPWR VGND sg13g2_dfrbpq_1
XFILLER_101_1815 VPWR VGND sg13g2_fill_2
X_22241_ _22241_/Y _22241_/A _22241_/B VPWR VGND sg13g2_nand2_1
XFILLER_69_1323 VPWR VGND sg13g2_fill_2
XFILLER_101_1859 VPWR VGND sg13g2_decap_8
XFILLER_3_509 VPWR VGND sg13g2_decap_4
XFILLER_106_927 VPWR VGND sg13g2_fill_2
XFILLER_30_1179 VPWR VGND sg13g2_decap_8
Xhold4801 _21995_/A _23992_/Q VPWR VGND sg13g2_dlygate4sd3_1
X_22172_ _22172_/Y _24076_/Q _22172_/B VPWR VGND sg13g2_nand2_1
Xhold4812 _21169_/A _23609_/Q VPWR VGND sg13g2_dlygate4sd3_1
Xhold4823 _20792_/A _23446_/Q VPWR VGND sg13g2_dlygate4sd3_1
Xhold4834 _21629_/A _23829_/Q VPWR VGND sg13g2_dlygate4sd3_1
XFILLER_47_1621 VPWR VGND sg13g2_decap_8
XFILLER_47_1632 VPWR VGND sg13g2_fill_1
Xhold4845 _21764_/A _23883_/Q VPWR VGND sg13g2_dlygate4sd3_1
Xhold4856 _22140_/A _24061_/Q VPWR VGND sg13g2_dlygate4sd3_1
XFILLER_47_1643 VPWR VGND sg13g2_decap_8
Xhold4867 _22283_/A _24129_/Q VPWR VGND sg13g2_dlygate4sd3_1
Xhold4878 _21833_/A _23914_/Q VPWR VGND sg13g2_dlygate4sd3_1
Xhold4889 _20905_/A _23499_/Q VPWR VGND sg13g2_dlygate4sd3_1
X_21054_ _21054_/Y _21054_/A _21071_/B VPWR VGND sg13g2_nand2_1
XFILLER_59_513 VPWR VGND sg13g2_decap_8
XFILLER_113_470 VPWR VGND sg13g2_decap_8
XFILLER_101_621 VPWR VGND sg13g2_decap_8
XFILLER_115_1023 VPWR VGND sg13g2_decap_8
XFILLER_82_1578 VPWR VGND sg13g2_decap_8
XFILLER_28_1075 VPWR VGND sg13g2_decap_8
X_20005_ _20005_/Y _20005_/A _20005_/B VPWR VGND sg13g2_nor2_1
XFILLER_86_332 VPWR VGND sg13g2_fill_1
XFILLER_100_131 VPWR VGND sg13g2_decap_8
XFILLER_87_888 VPWR VGND sg13g2_decap_4
XFILLER_60_1854 VPWR VGND sg13g2_fill_1
XFILLER_80_1291 VPWR VGND sg13g2_decap_8
XFILLER_46_218 VPWR VGND sg13g2_decap_8
XFILLER_100_175 VPWR VGND sg13g2_decap_8
XFILLER_46_229 VPWR VGND sg13g2_fill_1
XFILLER_39_292 VPWR VGND sg13g2_decap_8
XFILLER_55_741 VPWR VGND sg13g2_decap_8
XFILLER_55_752 VPWR VGND sg13g2_fill_2
XFILLER_55_763 VPWR VGND sg13g2_decap_4
XFILLER_95_1939 VPWR VGND sg13g2_decap_8
XFILLER_36_56 VPWR VGND sg13g2_decap_8
X_21956_ _23972_/D _21956_/A1 _21961_/B _21955_/Y VPWR VGND sg13g2_o21ai_1
XFILLER_82_571 VPWR VGND sg13g2_decap_4
XFILLER_3_1792 VPWR VGND sg13g2_decap_8
X_20907_ _20907_/Y _23500_/Q _20913_/B VPWR VGND sg13g2_nand2_1
XFILLER_19_1712 VPWR VGND sg13g2_fill_1
X_21887_ _21887_/Y _21887_/A _21893_/B VPWR VGND sg13g2_nand2_1
XFILLER_43_969 VPWR VGND sg13g2_decap_4
XFILLER_42_468 VPWR VGND sg13g2_fill_2
X_23626_ _23626_/Q clkload37/A _23626_/D fanout2729/X VPWR VGND sg13g2_dfrbpq_1
XFILLER_54_1614 VPWR VGND sg13g2_decap_8
XFILLER_19_1745 VPWR VGND sg13g2_fill_1
X_20838_ _23466_/D _20972_/A1 _20841_/B _20837_/Y VPWR VGND sg13g2_o21ai_1
XFILLER_74_1062 VPWR VGND sg13g2_fill_1
XFILLER_74_1073 VPWR VGND sg13g2_decap_8
XFILLER_11_822 VPWR VGND sg13g2_fill_1
XFILLER_35_1035 VPWR VGND sg13g2_fill_1
X_23557_ _23557_/Q clkload37/A _23557_/D fanout2713/X VPWR VGND sg13g2_dfrbpq_1
X_11571_ _14102_/C _11634_/A _11571_/B VPWR VGND sg13g2_nand2_1
X_20769_ _23434_/D _20972_/A1 _20768_/B _20768_/Y VPWR VGND sg13g2_o21ai_1
X_13310_ _13311_/A _23563_/Q _13975_/A2 _13309_/X _13978_/S1 VPWR VGND sg13g2_a22oi_1
X_22508_ _22508_/Q _22941_/CLK _22508_/D fanout2802/X VPWR VGND sg13g2_dfrbpq_1
XFILLER_13_1322 VPWR VGND sg13g2_decap_4
X_14290_ _14336_/C _14399_/B _14290_/B _14290_/C VPWR VGND sg13g2_and3_1
X_23488_ _23488_/Q clkload40/A _23488_/D fanout2736/X VPWR VGND sg13g2_dfrbpq_1
XFILLER_104_1461 VPWR VGND sg13g2_decap_8
XFILLER_6_336 VPWR VGND sg13g2_decap_4
X_13241_ _13241_/X _13239_/X _13240_/X _13681_/S VPWR VGND sg13g2_mux2_1
X_22439_ _24204_/D _20237_/Y _22444_/B _22438_/Y VPWR VGND sg13g2_o21ai_1
XFILLER_109_776 VPWR VGND sg13g2_decap_8
XFILLER_48_1407 VPWR VGND sg13g2_fill_1
X_13172_ _13172_/X _13170_/X _13171_/X _13770_/A VPWR VGND sg13g2_mux2_1
XFILLER_112_908 VPWR VGND sg13g2_decap_8
X_12123_ _12123_/Y _12123_/A _23548_/Q VPWR VGND sg13g2_nand2_1
XFILLER_7_0 VPWR VGND sg13g2_decap_8
X_24109_ _24109_/Q _24205_/CLK _24109_/D fanout2649/X VPWR VGND sg13g2_dfrbpq_1
X_17980_ _17980_/X _19039_/A _23061_/Q _17992_/S VPWR VGND sg13g2_mux2_1
XFILLER_96_118 VPWR VGND sg13g2_decap_8
X_16931_ _16931_/Y _17119_/A _17044_/D VPWR VGND sg13g2_nand2_1
XFILLER_78_822 VPWR VGND sg13g2_decap_4
XFILLER_46_1142 VPWR VGND sg13g2_fill_1
XFILLER_104_470 VPWR VGND sg13g2_fill_1
XFILLER_77_310 VPWR VGND sg13g2_decap_8
XFILLER_89_181 VPWR VGND sg13g2_decap_8
XFILLER_46_1175 VPWR VGND sg13g2_fill_2
XFILLER_77_332 VPWR VGND sg13g2_fill_1
X_19650_ _19650_/Y _19696_/B _19650_/B VPWR VGND sg13g2_nor2_1
XFILLER_92_302 VPWR VGND sg13g2_decap_4
X_18601_ _22999_/D _14825_/A _18596_/X _18600_/Y VPWR VGND sg13g2_o21ai_1
X_15813_ _15813_/Y _15947_/A1 _15812_/Y _15947_/B1 VPWR VGND sg13g2_o21ai_1
XFILLER_111_1410 VPWR VGND sg13g2_fill_2
X_19581_ _19581_/Y _19708_/S _19694_/B _19580_/Y VPWR VGND sg13g2_a21oi_1
XFILLER_93_869 VPWR VGND sg13g2_fill_1
XFILLER_24_1495 VPWR VGND sg13g2_decap_4
X_18532_ _18533_/B _18366_/A _18334_/A _18527_/X _18301_/B VPWR VGND sg13g2_a22oi_1
X_15744_ _15745_/D _22606_/Q _15873_/B VPWR VGND sg13g2_nand2_1
XFILLER_34_903 VPWR VGND sg13g2_decap_4
XFILLER_46_763 VPWR VGND sg13g2_decap_8
X_12956_ _12956_/Y _12623_/X _12947_/Y _12955_/X VPWR VGND sg13g2_o21ai_1
XFILLER_61_700 VPWR VGND sg13g2_decap_8
XFILLER_111_1498 VPWR VGND sg13g2_fill_1
XFILLER_18_487 VPWR VGND sg13g2_decap_8
X_11907_ _11907_/Y _12239_/S _23642_/Q _11906_/Y VPWR VGND sg13g2_o21ai_1
X_18463_ _18465_/C _18039_/X _18822_/B _18463_/S VPWR VGND sg13g2_mux2_1
X_15675_ _22466_/D _16121_/A _15674_/X _15695_/S VPWR VGND sg13g2_mux2_1
X_12887_ _12897_/C _12881_/Y _12886_/Y _12558_/A VPWR VGND sg13g2_a21oi_1
XFILLER_76_1850 VPWR VGND sg13g2_decap_8
X_17414_ _17414_/Y _22826_/Q _17419_/B VPWR VGND sg13g2_nand2_1
X_14626_ _14626_/Y _14631_/B _14615_/Y _14625_/Y VPWR VGND sg13g2_o21ai_1
X_11838_ _11838_/Y _11384_/Y _11837_/Y _12288_/B VPWR VGND sg13g2_a21oi_1
XFILLER_33_479 VPWR VGND sg13g2_decap_8
XFILLER_42_991 VPWR VGND sg13g2_decap_4
Xplace4107 _13846_/A _22993_/Q VPWR VGND sg13g2_buf_1
Xplace4118 _13141_/B _12674_/C VPWR VGND sg13g2_buf_2
X_11769_ _11770_/B _11767_/X _11768_/X _12406_/A VPWR VGND sg13g2_mux2_1
XFILLER_13_170 VPWR VGND sg13g2_fill_1
Xplace4129 _12498_/S _12502_/S VPWR VGND sg13g2_buf_1
Xplace3406 _17369_/B _17371_/S VPWR VGND sg13g2_buf_1
XFILLER_31_1400 VPWR VGND sg13g2_decap_4
X_13508_ _13509_/D _14060_/A _13436_/Y _13740_/B1 _13440_/Y _13519_/B VPWR VGND sg13g2_a221oi_1
Xplace3417 _17293_/B _17298_/B VPWR VGND sg13g2_buf_1
X_14488_ _14491_/B _22612_/Q _23023_/Q VPWR VGND sg13g2_xor2_1
XFILLER_70_1471 VPWR VGND sg13g2_fill_2
Xplace3428 _16431_/B _16425_/B VPWR VGND sg13g2_buf_1
XFILLER_9_174 VPWR VGND sg13g2_decap_4
Xplace3439 _17920_/B1 _17929_/B1 VPWR VGND sg13g2_buf_1
X_19015_ _19015_/Y _23058_/Q _19008_/A _19048_/B1 VPWR VGND sg13g2_o21ai_1
X_16158_ _16158_/Y _16158_/A _16199_/B VPWR VGND sg13g2_nand2_1
XFILLER_115_768 VPWR VGND sg13g2_decap_8
XFILLER_114_245 VPWR VGND sg13g2_decap_8
XFILLER_9_1401 VPWR VGND sg13g2_decap_8
XFILLER_102_407 VPWR VGND sg13g2_decap_8
XFILLER_87_107 VPWR VGND sg13g2_decap_8
XFILLER_83_1865 VPWR VGND sg13g2_decap_8
XFILLER_9_1434 VPWR VGND sg13g2_decap_8
X_19917_ _19918_/A _20249_/A1 _23205_/Q _23213_/Q _20249_/A2 _19501_/A _20154_/S1
+ VPWR VGND sg13g2_mux4_1
XFILLER_68_321 VPWR VGND sg13g2_fill_2
XFILLER_69_844 VPWR VGND sg13g2_fill_1
XFILLER_69_855 VPWR VGND sg13g2_decap_8
XFILLER_96_641 VPWR VGND sg13g2_fill_1
XFILLER_96_652 VPWR VGND sg13g2_fill_1
X_19848_ _19848_/Y _19996_/B2 _19846_/Y _19847_/Y VPWR VGND sg13g2_a21oi_1
XFILLER_69_877 VPWR VGND sg13g2_fill_1
XFILLER_96_696 VPWR VGND sg13g2_fill_1
XFILLER_83_313 VPWR VGND sg13g2_decap_8
XFILLER_113_28 VPWR VGND sg13g2_decap_8
XFILLER_83_324 VPWR VGND sg13g2_fill_1
X_19779_ _19779_/Y _11889_/A _20334_/B _19778_/Y VPWR VGND sg13g2_o21ai_1
XFILLER_3_1022 VPWR VGND sg13g2_fill_1
XFILLER_3_1033 VPWR VGND sg13g2_decap_8
X_21810_ _21810_/Y _23902_/Q _21818_/B VPWR VGND sg13g2_nand2_1
X_22790_ _22790_/Q clkload22/A _22790_/D fanout2876/X VPWR VGND sg13g2_dfrbpq_1
XFILLER_83_379 VPWR VGND sg13g2_fill_2
XFILLER_97_1062 VPWR VGND sg13g2_decap_8
XFILLER_0_1921 VPWR VGND sg13g2_decap_8
XFILLER_97_1073 VPWR VGND sg13g2_fill_1
XFILLER_92_891 VPWR VGND sg13g2_decap_8
XFILLER_64_593 VPWR VGND sg13g2_fill_2
XFILLER_51_210 VPWR VGND sg13g2_decap_8
XFILLER_52_744 VPWR VGND sg13g2_decap_8
XFILLER_25_969 VPWR VGND sg13g2_decap_8
XFILLER_52_755 VPWR VGND sg13g2_fill_2
X_21672_ _23848_/D _23848_/Q _21898_/A0 _21689_/S VPWR VGND sg13g2_mux2_1
XFILLER_36_1333 VPWR VGND sg13g2_decap_8
X_23411_ _23411_/Q clkload50/A _23411_/D fanout2662/X VPWR VGND sg13g2_dfrbpq_1
X_20623_ _23365_/D _22425_/A1 _20624_/B _20622_/Y VPWR VGND sg13g2_o21ai_1
XFILLER_32_490 VPWR VGND sg13g2_decap_8
XFILLER_22_14 VPWR VGND sg13g2_fill_2
XFILLER_22_25 VPWR VGND sg13g2_fill_1
XFILLER_14_1620 VPWR VGND sg13g2_decap_8
X_23342_ _23342_/Q clkload35/A _23342_/D fanout2630/X VPWR VGND sg13g2_dfrbpq_1
X_20554_ _23332_/D _21261_/A1 _20572_/B _20553_/Y VPWR VGND sg13g2_o21ai_1
XFILLER_22_69 VPWR VGND sg13g2_fill_1
Xplace3940 _17538_/B _14174_/D VPWR VGND sg13g2_buf_1
Xplace3951 _19781_/B1 _19881_/B1 VPWR VGND sg13g2_buf_1
X_23273_ _23273_/Q clkload46/A _23273_/D fanout2672/X VPWR VGND sg13g2_dfrbpq_1
X_20485_ _23303_/D _22429_/A1 _20500_/B _20484_/Y VPWR VGND sg13g2_o21ai_1
Xplace3962 _14933_/S _14982_/S VPWR VGND sg13g2_buf_1
XFILLER_4_807 VPWR VGND sg13g2_fill_2
XFILLER_69_1120 VPWR VGND sg13g2_fill_2
XFILLER_106_702 VPWR VGND sg13g2_fill_1
Xplace3973 _18771_/B _14472_/B VPWR VGND sg13g2_buf_1
Xplace3984 _12788_/B _11705_/A VPWR VGND sg13g2_buf_2
X_22224_ _24100_/D _22356_/A1 _22247_/B _22223_/Y VPWR VGND sg13g2_o21ai_1
Xplace3995 _14189_/A _11477_/X VPWR VGND sg13g2_buf_1
Xclkbuf_leaf_0_clk_i _22869_/CLK clkbuf_leaf_0_clk_i/A VPWR VGND sg13g2_buf_16
X_22155_ _24067_/D _22288_/A1 _22168_/B _22154_/Y VPWR VGND sg13g2_o21ai_1
XFILLER_106_779 VPWR VGND sg13g2_decap_8
Xhold4642 _17293_/A _22776_/Q VPWR VGND sg13g2_dlygate4sd3_1
XFILLER_0_7 VPWR VGND sg13g2_decap_8
Xhold4653 _17291_/A _22775_/Q VPWR VGND sg13g2_dlygate4sd3_1
X_21106_ _21106_/Y _21106_/A _21112_/B VPWR VGND sg13g2_nand2_1
Xhold4664 _17447_/A _22842_/Q VPWR VGND sg13g2_dlygate4sd3_1
XFILLER_78_118 VPWR VGND sg13g2_decap_8
Xhold4675 _17337_/A _22796_/Q VPWR VGND sg13g2_dlygate4sd3_1
Xhold4686 _17321_/A _22789_/Q VPWR VGND sg13g2_dlygate4sd3_1
Xhold4697 _17295_/A _22777_/Q VPWR VGND sg13g2_dlygate4sd3_1
XFILLER_87_652 VPWR VGND sg13g2_fill_1
XFILLER_101_451 VPWR VGND sg13g2_fill_2
XFILLER_59_365 VPWR VGND sg13g2_decap_8
XFILLER_101_462 VPWR VGND sg13g2_fill_2
XFILLER_101_473 VPWR VGND sg13g2_fill_2
XFILLER_25_1782 VPWR VGND sg13g2_fill_1
XFILLER_5_1854 VPWR VGND sg13g2_decap_8
XFILLER_41_1050 VPWR VGND sg13g2_fill_1
XFILLER_21_1635 VPWR VGND sg13g2_decap_4
X_12810_ _12810_/Y _14129_/C _23492_/Q _12809_/X VPWR VGND sg13g2_a21oi_1
X_13790_ _13790_/X _13796_/B _13790_/B VPWR VGND sg13g2_and2_1
XFILLER_28_774 VPWR VGND sg13g2_fill_1
X_22988_ _22988_/Q clkload16/A _22988_/D fanout2919/X VPWR VGND sg13g2_dfrbpq_2
XFILLER_83_891 VPWR VGND sg13g2_decap_8
X_12741_ _12741_/X _24163_/Q _24195_/Q _23235_/Q _23267_/Q _13962_/S0 _12986_/S1 VPWR
+ VGND sg13g2_mux4_1
XFILLER_63_21 VPWR VGND sg13g2_decap_8
XFILLER_70_541 VPWR VGND sg13g2_fill_1
X_15460_ _15465_/B _22884_/Q _15296_/Y _15309_/Y _22488_/Q VPWR VGND sg13g2_a22oi_1
X_12672_ _12677_/A _12672_/A _13276_/A VPWR VGND sg13g2_nor2_1
XFILLER_93_1471 VPWR VGND sg13g2_decap_8
XFILLER_30_405 VPWR VGND sg13g2_fill_2
XFILLER_42_287 VPWR VGND sg13g2_decap_8
XFILLER_106_1512 VPWR VGND sg13g2_decap_4
X_23609_ _23609_/Q clkload59/A _23609_/D fanout2787/X VPWR VGND sg13g2_dfrbpq_1
X_11623_ _14090_/A _11623_/A _14116_/A _14116_/B _11623_/D VPWR VGND sg13g2_and4_1
X_15391_ _16435_/A _15391_/A VPWR VGND sg13g2_inv_1
XFILLER_11_641 VPWR VGND sg13g2_decap_4
XFILLER_50_1308 VPWR VGND sg13g2_decap_8
X_17130_ _17130_/Y _17130_/A _17141_/B VPWR VGND sg13g2_nor2_1
X_14342_ _14342_/Y _14342_/A _14342_/B _14342_/C _14342_/D VPWR VGND sg13g2_nor4_1
X_11554_ _11554_/Y _11551_/Y _11554_/A2 _11554_/B1 VPWR VGND sg13g2_o21ai_1
XFILLER_54_1499 VPWR VGND sg13g2_fill_2
XFILLER_13_1130 VPWR VGND sg13g2_fill_2
X_17061_ _17062_/B _17061_/A _17090_/A _17083_/B VPWR VGND sg13g2_nor3_1
X_14273_ _14273_/Y _17043_/A _14272_/Y _17532_/A VPWR VGND sg13g2_o21ai_1
XFILLER_32_1775 VPWR VGND sg13g2_fill_2
XFILLER_104_1280 VPWR VGND sg13g2_decap_8
XFILLER_13_1163 VPWR VGND sg13g2_decap_8
X_16012_ _16016_/C _22482_/Q _15639_/B _15317_/Y _22618_/Q VPWR VGND sg13g2_a22oi_1
XFILLER_109_573 VPWR VGND sg13g2_decap_8
XFILLER_12_80 VPWR VGND sg13g2_decap_4
X_13224_ _13225_/A _13155_/B _13223_/Y _14047_/A VPWR VGND sg13g2_a21oi_1
XFILLER_13_1196 VPWR VGND sg13g2_decap_8
XFILLER_100_1166 VPWR VGND sg13g2_decap_8
XFILLER_87_1286 VPWR VGND sg13g2_decap_8
X_13155_ _13155_/Y _14060_/B _13155_/B VPWR VGND sg13g2_xnor2_1
XFILLER_112_705 VPWR VGND sg13g2_decap_8
X_12106_ _12966_/A _15436_/A _19373_/A VPWR VGND sg13g2_nor2_1
X_17963_ _17977_/A _18463_/S _17960_/Y _17962_/Y VPWR VGND sg13g2_o21ai_1
X_13086_ _13086_/X _13086_/A _13086_/B VPWR VGND sg13g2_or2_1
XFILLER_65_1573 VPWR VGND sg13g2_decap_8
X_19702_ _19706_/B _19702_/A _19869_/B VPWR VGND sg13g2_nand2_1
XFILLER_78_652 VPWR VGND sg13g2_decap_8
X_16914_ _16915_/B _16914_/A _17030_/A _16954_/B VPWR VGND sg13g2_nor3_1
X_12037_ _12037_/Y _12414_/A _23162_/Q VPWR VGND sg13g2_nor2b_1
X_17894_ _17895_/B _22929_/Q _17909_/B VPWR VGND sg13g2_nand2_1
XFILLER_38_538 VPWR VGND sg13g2_decap_8
XFILLER_93_633 VPWR VGND sg13g2_fill_1
X_16845_ _16846_/B _22682_/Q _16849_/B VPWR VGND sg13g2_xnor2_1
XFILLER_66_858 VPWR VGND sg13g2_decap_8
XFILLER_19_752 VPWR VGND sg13g2_decap_8
XFILLER_4_1364 VPWR VGND sg13g2_decap_8
X_19564_ _19564_/Y _19563_/B _19375_/B _19563_/Y VPWR VGND sg13g2_o21ai_1
X_16776_ _16778_/C _16786_/C _16776_/B _16776_/C VPWR VGND sg13g2_nand3_1
XFILLER_20_1134 VPWR VGND sg13g2_decap_8
XFILLER_59_1311 VPWR VGND sg13g2_fill_2
XFILLER_81_828 VPWR VGND sg13g2_decap_8
XFILLER_80_305 VPWR VGND sg13g2_decap_8
X_13988_ _13988_/Y _23187_/Q _13988_/A2 _13988_/B1 _13987_/Y VPWR VGND sg13g2_a22oi_1
X_15727_ _15734_/A _22928_/Q _15924_/B _15726_/Y VPWR VGND sg13g2_a21oi_1
X_18515_ _18515_/Y _18531_/A _18513_/Y _18514_/Y VPWR VGND sg13g2_a21oi_1
XFILLER_74_891 VPWR VGND sg13g2_decap_4
X_12939_ _12940_/B _12939_/A _12939_/B _12939_/C _12939_/D VPWR VGND sg13g2_nand4_1
X_19495_ _19519_/B _19582_/A _19835_/B _19495_/C VPWR VGND sg13g2_nor3_1
X_18446_ _18816_/B _19123_/A1 _23069_/Q _18446_/S VPWR VGND sg13g2_mux2_1
X_15658_ _15668_/B _22925_/Q _15552_/B _15698_/A2 _22497_/Q VPWR VGND sg13g2_a22oi_1
XFILLER_37_1631 VPWR VGND sg13g2_fill_1
XFILLER_61_585 VPWR VGND sg13g2_fill_1
XFILLER_37_1653 VPWR VGND sg13g2_fill_1
X_14609_ _14609_/Y _24219_/Q _14609_/B _14609_/C VPWR VGND sg13g2_nor3_1
X_18377_ _18377_/X _18377_/A _18377_/B VPWR VGND sg13g2_and2_1
XFILLER_57_1090 VPWR VGND sg13g2_decap_8
XFILLER_21_449 VPWR VGND sg13g2_fill_1
X_15589_ _15589_/X _17113_/A _22462_/Q _15589_/S VPWR VGND sg13g2_mux2_1
XFILLER_30_972 VPWR VGND sg13g2_fill_2
Xplace3203 _21952_/A1 _22286_/A1 VPWR VGND sg13g2_buf_1
XFILLER_50_1820 VPWR VGND sg13g2_decap_8
Xplace3214 _20300_/B _20283_/S VPWR VGND sg13g2_buf_1
Xplace3225 _21716_/B _21713_/B VPWR VGND sg13g2_buf_1
XFILLER_50_1842 VPWR VGND sg13g2_fill_2
XFILLER_11_1804 VPWR VGND sg13g2_decap_8
Xplace3236 _21657_/B _21674_/B VPWR VGND sg13g2_buf_1
Xplace3247 _21112_/B _21108_/B VPWR VGND sg13g2_buf_1
XFILLER_70_1290 VPWR VGND sg13g2_fill_2
Xplace3258 _22249_/A0 _22315_/A0 VPWR VGND sg13g2_buf_1
Xplace3269 _21971_/A1 _21342_/A1 VPWR VGND sg13g2_buf_1
XFILLER_102_1954 VPWR VGND sg13g2_fill_1
X_20270_ _23246_/D _20300_/B _22442_/A1 _20269_/Y VPWR VGND sg13g2_o21ai_1
XFILLER_108_28 VPWR VGND sg13g2_decap_8
XFILLER_115_565 VPWR VGND sg13g2_decap_8
XFILLER_66_1348 VPWR VGND sg13g2_decap_8
XFILLER_102_204 VPWR VGND sg13g2_decap_4
XFILLER_83_1684 VPWR VGND sg13g2_decap_8
XFILLER_83_1695 VPWR VGND sg13g2_decap_8
XFILLER_64_1072 VPWR VGND sg13g2_decap_8
X_23960_ _23960_/Q clkload52/A _23960_/D fanout2690/X VPWR VGND sg13g2_dfrbpq_1
XFILLER_69_663 VPWR VGND sg13g2_decap_8
XFILLER_97_983 VPWR VGND sg13g2_decap_4
X_22911_ _22911_/Q _22917_/CLK _22911_/D fanout2895/X VPWR VGND sg13g2_dfrbpq_1
XFILLER_111_793 VPWR VGND sg13g2_decap_8
XFILLER_79_1709 VPWR VGND sg13g2_fill_1
X_23891_ _23891_/Q clkload51/A _23891_/D fanout2664/X VPWR VGND sg13g2_dfrbpq_1
XFILLER_56_335 VPWR VGND sg13g2_fill_1
XFILLER_56_346 VPWR VGND sg13g2_decap_8
XFILLER_56_357 VPWR VGND sg13g2_decap_8
XFILLER_42_1392 VPWR VGND sg13g2_fill_2
X_22842_ _22842_/Q clkload21/A _22842_/D fanout2874/X VPWR VGND sg13g2_dfrbpq_1
XFILLER_25_700 VPWR VGND sg13g2_fill_2
XFILLER_77_1422 VPWR VGND sg13g2_fill_1
XFILLER_83_176 VPWR VGND sg13g2_decap_4
XFILLER_83_198 VPWR VGND sg13g2_decap_8
X_22773_ _22773_/Q _22869_/CLK _22773_/D fanout2793/X VPWR VGND sg13g2_dfrbpq_1
XFILLER_38_1406 VPWR VGND sg13g2_fill_1
XFILLER_77_1466 VPWR VGND sg13g2_decap_4
XFILLER_80_872 VPWR VGND sg13g2_decap_8
XFILLER_13_917 VPWR VGND sg13g2_fill_1
XFILLER_0_1773 VPWR VGND sg13g2_decap_4
XFILLER_90_1644 VPWR VGND sg13g2_fill_2
XFILLER_33_35 VPWR VGND sg13g2_fill_1
XFILLER_107_1832 VPWR VGND sg13g2_decap_8
X_21655_ _21655_/Y _21655_/A _21657_/B VPWR VGND sg13g2_nand2_1
XFILLER_51_1606 VPWR VGND sg13g2_fill_1
XFILLER_55_1775 VPWR VGND sg13g2_decap_8
XFILLER_90_1688 VPWR VGND sg13g2_decap_4
XFILLER_21_972 VPWR VGND sg13g2_decap_8
X_20606_ _23357_/D _21178_/A1 _20607_/B _20605_/Y VPWR VGND sg13g2_o21ai_1
X_21586_ _21586_/Y _23808_/Q _21590_/B VPWR VGND sg13g2_nand2_1
XFILLER_32_1038 VPWR VGND sg13g2_decap_8
X_23325_ _23325_/Q clkload55/A _23325_/D fanout2774/X VPWR VGND sg13g2_dfrbpq_1
Xrebuffer5450 _14032_/C _13356_/B VPWR VGND sg13g2_buf_1
X_20537_ _20537_/Y _23325_/Q _20539_/B VPWR VGND sg13g2_nand2_1
XFILLER_14_1461 VPWR VGND sg13g2_decap_8
Xrebuffer5461 place3976/A _12577_/Y VPWR VGND sg13g2_buf_2
Xrebuffer5472 _14690_/A1 _12990_/A VPWR VGND sg13g2_buf_1
Xrebuffer5483 _17838_/A _14407_/A VPWR VGND sg13g2_buf_1
Xplace3770 _12340_/A _13296_/A VPWR VGND sg13g2_buf_1
XFILLER_49_1502 VPWR VGND sg13g2_decap_8
Xrebuffer5494 _13733_/A _20243_/B VPWR VGND sg13g2_buf_1
XFILLER_106_510 VPWR VGND sg13g2_decap_8
X_23256_ _23256_/Q clkload57/A _23256_/D fanout2761/X VPWR VGND sg13g2_dfrbpq_1
Xplace3781 _12959_/A _12428_/C VPWR VGND sg13g2_buf_1
XFILLER_88_1562 VPWR VGND sg13g2_decap_8
XFILLER_10_1336 VPWR VGND sg13g2_decap_8
X_20468_ _23295_/D _22412_/A1 _20473_/B _20467_/Y VPWR VGND sg13g2_o21ai_1
X_11270_ _11502_/D _11249_/X _11270_/B VPWR VGND sg13g2_nand2b_1
Xplace3792 _19605_/A _11662_/B VPWR VGND sg13g2_buf_1
Xhold5140 _21489_/A _23764_/Q VPWR VGND sg13g2_dlygate4sd3_1
Xhold5151 _21543_/A _23788_/Q VPWR VGND sg13g2_dlygate4sd3_1
Xhold5162 _21612_/A _23822_/Q VPWR VGND sg13g2_dlygate4sd3_1
X_20399_ _23263_/D _22412_/A1 _20404_/B _20398_/Y VPWR VGND sg13g2_o21ai_1
X_23187_ _23187_/Q _23187_/CLK _23187_/D fanout2915/X VPWR VGND sg13g2_dfrbpq_1
Xhold5173 _17571_/A _22880_/Q VPWR VGND sg13g2_dlygate4sd3_1
Xhold5184 _19753_/A _23224_/Q VPWR VGND sg13g2_dlygate4sd3_1
XFILLER_49_1568 VPWR VGND sg13g2_decap_4
XFILLER_106_587 VPWR VGND sg13g2_decap_8
Xhold5195 _22017_/A _24002_/Q VPWR VGND sg13g2_dlygate4sd3_1
X_22138_ _22138_/Y _22138_/A _22142_/B VPWR VGND sg13g2_nand2_1
X_14960_ _14962_/B _14956_/Y _14958_/Y _14959_/Y VPWR VGND sg13g2_a21o_1
XFILLER_114_1825 VPWR VGND sg13g2_decap_8
X_22069_ _22069_/Y _22069_/A _22069_/B VPWR VGND sg13g2_nand2_1
X_13911_ _13912_/A _23571_/Q _13911_/A2 _13910_/X _13911_/B2 VPWR VGND sg13g2_a22oi_1
XFILLER_47_313 VPWR VGND sg13g2_fill_2
XFILLER_59_184 VPWR VGND sg13g2_decap_8
XFILLER_48_858 VPWR VGND sg13g2_fill_2
X_16630_ _16631_/B _16635_/A _16634_/B VPWR VGND sg13g2_nand2_1
XFILLER_78_1219 VPWR VGND sg13g2_decap_8
X_13842_ _13842_/X _23730_/Q _23762_/Q _23794_/Q _23826_/Q _13961_/S0 _13964_/S1 VPWR
+ VGND sg13g2_mux4_1
XFILLER_63_828 VPWR VGND sg13g2_decap_4
XFILLER_74_154 VPWR VGND sg13g2_fill_2
XFILLER_28_560 VPWR VGND sg13g2_decap_8
XFILLER_95_1522 VPWR VGND sg13g2_fill_2
XFILLER_16_711 VPWR VGND sg13g2_decap_4
XFILLER_74_64 VPWR VGND sg13g2_decap_8
X_16561_ _16561_/Y _16561_/A _16561_/B VPWR VGND sg13g2_nor2_1
XFILLER_74_75 VPWR VGND sg13g2_fill_2
X_13773_ _13774_/B _23313_/Q _23345_/Q _23377_/Q _23409_/Q _13773_/S0 _13911_/B2 VPWR
+ VGND sg13g2_mux4_1
XFILLER_90_669 VPWR VGND sg13g2_fill_1
X_15512_ _15512_/Y _19428_/A _15690_/B VPWR VGND sg13g2_nor2_1
X_18300_ _18301_/C _18361_/B _18295_/Y _18299_/Y VPWR VGND sg13g2_a21oi_1
X_19280_ _23198_/D _23198_/Q _20255_/A1 _19300_/S VPWR VGND sg13g2_mux2_1
X_12724_ _12725_/C _11363_/B _12707_/X _12716_/X _13245_/B2 _12723_/Y VPWR VGND sg13g2_a221oi_1
X_16492_ _16492_/Y _22608_/Q _16495_/S VPWR VGND sg13g2_nand2_1
XFILLER_15_287 VPWR VGND sg13g2_decap_8
Xinput4360 _17890_/A1 boot_addr_i[18] VPWR VGND sg13g2_buf_1
X_18231_ _22969_/D _18565_/B _18229_/Y _18230_/Y VPWR VGND sg13g2_o21ai_1
Xinput4371 _17924_/A1 boot_addr_i[29] VPWR VGND sg13g2_buf_1
XFILLER_31_747 VPWR VGND sg13g2_decap_4
X_12655_ _12655_/Y _24130_/Q _12997_/S VPWR VGND sg13g2_nand2b_1
XFILLER_70_393 VPWR VGND sg13g2_decap_8
Xinput4382 _20316_/A1 data_rdata_i[13] VPWR VGND sg13g2_buf_1
XFILLER_19_1372 VPWR VGND sg13g2_fill_2
Xinput4393 _20095_/A0 data_rdata_i[23] VPWR VGND sg13g2_buf_1
X_18162_ _18416_/A _18162_/A _18210_/B VPWR VGND sg13g2_nand2_1
XFILLER_8_910 VPWR VGND sg13g2_decap_4
XFILLER_50_1105 VPWR VGND sg13g2_decap_4
X_11606_ _11606_/X _11606_/A _11606_/B VPWR VGND sg13g2_or2_1
X_15374_ _15374_/X _19727_/S _16352_/B _19740_/A VPWR VGND sg13g2_and3_1
XFILLER_15_1236 VPWR VGND sg13g2_fill_1
XFILLER_12_972 VPWR VGND sg13g2_fill_1
XFILLER_50_1116 VPWR VGND sg13g2_fill_1
XFILLER_54_1285 VPWR VGND sg13g2_decap_8
XFILLER_106_1375 VPWR VGND sg13g2_decap_8
X_17113_ _17113_/Y _17113_/A _17113_/B VPWR VGND sg13g2_nor2_1
XFILLER_106_1386 VPWR VGND sg13g2_fill_2
X_14325_ _19980_/B _14358_/B VPWR VGND sg13g2_inv_1
X_11537_ _11537_/Y _11537_/A VPWR VGND sg13g2_inv_1
XFILLER_11_493 VPWR VGND sg13g2_decap_8
X_18093_ _18569_/C _24226_/Q _18595_/A1 VPWR VGND sg13g2_nor2b_1
X_17044_ _17045_/C _17044_/A _17044_/B _17044_/C _17044_/D VPWR VGND sg13g2_nor4_1
X_14256_ _14609_/B _24218_/Q _24223_/Q VPWR VGND sg13g2_or2_1
XFILLER_67_1602 VPWR VGND sg13g2_decap_8
XFILLER_109_381 VPWR VGND sg13g2_fill_1
X_11468_ _11468_/Y _11714_/S _23574_/Q _11467_/Y VPWR VGND sg13g2_o21ai_1
XFILLER_48_1001 VPWR VGND sg13g2_decap_4
X_13207_ _13208_/B _24169_/Q _23305_/Q _13213_/S VPWR VGND sg13g2_mux2_1
XFILLER_48_1012 VPWR VGND sg13g2_fill_1
XFILLER_98_714 VPWR VGND sg13g2_decap_4
X_14187_ _24221_/D _14187_/A _17540_/A _14187_/C VPWR VGND sg13g2_nor3_1
XFILLER_112_502 VPWR VGND sg13g2_decap_8
X_11399_ _11414_/A _11427_/B _11423_/B VPWR VGND sg13g2_or2_2
XFILLER_45_1900 VPWR VGND sg13g2_fill_2
X_13138_ _13146_/A _13138_/A _13138_/B VPWR VGND sg13g2_nor2_1
XFILLER_45_1922 VPWR VGND sg13g2_fill_1
X_18995_ _18997_/B _18995_/A _19039_/B VPWR VGND sg13g2_nand2_1
XFILLER_98_769 VPWR VGND sg13g2_decap_8
XFILLER_80_1835 VPWR VGND sg13g2_fill_1
XFILLER_79_961 VPWR VGND sg13g2_decap_8
XFILLER_6_1404 VPWR VGND sg13g2_fill_1
XFILLER_112_579 VPWR VGND sg13g2_decap_8
XFILLER_100_719 VPWR VGND sg13g2_fill_2
X_17946_ _17947_/B _18929_/A _23051_/Q _18922_/A VPWR VGND sg13g2_mux2_1
X_13069_ _13069_/Y _14103_/A _13069_/B _13071_/B VPWR VGND sg13g2_nor3_1
XFILLER_61_1256 VPWR VGND sg13g2_fill_2
XFILLER_26_1387 VPWR VGND sg13g2_decap_4
XFILLER_94_942 VPWR VGND sg13g2_decap_8
XFILLER_94_953 VPWR VGND sg13g2_fill_2
X_17877_ _22923_/D _17877_/A _17877_/B VPWR VGND sg13g2_nand2_1
X_16828_ _16829_/B _22677_/Q _22676_/Q _22675_/Q _16828_/D VPWR VGND sg13g2_nand4_1
XFILLER_54_839 VPWR VGND sg13g2_decap_8
XFILLER_93_496 VPWR VGND sg13g2_decap_8
XFILLER_78_1742 VPWR VGND sg13g2_decap_8
XFILLER_80_124 VPWR VGND sg13g2_decap_8
X_16759_ _16760_/B _22667_/Q _16770_/D VPWR VGND sg13g2_xor2_1
XFILLER_0_72 VPWR VGND sg13g2_fill_1
XFILLER_53_349 VPWR VGND sg13g2_decap_8
XFILLER_78_1775 VPWR VGND sg13g2_decap_8
XFILLER_80_168 VPWR VGND sg13g2_fill_2
XFILLER_94_1076 VPWR VGND sg13g2_decap_4
XFILLER_91_1920 VPWR VGND sg13g2_decap_8
XFILLER_55_1027 VPWR VGND sg13g2_decap_4
X_18429_ _18430_/B _18379_/B _18422_/Y _18428_/Y VPWR VGND sg13g2_a21oi_1
XFILLER_37_1461 VPWR VGND sg13g2_fill_2
XFILLER_33_1314 VPWR VGND sg13g2_decap_8
XFILLER_72_1363 VPWR VGND sg13g2_decap_4
X_21440_ _23738_/D _21934_/A1 _21441_/B _21439_/Y VPWR VGND sg13g2_o21ai_1
Xplace3000 _17218_/A _17144_/B VPWR VGND sg13g2_buf_1
XFILLER_9_92 VPWR VGND sg13g2_decap_8
XFILLER_30_780 VPWR VGND sg13g2_fill_1
Xplace3011 _22276_/B _22263_/B VPWR VGND sg13g2_buf_1
XFILLER_108_808 VPWR VGND sg13g2_fill_2
Xplace3022 _22250_/B _22247_/B VPWR VGND sg13g2_buf_1
X_21371_ _23705_/D _21932_/A1 _21380_/B _21370_/Y VPWR VGND sg13g2_o21ai_1
Xplace3033 _22160_/B _22175_/B VPWR VGND sg13g2_buf_1
XFILLER_15_1770 VPWR VGND sg13g2_fill_2
Xplace3044 _22047_/S _22045_/B VPWR VGND sg13g2_buf_1
Xplace3055 _21957_/B _21961_/B VPWR VGND sg13g2_buf_1
Xplace3066 _21804_/B _21802_/B VPWR VGND sg13g2_buf_1
XFILLER_11_1634 VPWR VGND sg13g2_decap_8
X_23110_ _23110_/Q _23114_/CLK _23110_/D fanout2907/X VPWR VGND sg13g2_dfrbpq_1
X_20322_ _20322_/Y _20322_/A _20322_/B _20338_/C VPWR VGND sg13g2_nand3_1
Xplace3077 _21581_/B _21572_/B VPWR VGND sg13g2_buf_1
X_24090_ _24090_/Q clkload48/A _24090_/D fanout2686/X VPWR VGND sg13g2_dfrbpq_1
XFILLER_89_1871 VPWR VGND sg13g2_decap_4
Xplace3088 _21539_/B _21534_/B VPWR VGND sg13g2_buf_1
XFILLER_85_1713 VPWR VGND sg13g2_decap_8
Xplace3099 _21422_/B _21416_/B VPWR VGND sg13g2_buf_1
XFILLER_11_1678 VPWR VGND sg13g2_fill_2
XFILLER_11_1689 VPWR VGND sg13g2_fill_1
X_23041_ _23041_/Q _23114_/CLK _23041_/D fanout2907/X VPWR VGND sg13g2_dfrbpq_1
XFILLER_103_513 VPWR VGND sg13g2_decap_8
XFILLER_0_117 VPWR VGND sg13g2_decap_4
XFILLER_27_1118 VPWR VGND sg13g2_decap_4
X_20184_ _20184_/Y _20272_/A _15774_/C _20201_/B VPWR VGND sg13g2_o21ai_1
XFILLER_44_1421 VPWR VGND sg13g2_fill_1
XFILLER_76_408 VPWR VGND sg13g2_fill_1
XFILLER_57_622 VPWR VGND sg13g2_fill_2
X_23943_ _23943_/Q clkload37/A _23943_/D fanout2709/X VPWR VGND sg13g2_dfrbpq_1
XFILLER_111_590 VPWR VGND sg13g2_decap_8
XFILLER_85_953 VPWR VGND sg13g2_fill_2
XFILLER_22_1730 VPWR VGND sg13g2_fill_1
XFILLER_56_132 VPWR VGND sg13g2_decap_8
XFILLER_2_1813 VPWR VGND sg13g2_decap_8
XFILLER_56_143 VPWR VGND sg13g2_fill_2
XFILLER_79_1539 VPWR VGND sg13g2_fill_1
X_23874_ _23874_/Q clkload39/A _23874_/D fanout2732/X VPWR VGND sg13g2_dfrbpq_1
XFILLER_72_614 VPWR VGND sg13g2_fill_2
XFILLER_44_316 VPWR VGND sg13g2_decap_4
XFILLER_84_485 VPWR VGND sg13g2_decap_8
XFILLER_84_496 VPWR VGND sg13g2_fill_1
XFILLER_77_1230 VPWR VGND sg13g2_fill_2
X_22825_ _22825_/Q _22869_/CLK _22825_/D fanout2797/X VPWR VGND sg13g2_dfrbpq_1
XFILLER_57_1804 VPWR VGND sg13g2_decap_8
XFILLER_72_658 VPWR VGND sg13g2_decap_8
XFILLER_25_541 VPWR VGND sg13g2_decap_8
XFILLER_96_1886 VPWR VGND sg13g2_fill_1
X_22756_ _22756_/Q clkload22/A _22756_/D fanout2885/X VPWR VGND sg13g2_dfrbpq_1
XFILLER_25_574 VPWR VGND sg13g2_fill_2
XFILLER_38_1236 VPWR VGND sg13g2_decap_8
XFILLER_77_1296 VPWR VGND sg13g2_decap_8
XFILLER_52_360 VPWR VGND sg13g2_decap_8
XFILLER_25_596 VPWR VGND sg13g2_decap_8
X_21707_ _23864_/D _21930_/A1 _21783_/B _21706_/Y VPWR VGND sg13g2_o21ai_1
X_22687_ _22687_/Q clkload23/A _22687_/D fanout2890/X VPWR VGND sg13g2_dfrbpq_1
X_12440_ _14059_/A _12440_/A _12440_/B _12440_/C VPWR VGND sg13g2_and3_1
XFILLER_55_1583 VPWR VGND sg13g2_decap_8
XFILLER_60_11 VPWR VGND sg13g2_fill_1
X_21638_ _21638_/Y _21638_/A _21648_/B VPWR VGND sg13g2_nand2_1
XFILLER_100_84 VPWR VGND sg13g2_decap_8
XFILLER_90_1485 VPWR VGND sg13g2_fill_1
Xclkbuf_leaf_33_clk_i _23966_/CLK clkload4/A VPWR VGND sg13g2_buf_16
X_12371_ _12372_/B _24159_/Q _23295_/Q _12502_/S VPWR VGND sg13g2_mux2_1
XFILLER_60_66 VPWR VGND sg13g2_decap_8
X_21569_ _23800_/D _21930_/A1 _21620_/S _21568_/Y VPWR VGND sg13g2_o21ai_1
Xplace4290 _13617_/B _13621_/S VPWR VGND sg13g2_buf_1
X_14110_ _14111_/B _14431_/A _14433_/B _14110_/S VPWR VGND sg13g2_mux2_1
XFILLER_68_1900 VPWR VGND sg13g2_decap_4
X_23308_ _23308_/Q clkload35/A _23308_/D fanout2632/X VPWR VGND sg13g2_dfrbpq_1
X_11322_ _11322_/Y _14121_/A _19360_/A _11233_/D VPWR VGND sg13g2_a21oi_1
Xrebuffer5280 place3978/A _12042_/Y VPWR VGND sg13g2_buf_2
X_15090_ _15090_/X _22540_/Q _15117_/A _15089_/Y VPWR VGND sg13g2_a21o_2
Xrebuffer5291 _14068_/B _17041_/A VPWR VGND sg13g2_buf_1
XFILLER_107_830 VPWR VGND sg13g2_fill_1
XFILLER_5_28 VPWR VGND sg13g2_fill_1
XFILLER_88_1370 VPWR VGND sg13g2_fill_1
XFILLER_5_39 VPWR VGND sg13g2_decap_8
XFILLER_107_0 VPWR VGND sg13g2_decap_8
X_14041_ _14042_/B _19322_/A _14041_/B _14041_/C VPWR VGND sg13g2_nor3_1
X_23239_ _23239_/Q clkload34/A _23239_/D fanout2632/X VPWR VGND sg13g2_dfrbpq_1
Xrebuffer4590 _12951_/B _12950_/B VPWR VGND sg13g2_buf_1
XFILLER_106_351 VPWR VGND sg13g2_decap_8
XFILLER_10_1177 VPWR VGND sg13g2_fill_1
XFILLER_49_1354 VPWR VGND sg13g2_fill_2
XFILLER_64_1808 VPWR VGND sg13g2_fill_2
XFILLER_49_1365 VPWR VGND sg13g2_fill_1
Xclkbuf_leaf_48_clk_i clkload37/A clkbuf_4_9__f_clk_i/X VPWR VGND sg13g2_buf_16
X_11184_ _14120_/B _11311_/A _22969_/Q VPWR VGND sg13g2_nor2_2
XFILLER_84_1278 VPWR VGND sg13g2_decap_8
XFILLER_79_246 VPWR VGND sg13g2_decap_8
XFILLER_95_706 VPWR VGND sg13g2_decap_8
XFILLER_79_257 VPWR VGND sg13g2_fill_1
X_17800_ _17800_/Y _17806_/A _17806_/B VPWR VGND sg13g2_xnor2_1
XFILLER_95_717 VPWR VGND sg13g2_fill_2
XFILLER_79_268 VPWR VGND sg13g2_fill_2
X_18780_ _18782_/B _18778_/Y _18779_/Y _18780_/S VPWR VGND sg13g2_mux2_1
X_15992_ _15993_/D _22617_/Q _15992_/A2 _15992_/B1 _22812_/Q VPWR VGND sg13g2_a22oi_1
XFILLER_7_1757 VPWR VGND sg13g2_decap_8
XFILLER_76_931 VPWR VGND sg13g2_decap_8
XFILLER_27_1696 VPWR VGND sg13g2_fill_1
X_17731_ _17739_/A _22567_/Q VPWR VGND sg13g2_inv_1
XFILLER_76_942 VPWR VGND sg13g2_fill_1
XFILLER_110_1519 VPWR VGND sg13g2_decap_8
XFILLER_85_85 VPWR VGND sg13g2_decap_8
XFILLER_35_305 VPWR VGND sg13g2_decap_4
X_14874_ _14875_/C _22458_/Q _14874_/B VPWR VGND sg13g2_nand2_1
XFILLER_63_614 VPWR VGND sg13g2_fill_2
X_17662_ _22889_/D _17661_/B _17659_/Y _17661_/Y VPWR VGND sg13g2_a21oi_1
X_19401_ _19477_/B _19401_/A _19401_/B VPWR VGND sg13g2_and2_1
XFILLER_75_496 VPWR VGND sg13g2_fill_1
X_16613_ _16628_/D _22637_/Q _22636_/Q _22635_/Q _22634_/Q VPWR VGND sg13g2_and4_1
XFILLER_40_1885 VPWR VGND sg13g2_decap_4
X_13825_ _13825_/Y _13824_/X _13985_/B VPWR VGND sg13g2_nand2b_1
XFILLER_90_433 VPWR VGND sg13g2_decap_4
X_17593_ _17624_/D _22552_/Q _17593_/B VPWR VGND sg13g2_and2_1
XFILLER_44_861 VPWR VGND sg13g2_decap_8
X_16544_ _16549_/B _22623_/Q _22622_/Q _22621_/Q _22620_/Q VPWR VGND sg13g2_and4_1
X_13756_ _24272_/A _14059_/B VPWR VGND sg13g2_inv_2
XFILLER_31_511 VPWR VGND sg13g2_decap_8
X_12707_ _12707_/X _12705_/X _12706_/X _12707_/S VPWR VGND sg13g2_mux2_1
X_19263_ _19263_/Y _19263_/A _19268_/A VPWR VGND sg13g2_nor2b_1
X_16475_ _22600_/D _16109_/A _16514_/B _16474_/Y VPWR VGND sg13g2_o21ai_1
XFILLER_108_1448 VPWR VGND sg13g2_fill_2
X_13687_ _13687_/Y _13686_/A _13684_/Y _13686_/Y VPWR VGND sg13g2_o21ai_1
XFILLER_31_566 VPWR VGND sg13g2_fill_2
X_15426_ _15435_/C _15423_/Y _16681_/C VPWR VGND sg13g2_nand2b_1
X_18214_ _18423_/B _18363_/A _18274_/B VPWR VGND sg13g2_nor2_1
XFILLER_31_577 VPWR VGND sg13g2_fill_2
X_12638_ _12638_/X _12759_/A _12638_/B _12638_/C VPWR VGND sg13g2_and3_1
Xoutput4505 data_wdata_o[11] _14703_/X VPWR VGND sg13g2_buf_1
Xoutput4516 data_wdata_o[21] _14729_/X VPWR VGND sg13g2_buf_1
XFILLER_54_1082 VPWR VGND sg13g2_decap_8
Xoutput4527 data_wdata_o[31] _14739_/X VPWR VGND sg13g2_buf_1
XFILLER_54_1093 VPWR VGND sg13g2_fill_1
Xoutput4538 instr_addr_o[12] _14933_/X VPWR VGND sg13g2_buf_1
XFILLER_8_762 VPWR VGND sg13g2_decap_4
Xoutput4549 instr_addr_o[23] _19176_/A VPWR VGND sg13g2_buf_1
X_12569_ _12569_/X _24065_/Q _24129_/Q _12570_/S VPWR VGND sg13g2_mux2_1
XFILLER_12_1932 VPWR VGND sg13g2_decap_8
XFILLER_69_1719 VPWR VGND sg13g2_fill_2
X_14308_ _14308_/Y _15289_/A _15186_/A _14307_/Y VPWR VGND sg13g2_o21ai_1
XFILLER_7_272 VPWR VGND sg13g2_fill_1
X_18076_ _18076_/Y _18504_/A _18076_/B VPWR VGND sg13g2_nor2_1
X_17027_ _22714_/D _16927_/S _17025_/Y _17026_/Y VPWR VGND sg13g2_o21ai_1
X_14239_ _14596_/B _24222_/Q VPWR VGND sg13g2_inv_1
XFILLER_82_1919 VPWR VGND sg13g2_fill_2
XFILLER_113_855 VPWR VGND sg13g2_decap_8
XFILLER_80_1610 VPWR VGND sg13g2_fill_2
XFILLER_28_1449 VPWR VGND sg13g2_decap_8
XFILLER_86_706 VPWR VGND sg13g2_fill_2
XFILLER_86_728 VPWR VGND sg13g2_decap_8
XFILLER_80_1632 VPWR VGND sg13g2_decap_4
X_18978_ _18980_/B _18975_/Y _19001_/C VPWR VGND sg13g2_nand2b_1
XFILLER_22_0 VPWR VGND sg13g2_decap_8
XFILLER_61_1031 VPWR VGND sg13g2_decap_8
XFILLER_6_1223 VPWR VGND sg13g2_decap_8
XFILLER_80_1665 VPWR VGND sg13g2_fill_1
X_17929_ _17931_/A _17929_/A1 _17929_/A2 _17929_/B1 _17929_/B2 VPWR VGND sg13g2_a22oi_1
XFILLER_22_1015 VPWR VGND sg13g2_decap_8
XFILLER_22_1026 VPWR VGND sg13g2_decap_8
XFILLER_38_132 VPWR VGND sg13g2_decap_8
XFILLER_82_901 VPWR VGND sg13g2_decap_8
XFILLER_6_1278 VPWR VGND sg13g2_decap_8
XFILLER_2_1109 VPWR VGND sg13g2_fill_2
X_20940_ _20940_/Y _20940_/A _20945_/B VPWR VGND sg13g2_nand2_1
XFILLER_39_688 VPWR VGND sg13g2_decap_8
XFILLER_67_997 VPWR VGND sg13g2_fill_1
XFILLER_81_411 VPWR VGND sg13g2_fill_2
XFILLER_38_176 VPWR VGND sg13g2_decap_8
X_20871_ _23482_/D _21305_/A1 _20874_/B _20870_/Y VPWR VGND sg13g2_o21ai_1
XFILLER_26_349 VPWR VGND sg13g2_fill_2
XFILLER_74_1403 VPWR VGND sg13g2_decap_4
X_22610_ _22610_/Q _22893_/CLK _22610_/D fanout2817/X VPWR VGND sg13g2_dfrbpq_1
XFILLER_81_488 VPWR VGND sg13g2_decap_8
X_23590_ _23590_/Q clkload42/A _23590_/D fanout2720/X VPWR VGND sg13g2_dfrbpq_1
XFILLER_35_883 VPWR VGND sg13g2_decap_8
X_22541_ _22541_/Q clkload6/A _22541_/D fanout2832/X VPWR VGND sg13g2_dfrbpq_1
XFILLER_74_1469 VPWR VGND sg13g2_fill_2
XFILLER_52_1712 VPWR VGND sg13g2_decap_4
XFILLER_17_1843 VPWR VGND sg13g2_decap_8
XFILLER_14_59 VPWR VGND sg13g2_fill_1
X_22472_ _22472_/Q clkload9/A _22472_/D fanout2823/X VPWR VGND sg13g2_dfrbpq_1
XFILLER_52_1756 VPWR VGND sg13g2_fill_1
X_24211_ _24211_/Q clkload50/A _24211_/D fanout2663/X VPWR VGND sg13g2_dfrbpq_1
X_21423_ _23732_/D _21622_/A1 _21422_/B _21422_/Y VPWR VGND sg13g2_o21ai_1
X_24142_ _24142_/Q _24170_/CLK _24142_/D fanout2639/X VPWR VGND sg13g2_dfrbpq_1
XFILLER_107_126 VPWR VGND sg13g2_decap_8
X_21354_ _23700_/D _21622_/A1 _21353_/B _21353_/Y VPWR VGND sg13g2_o21ai_1
XFILLER_11_1442 VPWR VGND sg13g2_decap_8
X_20305_ _20309_/A _20305_/A _20305_/B _20305_/C VPWR VGND sg13g2_nand3_1
XFILLER_100_7 VPWR VGND sg13g2_decap_8
X_24073_ _24073_/Q _24205_/CLK _24073_/D fanout2650/X VPWR VGND sg13g2_dfrbpq_1
X_21285_ _23666_/D _21619_/A1 _21287_/B _21284_/Y VPWR VGND sg13g2_o21ai_1
XFILLER_89_511 VPWR VGND sg13g2_fill_2
Xfanout2908 fanout2908/X fanout2914/X VPWR VGND sg13g2_buf_1
X_23024_ _23024_/Q clkload6/A _23024_/D fanout2835/X VPWR VGND sg13g2_dfrbpq_1
Xfanout2919 fanout2919/X fanout2922/X VPWR VGND sg13g2_buf_1
XFILLER_46_1516 VPWR VGND sg13g2_fill_1
XFILLER_81_1407 VPWR VGND sg13g2_decap_8
X_20236_ _20236_/Y _20236_/A _20236_/B VPWR VGND sg13g2_nand2_1
XFILLER_63_1830 VPWR VGND sg13g2_fill_2
XFILLER_7_1009 VPWR VGND sg13g2_decap_8
XFILLER_39_34 VPWR VGND sg13g2_decap_8
X_20167_ _20168_/C _20356_/B _20165_/Y _20166_/Y VPWR VGND sg13g2_a21oi_1
XFILLER_24_1803 VPWR VGND sg13g2_fill_2
XFILLER_115_1931 VPWR VGND sg13g2_decap_8
XFILLER_77_739 VPWR VGND sg13g2_fill_1
XFILLER_24_1836 VPWR VGND sg13g2_decap_8
XFILLER_76_238 VPWR VGND sg13g2_fill_2
X_20098_ _20099_/A _20098_/A0 _23212_/Q _23220_/Q _20098_/A3 _20224_/A _20316_/S0
+ VPWR VGND sg13g2_mux4_1
XFILLER_24_1847 VPWR VGND sg13g2_fill_2
XFILLER_57_430 VPWR VGND sg13g2_fill_2
XFILLER_69_290 VPWR VGND sg13g2_decap_4
XFILLER_29_132 VPWR VGND sg13g2_decap_8
X_23926_ _23926_/Q clkload58/A _23926_/D fanout2759/X VPWR VGND sg13g2_dfrbpq_1
XFILLER_45_614 VPWR VGND sg13g2_decap_8
XFILLER_84_282 VPWR VGND sg13g2_decap_8
X_23857_ _23857_/Q clkload51/A _23857_/D fanout2666/X VPWR VGND sg13g2_dfrbpq_1
X_11871_ _11983_/C _14441_/A _11681_/Y _11732_/Y VPWR VGND sg13g2_a21o_1
XFILLER_17_349 VPWR VGND sg13g2_decap_8
XFILLER_26_850 VPWR VGND sg13g2_decap_8
XFILLER_96_1672 VPWR VGND sg13g2_decap_8
X_13610_ _13611_/B _23311_/Q _23343_/Q _23375_/Q _23407_/Q _13610_/S0 _13111_/A VPWR
+ VGND sg13g2_mux4_1
XFILLER_2_1687 VPWR VGND sg13g2_decap_8
XFILLER_38_1000 VPWR VGND sg13g2_decap_4
XFILLER_60_606 VPWR VGND sg13g2_decap_4
X_22808_ _22808_/Q clkload10/A _22808_/D fanout2811/X VPWR VGND sg13g2_dfrbpq_1
XFILLER_44_168 VPWR VGND sg13g2_fill_2
XFILLER_109_1702 VPWR VGND sg13g2_decap_8
XFILLER_44_179 VPWR VGND sg13g2_fill_1
X_23788_ _23788_/Q clkload49/A _23788_/D fanout2744/X VPWR VGND sg13g2_dfrbpq_1
XFILLER_57_1667 VPWR VGND sg13g2_decap_8
XFILLER_109_1746 VPWR VGND sg13g2_decap_4
XFILLER_18_1629 VPWR VGND sg13g2_decap_8
XFILLER_25_393 VPWR VGND sg13g2_fill_2
X_13541_ _13541_/Y _13540_/Y _13534_/Y _13512_/Y VPWR VGND sg13g2_o21ai_1
XFILLER_71_21 VPWR VGND sg13g2_decap_8
X_22739_ _22739_/Q clkload20/A _22739_/D fanout2868/X VPWR VGND sg13g2_dfrbpq_1
XFILLER_109_1757 VPWR VGND sg13g2_fill_1
XFILLER_16_1320 VPWR VGND sg13g2_fill_2
X_16260_ _16261_/B _16263_/A _16273_/C VPWR VGND sg13g2_nand2_1
XFILLER_35_1943 VPWR VGND sg13g2_decap_8
XFILLER_40_363 VPWR VGND sg13g2_decap_8
XFILLER_71_65 VPWR VGND sg13g2_decap_8
XFILLER_35_1954 VPWR VGND sg13g2_fill_1
X_13472_ _20243_/A _13651_/A _13539_/B _13539_/C VPWR VGND sg13g2_and3_1
XFILLER_31_1807 VPWR VGND sg13g2_fill_1
XFILLER_70_1856 VPWR VGND sg13g2_decap_8
XFILLER_16_1353 VPWR VGND sg13g2_fill_1
XFILLER_40_396 VPWR VGND sg13g2_decap_4
X_12423_ _12429_/C _19928_/A _19928_/B VPWR VGND sg13g2_or2_1
XFILLER_16_1364 VPWR VGND sg13g2_decap_8
X_16191_ _16191_/X _22510_/Q _16197_/B VPWR VGND sg13g2_and2_1
XFILLER_70_1889 VPWR VGND sg13g2_fill_2
XFILLER_12_1228 VPWR VGND sg13g2_decap_8
X_15142_ _16784_/A _15447_/C _15447_/A _15447_/B VPWR VGND sg13g2_nand3b_1
XFILLER_5_710 VPWR VGND sg13g2_fill_1
XFILLER_5_721 VPWR VGND sg13g2_fill_2
X_12354_ _12355_/B _12439_/A _12531_/B _12354_/C VPWR VGND sg13g2_or3_1
XFILLER_86_1318 VPWR VGND sg13g2_decap_8
X_11305_ _11305_/Y _11569_/A _11305_/B VPWR VGND sg13g2_nand2_1
X_15073_ _15073_/Y _15073_/A _23150_/Q VPWR VGND sg13g2_nand2_1
XFILLER_68_1741 VPWR VGND sg13g2_decap_8
X_19950_ _19950_/Y _23230_/Q _19950_/B VPWR VGND sg13g2_nand2_1
X_12285_ _13611_/A _12285_/A _12394_/B VPWR VGND sg13g2_nand2_2
XFILLER_5_787 VPWR VGND sg13g2_decap_4
X_14024_ _14024_/X _14024_/A _15186_/A _14618_/A VPWR VGND sg13g2_and3_1
XFILLER_9_1808 VPWR VGND sg13g2_decap_8
XFILLER_64_1616 VPWR VGND sg13g2_fill_1
X_19881_ _19881_/Y _20095_/A0 _19881_/A2 _19881_/B1 _20098_/A0 _19996_/B2 VPWR VGND
+ sg13g2_a221oi_1
XFILLER_4_297 VPWR VGND sg13g2_decap_8
X_18832_ _23039_/D _18832_/A _18832_/B _18832_/C VPWR VGND sg13g2_nand3_1
XFILLER_110_836 VPWR VGND sg13g2_decap_8
XFILLER_95_525 VPWR VGND sg13g2_fill_1
XFILLER_67_227 VPWR VGND sg13g2_decap_4
XFILLER_7_1543 VPWR VGND sg13g2_fill_2
XFILLER_67_238 VPWR VGND sg13g2_fill_2
X_15975_ _15976_/D _15975_/A _15975_/B _15975_/C _15975_/D VPWR VGND sg13g2_and4_1
XFILLER_7_1587 VPWR VGND sg13g2_fill_2
XFILLER_48_452 VPWR VGND sg13g2_fill_1
XFILLER_97_1414 VPWR VGND sg13g2_fill_2
XFILLER_82_208 VPWR VGND sg13g2_decap_8
XFILLER_3_1429 VPWR VGND sg13g2_decap_8
X_14926_ _14929_/B _22463_/Q _14947_/B _15103_/B1 _22922_/Q VPWR VGND sg13g2_a22oi_1
X_18694_ _18694_/Y _23017_/Q _18694_/B VPWR VGND sg13g2_xnor2_1
XFILLER_91_720 VPWR VGND sg13g2_decap_8
XFILLER_64_934 VPWR VGND sg13g2_decap_8
XFILLER_40_1660 VPWR VGND sg13g2_decap_4
XFILLER_64_945 VPWR VGND sg13g2_decap_8
XFILLER_110_1349 VPWR VGND sg13g2_decap_8
XFILLER_63_433 VPWR VGND sg13g2_decap_4
XFILLER_97_1469 VPWR VGND sg13g2_fill_1
X_17645_ _17645_/X _22558_/Q _17645_/B VPWR VGND sg13g2_xor2_1
XFILLER_91_753 VPWR VGND sg13g2_fill_2
X_14857_ _14857_/Y _14875_/A _14857_/B _14857_/C VPWR VGND sg13g2_nand3_1
XFILLER_75_1701 VPWR VGND sg13g2_decap_8
XFILLER_91_775 VPWR VGND sg13g2_fill_1
XFILLER_75_1712 VPWR VGND sg13g2_fill_2
X_13808_ _13854_/B _20304_/C _13808_/B VPWR VGND sg13g2_xnor2_1
XFILLER_95_1171 VPWR VGND sg13g2_decap_8
XFILLER_91_797 VPWR VGND sg13g2_decap_8
X_14788_ _18598_/A _14788_/A _14788_/B _14788_/C VPWR VGND sg13g2_nand3_1
XFILLER_56_1122 VPWR VGND sg13g2_decap_4
XFILLER_32_820 VPWR VGND sg13g2_fill_2
XFILLER_36_1707 VPWR VGND sg13g2_fill_1
X_13739_ _13739_/Y _13753_/A _13856_/A _13856_/B _13877_/B VPWR VGND sg13g2_nand4_1
XFILLER_17_1117 VPWR VGND sg13g2_decap_8
XFILLER_108_1267 VPWR VGND sg13g2_fill_1
XFILLER_91_1079 VPWR VGND sg13g2_decap_4
X_19246_ _19246_/Y _19240_/X _19243_/Y _19244_/Y _19245_/Y VPWR VGND sg13g2_a22oi_1
X_16458_ _16458_/Y _22593_/Q _16472_/B VPWR VGND sg13g2_nand2_1
XFILLER_31_385 VPWR VGND sg13g2_decap_8
X_19177_ _23147_/D _15034_/Y _19176_/B _19176_/Y VPWR VGND sg13g2_o21ai_1
X_16389_ _22559_/D _18657_/A _16388_/B _16388_/Y VPWR VGND sg13g2_o21ai_1
X_18059_ _18464_/A _18238_/A _18425_/B VPWR VGND sg13g2_nand2_1
XFILLER_86_1852 VPWR VGND sg13g2_fill_2
XFILLER_86_1863 VPWR VGND sg13g2_fill_1
XFILLER_86_1885 VPWR VGND sg13g2_decap_4
XFILLER_99_853 VPWR VGND sg13g2_fill_2
XFILLER_47_1858 VPWR VGND sg13g2_decap_4
XFILLER_113_652 VPWR VGND sg13g2_decap_8
X_20021_ _20021_/Y _20100_/A1 _20018_/Y _20020_/Y _20130_/B _20100_/C1 VPWR VGND sg13g2_a221oi_1
XFILLER_112_140 VPWR VGND sg13g2_decap_8
XFILLER_101_803 VPWR VGND sg13g2_fill_2
XFILLER_115_1227 VPWR VGND sg13g2_decap_8
XFILLER_100_302 VPWR VGND sg13g2_fill_2
XFILLER_98_385 VPWR VGND sg13g2_fill_2
XFILLER_55_901 VPWR VGND sg13g2_decap_8
XFILLER_39_463 VPWR VGND sg13g2_decap_8
X_21972_ _23981_/D _21972_/A0 _23981_/Q _21981_/S VPWR VGND sg13g2_mux2_1
XFILLER_67_783 VPWR VGND sg13g2_decap_8
XFILLER_6_1086 VPWR VGND sg13g2_fill_1
XFILLER_67_794 VPWR VGND sg13g2_fill_2
X_23711_ _23711_/Q _24190_/CLK _23711_/D fanout2774/X VPWR VGND sg13g2_dfrbpq_1
XFILLER_23_1891 VPWR VGND sg13g2_fill_1
XFILLER_54_433 VPWR VGND sg13g2_decap_8
XFILLER_82_753 VPWR VGND sg13g2_decap_8
XFILLER_55_967 VPWR VGND sg13g2_fill_1
XFILLER_27_669 VPWR VGND sg13g2_decap_8
XFILLER_54_455 VPWR VGND sg13g2_fill_1
XFILLER_42_606 VPWR VGND sg13g2_decap_8
XFILLER_25_14 VPWR VGND sg13g2_decap_8
X_23642_ _23642_/Q clkload57/A _23642_/D fanout2783/X VPWR VGND sg13g2_dfrbpq_1
XFILLER_93_1823 VPWR VGND sg13g2_decap_8
XFILLER_110_1894 VPWR VGND sg13g2_decap_8
XFILLER_19_1905 VPWR VGND sg13g2_decap_8
XFILLER_26_179 VPWR VGND sg13g2_fill_2
X_20854_ _23476_/D _21983_/A1 _20853_/B _20853_/Y VPWR VGND sg13g2_o21ai_1
XFILLER_58_1954 VPWR VGND sg13g2_fill_1
XFILLER_25_58 VPWR VGND sg13g2_fill_1
XFILLER_35_691 VPWR VGND sg13g2_fill_1
X_23573_ _23573_/Q clkload52/A _23573_/D fanout2756/X VPWR VGND sg13g2_dfrbpq_1
X_20785_ _23444_/D _21983_/A1 _20784_/B _20784_/Y VPWR VGND sg13g2_o21ai_1
XFILLER_22_341 VPWR VGND sg13g2_decap_8
XFILLER_70_1108 VPWR VGND sg13g2_fill_1
X_22524_ _22524_/Q clkload6/A _22524_/D fanout2834/X VPWR VGND sg13g2_dfrbpq_1
XFILLER_91_1580 VPWR VGND sg13g2_decap_4
XFILLER_17_1651 VPWR VGND sg13g2_decap_8
XFILLER_52_1564 VPWR VGND sg13g2_fill_2
XFILLER_104_1632 VPWR VGND sg13g2_decap_8
XFILLER_17_1684 VPWR VGND sg13g2_fill_1
XFILLER_10_558 VPWR VGND sg13g2_fill_1
X_22455_ _22455_/Q clkload28/A _22455_/D fanout2855/X VPWR VGND sg13g2_dfrbpq_1
XFILLER_100_1507 VPWR VGND sg13g2_fill_1
XFILLER_13_1559 VPWR VGND sg13g2_decap_8
X_21406_ _21406_/Y _21406_/A _21406_/B VPWR VGND sg13g2_nand2_1
XFILLER_104_1687 VPWR VGND sg13g2_fill_1
XFILLER_30_1862 VPWR VGND sg13g2_decap_8
X_24125_ _24125_/Q clkload44/A _24125_/D fanout2746/X VPWR VGND sg13g2_dfrbpq_1
X_21337_ _21337_/Y _21337_/A _21337_/B VPWR VGND sg13g2_nand2_1
XFILLER_65_1903 VPWR VGND sg13g2_fill_1
X_12070_ _12092_/A _12111_/B VPWR VGND sg13g2_inv_1
X_24056_ _24056_/Q clkload46/A _24056_/D fanout2687/X VPWR VGND sg13g2_dfrbpq_1
Xfanout2705 fanout2705/X fanout2706/X VPWR VGND sg13g2_buf_1
Xfanout2716 fanout2716/X fanout2717/X VPWR VGND sg13g2_buf_1
Xfanout2727 fanout2727/X fanout2728/X VPWR VGND sg13g2_buf_1
XFILLER_104_652 VPWR VGND sg13g2_fill_1
XFILLER_26_1909 VPWR VGND sg13g2_decap_4
Xfanout2738 fanout2738/X fanout2741/X VPWR VGND sg13g2_buf_1
XFILLER_2_779 VPWR VGND sg13g2_fill_1
X_23007_ _23007_/Q _23029_/CLK _23007_/D fanout2850/X VPWR VGND sg13g2_dfrbpq_1
Xfanout2749 fanout2749/X fanout2750/X VPWR VGND sg13g2_buf_1
XFILLER_81_1237 VPWR VGND sg13g2_decap_4
XFILLER_89_385 VPWR VGND sg13g2_decap_8
XFILLER_1_278 VPWR VGND sg13g2_fill_2
X_21199_ _21199_/Y _23623_/Q _21205_/B VPWR VGND sg13g2_nand2_1
XFILLER_103_173 VPWR VGND sg13g2_fill_2
XFILLER_49_249 VPWR VGND sg13g2_decap_8
XFILLER_63_1682 VPWR VGND sg13g2_fill_1
XFILLER_8_1874 VPWR VGND sg13g2_decap_8
XFILLER_65_709 VPWR VGND sg13g2_fill_2
XFILLER_24_1655 VPWR VGND sg13g2_fill_2
XFILLER_92_517 VPWR VGND sg13g2_fill_1
XFILLER_44_1092 VPWR VGND sg13g2_decap_8
X_15760_ _16148_/A _20179_/A _15963_/B VPWR VGND sg13g2_nor2_1
XFILLER_20_1508 VPWR VGND sg13g2_decap_8
X_12972_ _12972_/X _24038_/Q _24102_/Q _12974_/A VPWR VGND sg13g2_mux2_1
XFILLER_92_539 VPWR VGND sg13g2_decap_8
XFILLER_46_934 VPWR VGND sg13g2_decap_8
XFILLER_57_271 VPWR VGND sg13g2_fill_1
XFILLER_73_720 VPWR VGND sg13g2_decap_8
XFILLER_98_1756 VPWR VGND sg13g2_fill_2
XFILLER_85_591 VPWR VGND sg13g2_decap_8
X_11923_ _11923_/X _23834_/Q _23866_/Q _23930_/Q _23962_/Q _11923_/S0 _12171_/S1 VPWR
+ VGND sg13g2_mux4_1
XFILLER_98_1767 VPWR VGND sg13g2_fill_2
XFILLER_17_124 VPWR VGND sg13g2_decap_4
X_14711_ _14711_/Y _14711_/A1 _14710_/B _14710_/Y VPWR VGND sg13g2_o21ai_1
XFILLER_59_1718 VPWR VGND sg13g2_decap_8
X_23909_ _23909_/Q clkload37/A _23909_/D fanout2713/X VPWR VGND sg13g2_dfrbpq_1
X_15691_ _15693_/A _15690_/A _15785_/B _15690_/Y VPWR VGND sg13g2_a21oi_1
XFILLER_17_146 VPWR VGND sg13g2_decap_8
XFILLER_72_230 VPWR VGND sg13g2_decap_8
XFILLER_73_764 VPWR VGND sg13g2_decap_8
X_14642_ _14642_/Y _14642_/A _14642_/B VPWR VGND sg13g2_nor2_1
X_17430_ _17430_/Y _22835_/Q _17432_/S VPWR VGND sg13g2_nand2_1
XFILLER_61_926 VPWR VGND sg13g2_decap_4
X_11854_ _11857_/C _11854_/A _11854_/B VPWR VGND sg13g2_nor2_1
XFILLER_60_414 VPWR VGND sg13g2_decap_8
XFILLER_73_797 VPWR VGND sg13g2_decap_8
XFILLER_61_948 VPWR VGND sg13g2_fill_2
XFILLER_109_1510 VPWR VGND sg13g2_fill_2
XFILLER_82_64 VPWR VGND sg13g2_decap_8
XFILLER_14_853 VPWR VGND sg13g2_decap_8
X_17361_ _22807_/D _16500_/Y _17367_/B _17360_/Y VPWR VGND sg13g2_o21ai_1
X_14573_ _24219_/D _14596_/B _14573_/B VPWR VGND sg13g2_nor2_1
XFILLER_72_1918 VPWR VGND sg13g2_decap_8
XFILLER_109_1565 VPWR VGND sg13g2_fill_1
X_19100_ _19100_/X _18962_/A _23118_/Q _19114_/S VPWR VGND sg13g2_mux2_1
XFILLER_57_1497 VPWR VGND sg13g2_decap_4
X_16312_ _16316_/A _16323_/C _16311_/B _16323_/B VPWR VGND sg13g2_a21oi_1
X_17292_ _22775_/D _16500_/Y _17291_/B _17291_/Y VPWR VGND sg13g2_o21ai_1
XFILLER_15_91 VPWR VGND sg13g2_fill_1
XFILLER_9_334 VPWR VGND sg13g2_decap_8
XFILLER_70_1642 VPWR VGND sg13g2_fill_1
X_16243_ _16243_/X _16243_/A _16253_/C VPWR VGND sg13g2_xor2_1
X_19031_ _19032_/B _19030_/Y _23060_/Q _19045_/C VPWR VGND sg13g2_mux2_1
XFILLER_51_1041 VPWR VGND sg13g2_decap_8
X_13455_ _13455_/X _24173_/Q _24205_/Q _23245_/Q _23277_/Q _13133_/A _13635_/S1 VPWR
+ VGND sg13g2_mux4_1
XFILLER_16_1194 VPWR VGND sg13g2_decap_8
X_12406_ _12406_/Y _12406_/A _12406_/B VPWR VGND sg13g2_nand2_1
XFILLER_51_1085 VPWR VGND sg13g2_decap_4
XFILLER_12_1047 VPWR VGND sg13g2_fill_2
X_13386_ _13387_/B _23852_/Q _23884_/Q _23948_/Q _23980_/Q _13551_/S0 _13398_/S VPWR
+ VGND sg13g2_mux4_1
XFILLER_63_7 VPWR VGND sg13g2_decap_8
X_15125_ _24230_/D _18567_/B _15126_/B _15123_/Y _15124_/Y VPWR VGND sg13g2_a22oi_1
XFILLER_114_438 VPWR VGND sg13g2_decap_8
X_19933_ _19933_/Y _19757_/A _19581_/Y _19932_/X VPWR VGND sg13g2_a21oi_1
X_15056_ _15057_/B _22476_/Q _15006_/B _14966_/B VPWR VGND sg13g2_a21oi_1
X_12268_ _12278_/A _12340_/C _12350_/C VPWR VGND sg13g2_nor2_1
X_14007_ _14008_/D _14002_/Y _13743_/Y _14006_/B _13530_/Y _13434_/A VPWR VGND sg13g2_a221oi_1
XFILLER_9_1638 VPWR VGND sg13g2_decap_8
X_11219_ _11219_/Y _23192_/Q _23191_/Q VPWR VGND sg13g2_nor2_2
XFILLER_29_1566 VPWR VGND sg13g2_fill_1
XFILLER_64_1446 VPWR VGND sg13g2_fill_1
XFILLER_68_503 VPWR VGND sg13g2_decap_8
X_19864_ _19880_/B _14340_/A _19862_/Y _19863_/Y _19861_/B _15490_/Y VPWR VGND sg13g2_a221oi_1
X_12199_ _12199_/Y _13706_/S _12198_/X _13191_/B1 VPWR VGND sg13g2_o21ai_1
XFILLER_81_1760 VPWR VGND sg13g2_fill_1
XFILLER_42_1711 VPWR VGND sg13g2_decap_4
X_18815_ _18820_/A _23037_/Q _18827_/B _18821_/C VPWR VGND sg13g2_nand3_1
XFILLER_96_867 VPWR VGND sg13g2_decap_8
XFILLER_95_344 VPWR VGND sg13g2_decap_4
XFILLER_7_1340 VPWR VGND sg13g2_fill_2
XFILLER_110_655 VPWR VGND sg13g2_decap_8
X_19795_ _19795_/Y _19702_/A _19566_/B _19794_/Y VPWR VGND sg13g2_a21oi_1
XFILLER_95_377 VPWR VGND sg13g2_decap_4
XFILLER_55_208 VPWR VGND sg13g2_decap_8
X_18746_ _18753_/B _23027_/Q _18750_/C VPWR VGND sg13g2_nand2_1
XFILLER_110_1102 VPWR VGND sg13g2_decap_8
X_15958_ _15958_/Y _16025_/A _16193_/A VPWR VGND sg13g2_nor2_1
XFILLER_36_411 VPWR VGND sg13g2_decap_8
XFILLER_49_794 VPWR VGND sg13g2_decap_8
XFILLER_48_282 VPWR VGND sg13g2_decap_8
X_14909_ _16263_/A _16257_/A _16257_/B _14908_/Y VPWR VGND sg13g2_o21ai_1
X_18677_ _23013_/D _18677_/A _18677_/B VPWR VGND sg13g2_nor2_1
XFILLER_97_1266 VPWR VGND sg13g2_fill_1
X_15889_ _16181_/A _23023_/Q _22573_/Q _15889_/S VPWR VGND sg13g2_mux2_1
XFILLER_36_455 VPWR VGND sg13g2_decap_8
XFILLER_64_775 VPWR VGND sg13g2_fill_1
XFILLER_24_617 VPWR VGND sg13g2_fill_1
XFILLER_36_477 VPWR VGND sg13g2_decap_8
X_17628_ _17628_/Y _17628_/A _17628_/B VPWR VGND sg13g2_nand2_1
XFILLER_63_263 VPWR VGND sg13g2_decap_8
XFILLER_91_594 VPWR VGND sg13g2_decap_8
XFILLER_23_116 VPWR VGND sg13g2_fill_2
XFILLER_51_436 VPWR VGND sg13g2_fill_2
XFILLER_32_672 VPWR VGND sg13g2_decap_8
X_20570_ _23340_/D _20702_/A1 _20581_/B _20569_/Y VPWR VGND sg13g2_o21ai_1
XFILLER_20_834 VPWR VGND sg13g2_fill_2
XFILLER_32_694 VPWR VGND sg13g2_fill_2
XFILLER_14_1802 VPWR VGND sg13g2_decap_8
X_19229_ _23183_/D _24272_/A _23183_/Q _19229_/S VPWR VGND sg13g2_mux2_1
XFILLER_88_1914 VPWR VGND sg13g2_decap_4
X_22240_ _24109_/D _22373_/A1 _24109_/Q _22243_/S VPWR VGND sg13g2_mux2_1
XFILLER_34_1294 VPWR VGND sg13g2_decap_4
XFILLER_14_1879 VPWR VGND sg13g2_decap_8
XFILLER_30_1136 VPWR VGND sg13g2_fill_1
XFILLER_69_1346 VPWR VGND sg13g2_fill_2
X_22171_ _24075_/D _20217_/Y _22184_/B _22170_/Y VPWR VGND sg13g2_o21ai_1
Xhold4802 _20928_/A _23510_/Q VPWR VGND sg13g2_dlygate4sd3_1
Xhold4813 _17453_/A _22845_/Q VPWR VGND sg13g2_dlygate4sd3_1
Xhold4824 _21104_/A _23578_/Q VPWR VGND sg13g2_dlygate4sd3_1
Xhold4835 _22348_/A _24161_/Q VPWR VGND sg13g2_dlygate4sd3_1
X_21122_ _23586_/D _21323_/A1 _21121_/B _21121_/Y VPWR VGND sg13g2_o21ai_1
Xhold4846 _21660_/A _23843_/Q VPWR VGND sg13g2_dlygate4sd3_1
Xhold4857 _21953_/A _23971_/Q VPWR VGND sg13g2_dlygate4sd3_1
Xhold4868 _20052_/A _23234_/Q VPWR VGND sg13g2_dlygate4sd3_1
Xhold4879 _22374_/A _24174_/Q VPWR VGND sg13g2_dlygate4sd3_1
XFILLER_101_600 VPWR VGND sg13g2_decap_8
XFILLER_99_672 VPWR VGND sg13g2_fill_2
XFILLER_47_1666 VPWR VGND sg13g2_fill_1
XFILLER_115_1002 VPWR VGND sg13g2_decap_8
XFILLER_99_683 VPWR VGND sg13g2_decap_8
XFILLER_87_845 VPWR VGND sg13g2_fill_1
X_20004_ _20004_/Y _20030_/S _20004_/B VPWR VGND sg13g2_nor2_1
XFILLER_8_1159 VPWR VGND sg13g2_decap_4
XFILLER_47_709 VPWR VGND sg13g2_decap_4
XFILLER_80_1270 VPWR VGND sg13g2_decap_8
XFILLER_115_1079 VPWR VGND sg13g2_decap_8
XFILLER_28_912 VPWR VGND sg13g2_fill_1
XFILLER_41_1243 VPWR VGND sg13g2_decap_4
XFILLER_74_528 VPWR VGND sg13g2_decap_8
XFILLER_112_1945 VPWR VGND sg13g2_decap_8
XFILLER_21_1839 VPWR VGND sg13g2_fill_1
XFILLER_36_13 VPWR VGND sg13g2_fill_1
XFILLER_27_444 VPWR VGND sg13g2_fill_2
XFILLER_28_967 VPWR VGND sg13g2_decap_8
X_21955_ _21955_/Y _21955_/A _21961_/B VPWR VGND sg13g2_nand2_1
XFILLER_28_978 VPWR VGND sg13g2_fill_1
XFILLER_3_1771 VPWR VGND sg13g2_decap_8
XFILLER_28_989 VPWR VGND sg13g2_fill_2
XFILLER_43_926 VPWR VGND sg13g2_fill_2
XFILLER_54_252 VPWR VGND sg13g2_fill_1
XFILLER_27_477 VPWR VGND sg13g2_decap_8
X_20906_ _23499_/D _21969_/A1 _20913_/B _20905_/Y VPWR VGND sg13g2_o21ai_1
XFILLER_27_488 VPWR VGND sg13g2_fill_2
XFILLER_42_414 VPWR VGND sg13g2_fill_2
XFILLER_15_639 VPWR VGND sg13g2_decap_4
XFILLER_43_948 VPWR VGND sg13g2_decap_4
X_21886_ _23938_/D _21952_/A1 _21885_/B _21885_/Y VPWR VGND sg13g2_o21ai_1
X_23625_ _23625_/Q clkload47/A _23625_/D fanout2680/X VPWR VGND sg13g2_dfrbpq_1
XFILLER_39_1150 VPWR VGND sg13g2_fill_1
XFILLER_19_1735 VPWR VGND sg13g2_decap_4
XFILLER_14_149 VPWR VGND sg13g2_decap_8
X_20837_ _20837_/Y _20837_/A _20841_/B VPWR VGND sg13g2_nand2_1
XFILLER_35_1014 VPWR VGND sg13g2_decap_8
XFILLER_19_1768 VPWR VGND sg13g2_decap_8
XFILLER_19_1779 VPWR VGND sg13g2_fill_2
X_23556_ _23556_/Q clkload37/A _23556_/D fanout2713/X VPWR VGND sg13g2_dfrbpq_1
X_20768_ _20768_/Y _23434_/Q _20768_/B VPWR VGND sg13g2_nand2_1
XFILLER_35_1047 VPWR VGND sg13g2_decap_4
XFILLER_74_1096 VPWR VGND sg13g2_decap_8
X_22507_ _22507_/Q _22941_/CLK _22507_/D fanout2802/X VPWR VGND sg13g2_dfrbpq_1
XFILLER_22_193 VPWR VGND sg13g2_decap_8
X_23487_ _23487_/Q clkload40/A _23487_/D fanout2736/X VPWR VGND sg13g2_dfrbpq_1
XFILLER_11_889 VPWR VGND sg13g2_decap_8
X_20699_ _20699_/Y _23403_/Q _20713_/B VPWR VGND sg13g2_nand2_1
XFILLER_108_210 VPWR VGND sg13g2_decap_8
XFILLER_7_849 VPWR VGND sg13g2_fill_1
X_13240_ _13240_/X _23722_/Q _23754_/Q _23786_/Q _23818_/Q _12921_/S _13242_/S1 VPWR
+ VGND sg13g2_mux4_1
X_22438_ _22438_/Y _22438_/A _22444_/B VPWR VGND sg13g2_nand2_1
XFILLER_10_399 VPWR VGND sg13g2_fill_1
XFILLER_6_359 VPWR VGND sg13g2_fill_2
XFILLER_87_1435 VPWR VGND sg13g2_fill_2
X_13171_ _13171_/X _23721_/Q _23753_/Q _23785_/Q _23817_/Q _13166_/B _13765_/S1 VPWR
+ VGND sg13g2_mux4_1
X_22369_ _22369_/Y _22369_/A _22377_/B VPWR VGND sg13g2_nand2_1
X_12122_ _12122_/Y _13266_/A1 _12120_/X _12121_/X _11477_/X _12674_/C VPWR VGND sg13g2_a221oi_1
X_24108_ _24108_/Q _24210_/CLK _24108_/D fanout2642/X VPWR VGND sg13g2_dfrbpq_1
XFILLER_11_1091 VPWR VGND sg13g2_decap_8
XFILLER_105_950 VPWR VGND sg13g2_fill_2
XFILLER_46_1110 VPWR VGND sg13g2_decap_8
XFILLER_65_1755 VPWR VGND sg13g2_fill_1
XFILLER_105_983 VPWR VGND sg13g2_fill_1
X_16930_ _16930_/Y _22696_/Q _16930_/B VPWR VGND sg13g2_xnor2_1
X_24039_ _24039_/Q _24170_/CLK _24039_/D fanout2708/X VPWR VGND sg13g2_dfrbpq_1
X_12053_ _12065_/B _12047_/X _12048_/Y _12052_/X VPWR VGND sg13g2_o21ai_1
XFILLER_89_160 VPWR VGND sg13g2_decap_8
XFILLER_77_31 VPWR VGND sg13g2_fill_2
XFILLER_46_1154 VPWR VGND sg13g2_decap_8
XFILLER_81_1045 VPWR VGND sg13g2_fill_1
XFILLER_61_1619 VPWR VGND sg13g2_decap_4
XFILLER_65_1799 VPWR VGND sg13g2_fill_1
XFILLER_77_64 VPWR VGND sg13g2_fill_1
XFILLER_93_815 VPWR VGND sg13g2_decap_8
X_18600_ _18600_/Y _16233_/B _14475_/B _16231_/B _18599_/Y VPWR VGND sg13g2_a22oi_1
XFILLER_77_366 VPWR VGND sg13g2_decap_4
XFILLER_37_208 VPWR VGND sg13g2_fill_2
XFILLER_65_517 VPWR VGND sg13g2_decap_8
X_15812_ _15812_/Y _22738_/Q _15901_/A2 _15901_/B1 _22674_/Q VPWR VGND sg13g2_a22oi_1
X_19580_ _19580_/Y _19638_/S _19580_/B VPWR VGND sg13g2_nor2_1
XFILLER_8_1693 VPWR VGND sg13g2_decap_8
X_18531_ _18531_/Y _18531_/A _18531_/B _18531_/C _18531_/D VPWR VGND sg13g2_nand4_1
X_15743_ _15745_/C _22859_/Q _15966_/B1 _16004_/B1 _22824_/Q VPWR VGND sg13g2_a22oi_1
X_12955_ _12955_/X _12955_/A _13098_/A VPWR VGND sg13g2_and2_1
XFILLER_92_369 VPWR VGND sg13g2_decap_8
XFILLER_45_230 VPWR VGND sg13g2_fill_1
XFILLER_111_1477 VPWR VGND sg13g2_decap_8
XFILLER_19_989 VPWR VGND sg13g2_fill_1
XFILLER_18_466 VPWR VGND sg13g2_fill_1
X_11906_ _11906_/Y _23674_/Q _12239_/S VPWR VGND sg13g2_nand2b_1
XFILLER_34_926 VPWR VGND sg13g2_decap_8
XFILLER_94_1439 VPWR VGND sg13g2_decap_8
X_18462_ _18822_/B _19124_/A1 _23070_/Q _18462_/S VPWR VGND sg13g2_mux2_1
XFILLER_34_948 VPWR VGND sg13g2_fill_1
X_15674_ _15674_/X _17135_/A _22466_/Q _15694_/S VPWR VGND sg13g2_mux2_1
X_12886_ _12886_/Y _11953_/A _12883_/Y _12885_/Y _11954_/Y VPWR VGND sg13g2_a22oi_1
XFILLER_34_959 VPWR VGND sg13g2_fill_1
XFILLER_37_1802 VPWR VGND sg13g2_decap_4
XFILLER_45_296 VPWR VGND sg13g2_decap_4
XFILLER_60_222 VPWR VGND sg13g2_decap_8
X_17413_ _22825_/D _16150_/A _17412_/B _17412_/Y VPWR VGND sg13g2_o21ai_1
XFILLER_61_756 VPWR VGND sg13g2_decap_4
X_14625_ _14625_/Y _14631_/B _14625_/B VPWR VGND sg13g2_nand2_1
XFILLER_33_458 VPWR VGND sg13g2_decap_8
X_11837_ _11837_/Y _11904_/B _23225_/Q _11836_/Y VPWR VGND sg13g2_o21ai_1
X_18393_ _18403_/B _17968_/B _18797_/B _18393_/S VPWR VGND sg13g2_mux2_1
XFILLER_18_1223 VPWR VGND sg13g2_decap_4
XFILLER_57_1283 VPWR VGND sg13g2_decap_8
X_17344_ _22799_/D _17480_/A1 _17371_/S _17343_/Y VPWR VGND sg13g2_o21ai_1
Xplace4108 _14321_/A _22992_/Q VPWR VGND sg13g2_buf_1
XFILLER_60_288 VPWR VGND sg13g2_decap_8
XFILLER_72_1748 VPWR VGND sg13g2_fill_1
X_11768_ _11768_/X _23704_/Q _23736_/Q _23768_/Q _23800_/Q _11768_/S0 _11768_/S1 VPWR
+ VGND sg13g2_mux4_1
Xplace4119 _12674_/C _13960_/S1 VPWR VGND sg13g2_buf_2
XFILLER_13_193 VPWR VGND sg13g2_decap_8
Xplace3407 _17367_/B _17358_/B VPWR VGND sg13g2_buf_1
X_13507_ _13519_/B _13520_/B _15839_/A _13520_/A VPWR VGND sg13g2_o21ai_1
X_14487_ _14491_/A _22606_/Q _23017_/Q VPWR VGND sg13g2_xor2_1
Xplace3418 _17298_/B _17266_/B VPWR VGND sg13g2_buf_1
X_17275_ _22767_/D _17480_/A1 _17291_/B _17274_/Y VPWR VGND sg13g2_o21ai_1
X_11699_ _11699_/X _23256_/Q _23384_/Q _11699_/S VPWR VGND sg13g2_mux2_1
Xplace3429 _17869_/A _17517_/C VPWR VGND sg13g2_buf_1
XFILLER_35_1592 VPWR VGND sg13g2_decap_8
X_19014_ _19014_/Y _19047_/A _23090_/Q _19047_/C VPWR VGND sg13g2_nand3_1
X_16226_ _22515_/D _16226_/A VPWR VGND sg13g2_inv_1
X_13438_ _13438_/Y _13379_/B _13379_/A _13437_/Y VPWR VGND sg13g2_o21ai_1
X_16157_ _16157_/Y _22503_/Q _16156_/B _16156_/Y VPWR VGND sg13g2_a21oi_1
XFILLER_31_1489 VPWR VGND sg13g2_fill_1
X_13369_ _13370_/C _13861_/A _19423_/A _20179_/B VPWR VGND sg13g2_nand3_1
XFILLER_115_747 VPWR VGND sg13g2_decap_8
XFILLER_114_224 VPWR VGND sg13g2_decap_8
X_15108_ _18753_/A _15108_/A _15108_/B VPWR VGND sg13g2_or2_2
X_16088_ _22491_/D _15548_/B _16083_/Y _17382_/A VPWR VGND sg13g2_mux2_1
XFILLER_88_609 VPWR VGND sg13g2_fill_1
XFILLER_83_1822 VPWR VGND sg13g2_decap_8
X_19916_ _19916_/Y _20071_/A _19916_/B VPWR VGND sg13g2_nand2_1
X_15039_ _15040_/B _17905_/A1 _15107_/A2 _15070_/B VPWR VGND sg13g2_o21ai_1
XFILLER_69_812 VPWR VGND sg13g2_fill_1
X_19847_ _19847_/Y _20343_/A3 _19881_/A2 _19881_/B1 _20343_/A1 _19996_/B2 VPWR VGND
+ sg13g2_a221oi_1
XFILLER_60_1118 VPWR VGND sg13g2_fill_2
XFILLER_29_709 VPWR VGND sg13g2_decap_8
XFILLER_84_826 VPWR VGND sg13g2_fill_1
X_19778_ _19778_/Y _19778_/A _19778_/B _19778_/C _19778_/D VPWR VGND sg13g2_nor4_1
XFILLER_49_580 VPWR VGND sg13g2_decap_4
X_18729_ _18730_/B _18729_/A _18729_/B VPWR VGND sg13g2_nor2_1
XFILLER_0_1900 VPWR VGND sg13g2_decap_8
XFILLER_36_241 VPWR VGND sg13g2_decap_8
XFILLER_92_870 VPWR VGND sg13g2_decap_8
XFILLER_64_561 VPWR VGND sg13g2_fill_1
XFILLER_20_1861 VPWR VGND sg13g2_decap_8
XFILLER_37_786 VPWR VGND sg13g2_fill_1
XFILLER_77_1648 VPWR VGND sg13g2_decap_8
XFILLER_58_1058 VPWR VGND sg13g2_fill_2
XFILLER_52_789 VPWR VGND sg13g2_fill_2
X_23410_ _23410_/Q _24212_/CLK _23410_/D fanout2633/X VPWR VGND sg13g2_dfrbpq_1
X_20622_ _20622_/Y _20622_/A _20624_/B VPWR VGND sg13g2_nand2_1
XFILLER_16_1919 VPWR VGND sg13g2_decap_8
XFILLER_32_1209 VPWR VGND sg13g2_decap_8
X_23341_ _23341_/Q clkload31/A _23341_/D fanout2646/X VPWR VGND sg13g2_dfrbpq_1
XFILLER_36_1389 VPWR VGND sg13g2_decap_8
X_20553_ _20553_/Y _23332_/Q _20565_/B VPWR VGND sg13g2_nand2_1
XFILLER_18_1790 VPWR VGND sg13g2_decap_8
Xplace3930 _13624_/A _11355_/Y VPWR VGND sg13g2_buf_1
XFILLER_101_1613 VPWR VGND sg13g2_fill_1
Xplace3941 _13419_/A _11754_/B1 VPWR VGND sg13g2_buf_1
X_23272_ _23272_/Q clkload32/A _23272_/D fanout2647/X VPWR VGND sg13g2_dfrbpq_1
X_20484_ _20484_/Y _20484_/A _20500_/B VPWR VGND sg13g2_nand2_1
Xplace3952 _19881_/B1 _19505_/Y VPWR VGND sg13g2_buf_1
Xplace3963 _14982_/S _15082_/A VPWR VGND sg13g2_buf_1
XFILLER_4_819 VPWR VGND sg13g2_fill_2
Xplace3974 _13552_/A _12674_/Y VPWR VGND sg13g2_buf_2
X_22223_ _22223_/Y _24100_/Q _22243_/S VPWR VGND sg13g2_nand2_1
Xplace3985 _12145_/A place3986/A VPWR VGND sg13g2_buf_1
Xplace3996 _12475_/A _11707_/A VPWR VGND sg13g2_buf_2
XFILLER_84_1608 VPWR VGND sg13g2_fill_2
XFILLER_69_1165 VPWR VGND sg13g2_decap_8
X_22154_ _22154_/Y _22154_/A _22168_/B VPWR VGND sg13g2_nand2_1
Xhold4643 _17339_/A _22797_/Q VPWR VGND sg13g2_dlygate4sd3_1
Xhold4654 _17317_/A _22787_/Q VPWR VGND sg13g2_dlygate4sd3_1
Xhold4665 _17443_/A _22840_/Q VPWR VGND sg13g2_dlygate4sd3_1
X_21105_ _23578_/D _21305_/A1 _21108_/B _21104_/Y VPWR VGND sg13g2_o21ai_1
Xhold4676 _17313_/A _22785_/Q VPWR VGND sg13g2_dlygate4sd3_1
X_22085_ _24034_/D _22286_/A1 _22084_/B _22084_/Y VPWR VGND sg13g2_o21ai_1
Xhold4687 _17335_/A _22795_/Q VPWR VGND sg13g2_dlygate4sd3_1
Xhold4698 _18105_/A _22948_/Q VPWR VGND sg13g2_dlygate4sd3_1
XFILLER_82_1376 VPWR VGND sg13g2_fill_2
X_21036_ _23553_/D _22284_/A1 _21042_/B _21035_/Y VPWR VGND sg13g2_o21ai_1
XFILLER_87_664 VPWR VGND sg13g2_decap_8
XFILLER_87_675 VPWR VGND sg13g2_fill_1
XFILLER_47_506 VPWR VGND sg13g2_fill_1
XFILLER_87_686 VPWR VGND sg13g2_fill_1
XFILLER_5_1833 VPWR VGND sg13g2_decap_8
XFILLER_25_1761 VPWR VGND sg13g2_decap_8
XFILLER_59_388 VPWR VGND sg13g2_fill_2
XFILLER_74_314 VPWR VGND sg13g2_decap_8
XFILLER_21_1614 VPWR VGND sg13g2_fill_2
XFILLER_41_1040 VPWR VGND sg13g2_decap_4
XFILLER_74_325 VPWR VGND sg13g2_decap_8
XFILLER_112_1742 VPWR VGND sg13g2_fill_1
XFILLER_25_1794 VPWR VGND sg13g2_decap_8
XFILLER_60_1696 VPWR VGND sg13g2_decap_8
XFILLER_112_1775 VPWR VGND sg13g2_fill_2
X_22987_ _22987_/Q _24212_/CLK _22987_/D fanout2919/X VPWR VGND sg13g2_dfrbpq_2
XFILLER_21_1669 VPWR VGND sg13g2_decap_8
X_12740_ _12745_/C _12740_/A _12740_/B VPWR VGND sg13g2_nor2_1
XFILLER_27_263 VPWR VGND sg13g2_decap_4
X_21938_ _23964_/D _21938_/A1 _21942_/B _21937_/Y VPWR VGND sg13g2_o21ai_1
XFILLER_43_723 VPWR VGND sg13g2_fill_2
XFILLER_42_211 VPWR VGND sg13g2_decap_4
XFILLER_103_84 VPWR VGND sg13g2_decap_8
XFILLER_15_436 VPWR VGND sg13g2_decap_4
XFILLER_63_44 VPWR VGND sg13g2_fill_1
XFILLER_70_531 VPWR VGND sg13g2_fill_2
XFILLER_15_447 VPWR VGND sg13g2_fill_2
X_21869_ _21869_/Y _23931_/Q _21869_/B VPWR VGND sg13g2_nand2_1
XFILLER_93_1450 VPWR VGND sg13g2_decap_8
XFILLER_31_929 VPWR VGND sg13g2_decap_8
XFILLER_43_789 VPWR VGND sg13g2_decap_8
XFILLER_58_1581 VPWR VGND sg13g2_fill_2
XFILLER_70_575 VPWR VGND sg13g2_decap_8
X_23608_ _23608_/Q clkload57/A _23608_/D fanout2763/X VPWR VGND sg13g2_dfrbpq_1
XFILLER_93_1483 VPWR VGND sg13g2_decap_8
XFILLER_42_277 VPWR VGND sg13g2_decap_4
X_11622_ _14116_/B _14274_/A _14118_/A _14118_/C VPWR VGND sg13g2_nand3_1
XFILLER_30_428 VPWR VGND sg13g2_decap_8
XFILLER_15_1407 VPWR VGND sg13g2_fill_1
XFILLER_11_620 VPWR VGND sg13g2_decap_8
XFILLER_19_1587 VPWR VGND sg13g2_fill_1
X_14341_ _14342_/D _14438_/C _14341_/B VPWR VGND sg13g2_nand2b_1
X_23539_ _23539_/Q clkload51/A _23539_/D fanout2666/X VPWR VGND sg13g2_dfrbpq_1
XFILLER_10_130 VPWR VGND sg13g2_decap_8
Xclkbuf_3_4_0_clk_i clkbuf_3_4_0_clk_i/X clkbuf_0_clk_i/X VPWR VGND sg13g2_buf_16
XFILLER_7_624 VPWR VGND sg13g2_fill_1
X_14272_ _14272_/Y _14758_/B _16856_/B _14272_/C VPWR VGND sg13g2_nor3_1
X_11484_ _11484_/X _12788_/A _12577_/B VPWR VGND sg13g2_and2_2
XFILLER_109_552 VPWR VGND sg13g2_decap_8
X_16011_ _16016_/B _16011_/A _16011_/B VPWR VGND sg13g2_nor2_1
X_13223_ _13223_/Y _14045_/A VPWR VGND sg13g2_inv_1
XFILLER_100_1145 VPWR VGND sg13g2_decap_8
X_13154_ _14060_/B _14045_/A _14047_/A VPWR VGND sg13g2_nor2_1
XFILLER_88_41 VPWR VGND sg13g2_fill_1
XFILLER_48_1238 VPWR VGND sg13g2_decap_4
XFILLER_98_929 VPWR VGND sg13g2_decap_8
X_12105_ _12105_/Y _12340_/A _12102_/Y _12104_/Y VPWR VGND sg13g2_o21ai_1
X_17962_ _17962_/Y _18463_/S _17962_/B VPWR VGND sg13g2_nand2_1
X_13085_ _13085_/Y _12623_/B _12623_/A _13081_/Y _13082_/Y _13083_/Y VPWR VGND sg13g2_a221oi_1
XFILLER_111_238 VPWR VGND sg13g2_decap_8
X_19701_ _19869_/B _19714_/S _19571_/X _19700_/Y VPWR VGND sg13g2_a21oi_1
X_16913_ _16914_/A _22692_/Q VPWR VGND sg13g2_inv_1
XFILLER_6_1608 VPWR VGND sg13g2_decap_4
XFILLER_2_395 VPWR VGND sg13g2_fill_1
X_12036_ _12036_/X _11442_/A _12413_/B _22554_/Q VPWR VGND sg13g2_a21o_1
X_17893_ _17895_/A _17893_/A1 _17929_/A2 _17920_/B1 _17158_/A VPWR VGND sg13g2_a22oi_1
X_19632_ _23222_/D _19857_/B _19628_/Y _19631_/Y VPWR VGND sg13g2_o21ai_1
X_16844_ _16849_/B _22681_/Q _22680_/Q _22679_/Q _16844_/D VPWR VGND sg13g2_nand4_1
XFILLER_78_1902 VPWR VGND sg13g2_fill_2
XFILLER_19_731 VPWR VGND sg13g2_decap_8
XFILLER_24_1271 VPWR VGND sg13g2_fill_1
X_19563_ _19563_/Y _19366_/Y _19563_/B VPWR VGND sg13g2_nand2b_1
XFILLER_92_144 VPWR VGND sg13g2_fill_1
XFILLER_81_807 VPWR VGND sg13g2_decap_8
XFILLER_78_1935 VPWR VGND sg13g2_decap_8
X_13987_ _13987_/Y _22579_/Q _13987_/B VPWR VGND sg13g2_nand2b_1
XFILLER_111_1263 VPWR VGND sg13g2_decap_4
XFILLER_46_561 VPWR VGND sg13g2_decap_8
XFILLER_20_1157 VPWR VGND sg13g2_fill_2
X_18514_ _18514_/Y _18514_/A VPWR VGND sg13g2_inv_1
XFILLER_46_572 VPWR VGND sg13g2_fill_1
X_15726_ _15726_/Y _15726_/A _15726_/B _15726_/C _15726_/D VPWR VGND sg13g2_nand4_1
X_12938_ _12939_/D _13520_/A _20087_/B _13748_/A _13748_/B VPWR VGND sg13g2_nand4_1
X_19494_ _19495_/C _19494_/A _19494_/B VPWR VGND sg13g2_nor2_1
XFILLER_94_1236 VPWR VGND sg13g2_fill_2
XFILLER_59_1356 VPWR VGND sg13g2_decap_4
XFILLER_33_233 VPWR VGND sg13g2_decap_4
XFILLER_94_1269 VPWR VGND sg13g2_decap_8
X_18445_ _18445_/Y _18562_/C _18210_/B _18427_/B VPWR VGND sg13g2_o21ai_1
XFILLER_22_918 VPWR VGND sg13g2_fill_1
X_15657_ _15668_/A _22602_/Q _15964_/A2 _15945_/B1 _22797_/Q VPWR VGND sg13g2_a22oi_1
XFILLER_21_428 VPWR VGND sg13g2_decap_8
X_14608_ _24222_/D _14602_/Y _14608_/B VPWR VGND sg13g2_nand2b_1
X_18376_ _18377_/B _18344_/B _18380_/B _18403_/A VPWR VGND sg13g2_o21ai_1
X_15588_ _17113_/A _17517_/C VPWR VGND sg13g2_inv_1
XFILLER_18_1064 VPWR VGND sg13g2_fill_2
XFILLER_37_1698 VPWR VGND sg13g2_fill_2
X_17327_ _22791_/D _16080_/Y _17366_/S _17326_/Y VPWR VGND sg13g2_o21ai_1
X_14539_ _14545_/B _18016_/S _14539_/B VPWR VGND sg13g2_nor2_1
Xplace3204 _22286_/A1 _20049_/Y VPWR VGND sg13g2_buf_1
XFILLER_15_1941 VPWR VGND sg13g2_decap_8
Xplace3215 _18742_/A _16860_/A VPWR VGND sg13g2_buf_4
Xplace3226 _21713_/B _21783_/B VPWR VGND sg13g2_buf_1
Xplace3237 _21666_/B _21674_/B VPWR VGND sg13g2_buf_1
Xplace3248 _21108_/B _21099_/B VPWR VGND sg13g2_buf_1
X_17258_ _22759_/D _16080_/Y _17266_/B _17257_/Y VPWR VGND sg13g2_o21ai_1
XFILLER_102_1933 VPWR VGND sg13g2_decap_8
XFILLER_31_1242 VPWR VGND sg13g2_decap_4
Xplace3259 _21781_/A1 _22315_/A0 VPWR VGND sg13g2_buf_1
X_16209_ _16209_/Y _16209_/A _16209_/B VPWR VGND sg13g2_nand2_1
X_17189_ _17190_/C _22740_/Q _22739_/Q VPWR VGND sg13g2_nand2_1
XFILLER_66_1305 VPWR VGND sg13g2_fill_2
XFILLER_52_0 VPWR VGND sg13g2_decap_8
XFILLER_66_1316 VPWR VGND sg13g2_decap_8
XFILLER_115_544 VPWR VGND sg13g2_decap_8
XFILLER_29_1182 VPWR VGND sg13g2_decap_8
XFILLER_102_249 VPWR VGND sg13g2_decap_8
XFILLER_44_1647 VPWR VGND sg13g2_fill_1
XFILLER_68_141 VPWR VGND sg13g2_fill_1
XFILLER_29_506 VPWR VGND sg13g2_fill_2
XFILLER_68_152 VPWR VGND sg13g2_fill_2
XFILLER_111_772 VPWR VGND sg13g2_decap_8
XFILLER_29_517 VPWR VGND sg13g2_decap_8
X_22910_ _22910_/Q _22917_/CLK _22910_/D fanout2892/X VPWR VGND sg13g2_dfrbpq_1
X_23890_ _23890_/Q clkload29/A _23890_/D fanout2652/X VPWR VGND sg13g2_dfrbpq_1
XFILLER_110_271 VPWR VGND sg13g2_fill_2
XFILLER_84_634 VPWR VGND sg13g2_fill_1
XFILLER_99_1158 VPWR VGND sg13g2_decap_8
XFILLER_22_1945 VPWR VGND sg13g2_decap_8
X_22841_ _22841_/Q clkload25/A _22841_/D fanout2900/X VPWR VGND sg13g2_dfrbpq_1
XFILLER_84_667 VPWR VGND sg13g2_decap_4
X_22772_ _22772_/Q _22869_/CLK _22772_/D fanout2793/X VPWR VGND sg13g2_dfrbpq_1
XFILLER_37_583 VPWR VGND sg13g2_decap_8
XFILLER_0_1741 VPWR VGND sg13g2_decap_4
X_21723_ _23869_/D _21941_/A1 _21725_/B _21722_/Y VPWR VGND sg13g2_o21ai_1
XFILLER_25_767 VPWR VGND sg13g2_decap_8
XFILLER_90_1601 VPWR VGND sg13g2_decap_8
XFILLER_90_1612 VPWR VGND sg13g2_fill_2
XFILLER_90_1623 VPWR VGND sg13g2_decap_4
X_21654_ _23840_/D _21948_/A1 _21657_/B _21653_/Y VPWR VGND sg13g2_o21ai_1
XFILLER_33_47 VPWR VGND sg13g2_fill_1
XFILLER_55_1765 VPWR VGND sg13g2_fill_2
XFILLER_21_951 VPWR VGND sg13g2_decap_8
X_20605_ _20605_/Y _23357_/Q _20607_/B VPWR VGND sg13g2_nand2_1
XFILLER_36_1175 VPWR VGND sg13g2_decap_8
XFILLER_51_1629 VPWR VGND sg13g2_decap_8
XFILLER_32_1017 VPWR VGND sg13g2_decap_8
X_21585_ _23807_/D _21946_/A1 _21590_/B _21584_/Y VPWR VGND sg13g2_o21ai_1
XFILLER_107_1888 VPWR VGND sg13g2_decap_8
X_23324_ _23324_/Q clkload55/A _23324_/D fanout2772/X VPWR VGND sg13g2_dfrbpq_1
Xrebuffer5440 _13580_/A1 _12048_/Y VPWR VGND sg13g2_buf_2
X_20536_ _23324_/D _22405_/A1 _20539_/B _20535_/Y VPWR VGND sg13g2_o21ai_1
Xrebuffer5451 _13437_/B _13353_/Y VPWR VGND sg13g2_buf_2
Xrebuffer5462 _14006_/A_N _13757_/Y VPWR VGND sg13g2_buf_1
Xrebuffer5473 _11865_/B place3725/A VPWR VGND sg13g2_buf_1
Xplace3760 _19928_/B _12514_/A VPWR VGND sg13g2_buf_2
XFILLER_10_1315 VPWR VGND sg13g2_decap_8
Xrebuffer5484 _14244_/A _14407_/A VPWR VGND sg13g2_buf_1
X_23255_ _23255_/Q clkload57/A _23255_/D fanout2761/X VPWR VGND sg13g2_dfrbpq_1
Xplace3771 _13296_/A _11646_/X VPWR VGND sg13g2_buf_1
XFILLER_10_1326 VPWR VGND sg13g2_fill_2
Xrebuffer5495 _13543_/A _20243_/B VPWR VGND sg13g2_buf_1
Xplace3782 _12428_/C _12535_/A VPWR VGND sg13g2_buf_1
X_20467_ _20467_/Y _23295_/Q _20473_/B VPWR VGND sg13g2_nand2_1
Xplace3793 _19673_/B _16048_/S VPWR VGND sg13g2_buf_2
Xhold5130 _20471_/A _23297_/Q VPWR VGND sg13g2_dlygate4sd3_1
Xhold5141 _21900_/A _23946_/Q VPWR VGND sg13g2_dlygate4sd3_1
X_22206_ _24092_/D _22272_/A1 _22210_/B _22205_/Y VPWR VGND sg13g2_o21ai_1
Xhold5152 _20559_/A _23335_/Q VPWR VGND sg13g2_dlygate4sd3_1
X_23186_ _23186_/Q clkload17/A _23186_/D fanout2858/X VPWR VGND sg13g2_dfrbpq_1
Xhold5163 _17692_/A _22892_/Q VPWR VGND sg13g2_dlygate4sd3_1
XFILLER_106_566 VPWR VGND sg13g2_decap_8
X_20398_ _20398_/Y _23263_/Q _20404_/B VPWR VGND sg13g2_nand2_1
XFILLER_49_1558 VPWR VGND sg13g2_fill_2
Xhold5174 _22250_/A _24116_/Q VPWR VGND sg13g2_dlygate4sd3_1
Xhold5185 _21106_/A _23579_/Q VPWR VGND sg13g2_dlygate4sd3_1
X_22137_ _24059_/D _22270_/A1 _22136_/B _22136_/Y VPWR VGND sg13g2_o21ai_1
Xhold5196 _22391_/A _24182_/Q VPWR VGND sg13g2_dlygate4sd3_1
XFILLER_114_1804 VPWR VGND sg13g2_decap_8
X_22068_ _24026_/D _22268_/A1 _22069_/B _22067_/Y VPWR VGND sg13g2_o21ai_1
XFILLER_7_1939 VPWR VGND sg13g2_decap_8
XFILLER_59_141 VPWR VGND sg13g2_decap_4
XFILLER_102_772 VPWR VGND sg13g2_fill_1
XFILLER_82_1195 VPWR VGND sg13g2_decap_8
XFILLER_102_783 VPWR VGND sg13g2_decap_8
X_13910_ _13910_/X _23923_/Q _24019_/Q _13910_/S VPWR VGND sg13g2_mux2_1
XFILLER_87_472 VPWR VGND sg13g2_decap_8
X_21019_ _21019_/Y _23548_/Q _21019_/B VPWR VGND sg13g2_nand2_1
X_14890_ _14890_/Y _22520_/Q _14828_/A _14880_/Y _14890_/B2 _14889_/Y VPWR VGND sg13g2_a221oi_1
XFILLER_47_336 VPWR VGND sg13g2_decap_8
X_13841_ _13841_/X _23858_/Q _23890_/Q _23954_/Q _23986_/Q _12577_/C _13964_/S1 VPWR
+ VGND sg13g2_mux4_1
XFILLER_60_1493 VPWR VGND sg13g2_fill_1
XFILLER_62_306 VPWR VGND sg13g2_fill_2
XFILLER_74_43 VPWR VGND sg13g2_decap_8
XFILLER_75_689 VPWR VGND sg13g2_decap_8
XFILLER_90_626 VPWR VGND sg13g2_decap_8
XFILLER_56_870 VPWR VGND sg13g2_decap_8
XFILLER_28_572 VPWR VGND sg13g2_decap_8
X_16560_ _16561_/B _22627_/Q _16560_/B VPWR VGND sg13g2_xnor2_1
X_13772_ _13772_/X _24177_/Q _24209_/Q _23249_/Q _23281_/Q _13910_/S _13911_/B2 VPWR
+ VGND sg13g2_mux4_1
XFILLER_95_1556 VPWR VGND sg13g2_fill_2
XFILLER_16_745 VPWR VGND sg13g2_fill_1
XFILLER_15_233 VPWR VGND sg13g2_decap_4
X_12723_ _12723_/Y _12820_/S _12718_/Y _12720_/Y _13678_/A1 _12722_/Y VPWR VGND sg13g2_a221oi_1
X_16491_ _22607_/D _16150_/A _16508_/B _16490_/Y VPWR VGND sg13g2_o21ai_1
XFILLER_31_704 VPWR VGND sg13g2_fill_1
XFILLER_73_1810 VPWR VGND sg13g2_decap_8
X_18230_ _18230_/Y _22969_/Q _18565_/B VPWR VGND sg13g2_nand2_1
XFILLER_70_372 VPWR VGND sg13g2_decap_8
XFILLER_19_1340 VPWR VGND sg13g2_decap_4
Xinput4361 _17893_/A1 boot_addr_i[19] VPWR VGND sg13g2_buf_1
X_12654_ _12663_/A _13245_/B2 _12649_/Y _12653_/Y VPWR VGND sg13g2_a21oi_1
X_15442_ _16069_/A _23004_/Q _22554_/Q _15442_/S VPWR VGND sg13g2_mux2_1
Xinput4372 _17926_/A1 boot_addr_i[30] VPWR VGND sg13g2_buf_1
XFILLER_19_1362 VPWR VGND sg13g2_decap_4
Xinput4383 _20343_/A1 data_rdata_i[14] VPWR VGND sg13g2_buf_1
Xinput4394 _20249_/A0 data_rdata_i[24] VPWR VGND sg13g2_buf_1
XFILLER_73_1876 VPWR VGND sg13g2_decap_4
XFILLER_15_1215 VPWR VGND sg13g2_decap_8
XFILLER_34_1838 VPWR VGND sg13g2_decap_8
X_11605_ _11605_/Y _14591_/A _14117_/C VPWR VGND sg13g2_nor2_1
XFILLER_90_75 VPWR VGND sg13g2_decap_8
XFILLER_54_1275 VPWR VGND sg13g2_fill_1
X_12585_ _12585_/Y _14117_/A _12746_/A2 _12668_/A _12585_/B2 _12584_/Y VPWR VGND sg13g2_a221oi_1
X_15373_ _19740_/A _15373_/A _15373_/B _15373_/C _15373_/D VPWR VGND sg13g2_nand4_1
XFILLER_50_1128 VPWR VGND sg13g2_decap_8
XFILLER_102_1207 VPWR VGND sg13g2_fill_1
X_17112_ _17112_/Y _22727_/Q _17112_/B VPWR VGND sg13g2_xnor2_1
X_11536_ _11537_/A _11531_/X _11532_/X _11533_/X _11534_/X _11418_/A _11926_/S VPWR
+ VGND sg13g2_mux4_1
X_14324_ _14324_/Y _14300_/Y _14317_/Y _15478_/B VPWR VGND sg13g2_a21oi_1
XFILLER_89_1338 VPWR VGND sg13g2_decap_4
X_14255_ _14260_/A _14254_/Y _24223_/Q VPWR VGND sg13g2_nand2b_1
X_17043_ _17044_/C _17043_/A _17043_/B VPWR VGND sg13g2_or2_1
X_11467_ _11467_/Y _23638_/Q _11714_/S VPWR VGND sg13g2_nand2b_1
XFILLER_109_371 VPWR VGND sg13g2_fill_2
X_13206_ _13216_/C _13206_/A _13206_/B _13206_/C _13206_/D VPWR VGND sg13g2_nor4_1
XFILLER_87_1051 VPWR VGND sg13g2_decap_8
XFILLER_99_84 VPWR VGND sg13g2_decap_4
XFILLER_87_1062 VPWR VGND sg13g2_fill_2
X_11398_ _11398_/Y _11406_/S _23766_/Q _11397_/Y VPWR VGND sg13g2_o21ai_1
XFILLER_28_1609 VPWR VGND sg13g2_fill_1
XFILLER_87_1095 VPWR VGND sg13g2_fill_2
X_13137_ _13138_/B _23720_/Q _23752_/Q _23784_/Q _23816_/Q _13635_/S0 _13631_/S1 VPWR
+ VGND sg13g2_mux4_1
XFILLER_84_1950 VPWR VGND sg13g2_decap_4
XFILLER_10_1893 VPWR VGND sg13g2_decap_8
XFILLER_97_214 VPWR VGND sg13g2_fill_2
XFILLER_3_671 VPWR VGND sg13g2_fill_1
XFILLER_98_748 VPWR VGND sg13g2_fill_1
X_18994_ _23056_/D _18988_/Y _18991_/Y _18992_/Y _18993_/Y VPWR VGND sg13g2_a22oi_1
XFILLER_65_1360 VPWR VGND sg13g2_fill_1
XFILLER_112_558 VPWR VGND sg13g2_decap_8
X_17945_ _17945_/Y _17965_/A _23035_/Q _17944_/Y VPWR VGND sg13g2_a21oi_1
X_13068_ _13069_/B _20132_/A _15714_/A VPWR VGND sg13g2_nor2_1
XFILLER_97_269 VPWR VGND sg13g2_decap_8
XFILLER_41_1809 VPWR VGND sg13g2_decap_8
X_12019_ _12026_/A _12475_/A _12019_/B VPWR VGND sg13g2_nor2_1
XFILLER_78_472 VPWR VGND sg13g2_fill_2
XFILLER_6_1438 VPWR VGND sg13g2_fill_2
XFILLER_26_1366 VPWR VGND sg13g2_fill_1
XFILLER_38_314 VPWR VGND sg13g2_decap_8
X_17876_ _17877_/B _22923_/Q _17930_/B VPWR VGND sg13g2_nand2_1
XFILLER_65_111 VPWR VGND sg13g2_decap_8
X_16827_ _22677_/D _16500_/Y _16774_/Y _16826_/Y VPWR VGND sg13g2_o21ai_1
XFILLER_66_678 VPWR VGND sg13g2_decap_4
XFILLER_54_829 VPWR VGND sg13g2_decap_4
XFILLER_93_486 VPWR VGND sg13g2_fill_1
XFILLER_65_188 VPWR VGND sg13g2_decap_8
X_16758_ _16770_/D _16796_/B _16796_/C VPWR VGND sg13g2_nor2_1
XFILLER_0_84 VPWR VGND sg13g2_decap_4
X_15709_ _15709_/Y _16014_/A _15709_/B VPWR VGND sg13g2_nor2_1
X_19477_ _19719_/A _19773_/A _19477_/B VPWR VGND sg13g2_xnor2_1
X_16689_ _16735_/A _22652_/Q VPWR VGND sg13g2_inv_1
X_18428_ _18428_/Y _18253_/B _18424_/Y _18427_/Y VPWR VGND sg13g2_o21ai_1
XFILLER_107_1118 VPWR VGND sg13g2_fill_2
XFILLER_37_1451 VPWR VGND sg13g2_fill_1
XFILLER_37_1473 VPWR VGND sg13g2_fill_1
XFILLER_9_71 VPWR VGND sg13g2_decap_8
X_18359_ _18359_/Y _18476_/A _18359_/B VPWR VGND sg13g2_nor2_1
XFILLER_72_1375 VPWR VGND sg13g2_decap_4
Xplace3001 _17195_/A _17144_/B VPWR VGND sg13g2_buf_1
Xplace3012 _22263_/B _22316_/B VPWR VGND sg13g2_buf_1
Xplace3023 _22247_/B _22243_/S VPWR VGND sg13g2_buf_1
X_21370_ _21370_/Y _21370_/A _21380_/B VPWR VGND sg13g2_nand2_1
Xplace3034 _22117_/B _22095_/B VPWR VGND sg13g2_buf_1
Xplace3045 _22017_/B _22008_/B VPWR VGND sg13g2_buf_1
Xplace3056 _21961_/B _21982_/B VPWR VGND sg13g2_buf_1
Xplace3067 _21802_/B _21848_/B VPWR VGND sg13g2_buf_1
X_20321_ _20322_/B _14342_/A _14672_/A _13847_/Y VPWR VGND sg13g2_a21o_1
XFILLER_102_1763 VPWR VGND sg13g2_fill_2
Xplace3078 _21572_/B _21621_/B VPWR VGND sg13g2_buf_1
XFILLER_31_1083 VPWR VGND sg13g2_fill_2
Xplace3089 _21530_/B _21534_/B VPWR VGND sg13g2_buf_1
X_23040_ _23040_/Q clkload13/A _23040_/D fanout2914/X VPWR VGND sg13g2_dfrbpq_1
XFILLER_85_1736 VPWR VGND sg13g2_fill_1
XFILLER_89_715 VPWR VGND sg13g2_decap_8
XFILLER_89_726 VPWR VGND sg13g2_fill_1
X_20183_ _20183_/Y _24265_/A _19977_/B _19985_/Y _19474_/X _20182_/Y VPWR VGND sg13g2_a221oi_1
XFILLER_103_569 VPWR VGND sg13g2_decap_8
XFILLER_9_1051 VPWR VGND sg13g2_decap_8
XFILLER_83_1493 VPWR VGND sg13g2_fill_1
XFILLER_57_601 VPWR VGND sg13g2_fill_2
XFILLER_69_461 VPWR VGND sg13g2_decap_8
XFILLER_9_1084 VPWR VGND sg13g2_decap_8
XFILLER_9_1095 VPWR VGND sg13g2_fill_1
X_23942_ _23942_/Q clkload41/A _23942_/D fanout2723/X VPWR VGND sg13g2_dfrbpq_1
XFILLER_56_100 VPWR VGND sg13g2_decap_8
XFILLER_96_280 VPWR VGND sg13g2_fill_1
XFILLER_56_111 VPWR VGND sg13g2_fill_2
XFILLER_44_1499 VPWR VGND sg13g2_decap_8
XFILLER_29_358 VPWR VGND sg13g2_fill_2
XFILLER_45_807 VPWR VGND sg13g2_decap_8
XFILLER_84_453 VPWR VGND sg13g2_decap_8
X_23873_ _23873_/Q clkload39/A _23873_/D fanout2738/X VPWR VGND sg13g2_dfrbpq_1
XFILLER_113_1892 VPWR VGND sg13g2_decap_8
XFILLER_22_1775 VPWR VGND sg13g2_decap_8
XFILLER_56_177 VPWR VGND sg13g2_fill_2
X_22824_ _22824_/Q _22869_/CLK _22824_/D fanout2793/X VPWR VGND sg13g2_dfrbpq_1
XFILLER_22_1786 VPWR VGND sg13g2_decap_8
XFILLER_2_1869 VPWR VGND sg13g2_decap_8
XFILLER_44_13 VPWR VGND sg13g2_fill_1
XFILLER_77_1253 VPWR VGND sg13g2_decap_8
X_22755_ _22755_/Q clkload24/A _22755_/D fanout2898/X VPWR VGND sg13g2_dfrbpq_1
XFILLER_77_1275 VPWR VGND sg13g2_decap_8
XFILLER_57_1849 VPWR VGND sg13g2_decap_8
XFILLER_71_169 VPWR VGND sg13g2_decap_8
XFILLER_44_57 VPWR VGND sg13g2_decap_8
XFILLER_53_884 VPWR VGND sg13g2_decap_8
XFILLER_109_1939 VPWR VGND sg13g2_decap_8
X_21706_ _21706_/Y _21706_/A _21783_/B VPWR VGND sg13g2_nand2_1
X_22686_ _22686_/Q clkload23/A _22686_/D fanout2889/X VPWR VGND sg13g2_dfrbpq_1
XFILLER_40_534 VPWR VGND sg13g2_fill_1
XFILLER_12_247 VPWR VGND sg13g2_decap_4
XFILLER_40_556 VPWR VGND sg13g2_fill_2
XFILLER_90_1464 VPWR VGND sg13g2_fill_1
XFILLER_100_63 VPWR VGND sg13g2_decap_8
XFILLER_8_229 VPWR VGND sg13g2_decap_8
XFILLER_100_96 VPWR VGND sg13g2_decap_4
XFILLER_21_781 VPWR VGND sg13g2_decap_8
XFILLER_107_1696 VPWR VGND sg13g2_fill_2
X_12370_ _12385_/B _12370_/A _12370_/B _12370_/C _12370_/D VPWR VGND sg13g2_nor4_1
X_21568_ _21568_/Y _23800_/Q _21572_/B VPWR VGND sg13g2_nand2_1
XFILLER_20_280 VPWR VGND sg13g2_decap_8
Xplace4280 _13586_/A1 _13039_/S VPWR VGND sg13g2_buf_2
Xplace4291 _13614_/S0 _13621_/S VPWR VGND sg13g2_buf_2
XFILLER_5_914 VPWR VGND sg13g2_decap_4
Xrebuffer5270 _16300_/A _15033_/A1 VPWR VGND sg13g2_buf_1
X_23307_ _23307_/Q _24212_/CLK _23307_/D fanout2627/X VPWR VGND sg13g2_dfrbpq_1
X_11321_ _11321_/Y _14120_/C _11247_/B _14461_/A VPWR VGND sg13g2_a21oi_1
XFILLER_4_402 VPWR VGND sg13g2_decap_4
Xrebuffer5281 _14689_/A _13569_/B VPWR VGND sg13g2_buf_1
XFILLER_10_1112 VPWR VGND sg13g2_decap_8
X_21499_ _23766_/D _21926_/A1 _21502_/B _21498_/Y VPWR VGND sg13g2_o21ai_1
XFILLER_10_1123 VPWR VGND sg13g2_fill_1
Xrebuffer5292 _20197_/A _13247_/Y VPWR VGND sg13g2_buf_1
XFILLER_101_1251 VPWR VGND sg13g2_decap_8
Xplace3590 _20028_/A _19757_/A VPWR VGND sg13g2_buf_1
X_14040_ _14042_/A _19322_/A _14041_/B _14041_/C VPWR VGND sg13g2_and3_1
XFILLER_4_435 VPWR VGND sg13g2_decap_8
XFILLER_68_1934 VPWR VGND sg13g2_decap_8
Xrebuffer4580 place3725/A _11863_/Y VPWR VGND sg13g2_buf_8
X_23238_ _23238_/Q clkload33/A _23238_/D fanout2694/X VPWR VGND sg13g2_dfrbpq_1
XFILLER_5_969 VPWR VGND sg13g2_decap_4
X_11252_ _11447_/A _14614_/A _11251_/Y _11502_/A VPWR VGND sg13g2_o21ai_1
XFILLER_88_1382 VPWR VGND sg13g2_fill_1
Xrebuffer4591 _20087_/A _12950_/B VPWR VGND sg13g2_buf_1
XFILLER_10_1189 VPWR VGND sg13g2_fill_2
XFILLER_106_374 VPWR VGND sg13g2_fill_1
XFILLER_84_1246 VPWR VGND sg13g2_decap_8
XFILLER_79_214 VPWR VGND sg13g2_fill_2
XFILLER_106_385 VPWR VGND sg13g2_fill_1
XFILLER_84_1257 VPWR VGND sg13g2_fill_1
X_23169_ _23169_/Q clkload17/A _23169_/D fanout2857/X VPWR VGND sg13g2_dfrbpq_1
X_11183_ _11234_/B _14121_/A _22966_/Q _11316_/B _11305_/B VPWR VGND sg13g2_nand4_1
XFILLER_79_225 VPWR VGND sg13g2_decap_8
XFILLER_62_1511 VPWR VGND sg13g2_decap_8
XFILLER_69_98 VPWR VGND sg13g2_decap_8
X_15991_ _15993_/C _22780_/Q _15991_/A2 _15309_/Y _22512_/Q VPWR VGND sg13g2_a22oi_1
XFILLER_27_1675 VPWR VGND sg13g2_decap_8
XFILLER_88_781 VPWR VGND sg13g2_decap_4
XFILLER_62_1566 VPWR VGND sg13g2_decap_4
XFILLER_114_1656 VPWR VGND sg13g2_decap_8
XFILLER_76_954 VPWR VGND sg13g2_fill_2
XFILLER_97_1618 VPWR VGND sg13g2_decap_8
XFILLER_48_667 VPWR VGND sg13g2_decap_8
X_17661_ _17661_/Y _22889_/Q _17661_/B VPWR VGND sg13g2_nor2_1
XFILLER_91_913 VPWR VGND sg13g2_decap_8
XFILLER_5_1460 VPWR VGND sg13g2_fill_1
X_14873_ _14875_/B _22489_/Q _14848_/B _14872_/Y _14774_/X VPWR VGND sg13g2_a22oi_1
XFILLER_36_829 VPWR VGND sg13g2_decap_8
XFILLER_47_166 VPWR VGND sg13g2_fill_2
X_19400_ _19400_/Y _19986_/A _19364_/X _19399_/Y VPWR VGND sg13g2_o21ai_1
XFILLER_78_1028 VPWR VGND sg13g2_decap_8
XFILLER_90_412 VPWR VGND sg13g2_decap_8
X_13824_ _13824_/X _13820_/X _13821_/X _13822_/X _13823_/X _14129_/D _12050_/B VPWR
+ VGND sg13g2_mux4_1
XFILLER_112_1391 VPWR VGND sg13g2_decap_8
XFILLER_35_339 VPWR VGND sg13g2_decap_4
X_17592_ _17592_/Y _11569_/A _17573_/A _17591_/Y VPWR VGND sg13g2_o21ai_1
XFILLER_44_840 VPWR VGND sg13g2_decap_8
XFILLER_75_1916 VPWR VGND sg13g2_fill_2
X_19331_ _19351_/B _19331_/A _19608_/A _19331_/C _19480_/C VPWR VGND sg13g2_nand4_1
X_16543_ _22623_/D _15375_/Y _16547_/A _16542_/Y VPWR VGND sg13g2_a21oi_1
XFILLER_16_553 VPWR VGND sg13g2_decap_8
XFILLER_16_564 VPWR VGND sg13g2_fill_1
XFILLER_50_309 VPWR VGND sg13g2_fill_1
XFILLER_56_1326 VPWR VGND sg13g2_fill_2
X_13755_ _14059_/B _13755_/A _13755_/B _13755_/C _13755_/D VPWR VGND sg13g2_and4_1
XFILLER_62_169 VPWR VGND sg13g2_fill_1
XFILLER_90_489 VPWR VGND sg13g2_fill_2
XFILLER_56_1337 VPWR VGND sg13g2_fill_1
XFILLER_43_372 VPWR VGND sg13g2_fill_1
X_19262_ _23192_/D _19262_/A _19262_/B VPWR VGND sg13g2_nand2_1
X_12706_ _12706_/X _23715_/Q _23747_/Q _23779_/Q _23811_/Q _13006_/S0 _13006_/S1 VPWR
+ VGND sg13g2_mux4_1
XFILLER_93_7 VPWR VGND sg13g2_fill_2
XFILLER_38_1760 VPWR VGND sg13g2_decap_4
X_16474_ _16474_/Y _22600_/Q _16517_/S VPWR VGND sg13g2_nand2_1
X_13686_ _13686_/Y _13686_/A _13686_/B VPWR VGND sg13g2_nand2_1
X_18213_ _18245_/B _18425_/B _18498_/B VPWR VGND sg13g2_nand2_1
XFILLER_15_1012 VPWR VGND sg13g2_fill_1
X_12637_ _12638_/B _12623_/B _12636_/Y _12538_/B VPWR VGND sg13g2_a21oi_1
Xoutput4506 data_wdata_o[12] _14708_/X VPWR VGND sg13g2_buf_1
XFILLER_34_1646 VPWR VGND sg13g2_decap_8
XFILLER_34_1657 VPWR VGND sg13g2_fill_2
Xoutput4517 data_wdata_o[22] _14730_/X VPWR VGND sg13g2_buf_1
XFILLER_8_741 VPWR VGND sg13g2_decap_8
Xoutput4528 data_wdata_o[3] _14664_/X VPWR VGND sg13g2_buf_1
X_18144_ _18144_/Y _18144_/A _18404_/B VPWR VGND sg13g2_nor2_1
Xoutput4539 instr_addr_o[13] _14944_/X VPWR VGND sg13g2_buf_1
X_15356_ _15365_/A _15356_/A _15969_/B VPWR VGND sg13g2_nand2_1
X_12568_ _12572_/A _11954_/Y _12566_/X _12567_/Y _12889_/C _12686_/B VPWR VGND sg13g2_a221oi_1
XFILLER_12_1911 VPWR VGND sg13g2_decap_8
X_11519_ _11519_/X _24053_/Q _24117_/Q _13797_/S VPWR VGND sg13g2_mux2_1
X_14307_ _14307_/Y _15289_/A _19360_/B VPWR VGND sg13g2_nand2_1
X_18075_ _18076_/B _18290_/A _18070_/Y _18074_/Y VPWR VGND sg13g2_a21oi_1
X_15287_ _15346_/A _15287_/A _16786_/C VPWR VGND sg13g2_nor2b_1
X_12499_ _12504_/B _12499_/A _12499_/B VPWR VGND sg13g2_nor2_1
XFILLER_7_284 VPWR VGND sg13g2_decap_8
XFILLER_67_1411 VPWR VGND sg13g2_fill_2
X_17026_ _17026_/Y _17220_/A _17026_/B VPWR VGND sg13g2_nand2_1
XFILLER_113_834 VPWR VGND sg13g2_decap_8
XFILLER_112_333 VPWR VGND sg13g2_fill_2
XFILLER_45_1720 VPWR VGND sg13g2_fill_1
XFILLER_84_1791 VPWR VGND sg13g2_decap_8
X_18977_ _18977_/Y _18999_/A _18977_/B VPWR VGND sg13g2_nand2_1
XFILLER_45_1753 VPWR VGND sg13g2_fill_2
XFILLER_112_377 VPWR VGND sg13g2_decap_4
XFILLER_80_1655 VPWR VGND sg13g2_decap_4
XFILLER_100_539 VPWR VGND sg13g2_decap_8
X_17928_ _22940_/D _17928_/A _17928_/B VPWR VGND sg13g2_nand2_1
XFILLER_80_1688 VPWR VGND sg13g2_decap_8
XFILLER_78_291 VPWR VGND sg13g2_fill_2
XFILLER_15_0 VPWR VGND sg13g2_decap_8
XFILLER_26_1185 VPWR VGND sg13g2_fill_1
XFILLER_94_751 VPWR VGND sg13g2_decap_8
XFILLER_39_667 VPWR VGND sg13g2_decap_8
XFILLER_67_976 VPWR VGND sg13g2_fill_1
X_17859_ _17860_/A _17859_/A1 _17855_/A _17927_/B _22918_/Q _17858_/Y VPWR VGND sg13g2_a221oi_1
XFILLER_61_1098 VPWR VGND sg13g2_decap_8
XFILLER_96_1117 VPWR VGND sg13g2_fill_1
XFILLER_94_784 VPWR VGND sg13g2_decap_4
XFILLER_54_637 VPWR VGND sg13g2_fill_2
X_20870_ _20870_/Y _23482_/Q _20874_/B VPWR VGND sg13g2_nand2_1
XFILLER_78_1562 VPWR VGND sg13g2_fill_2
XFILLER_81_467 VPWR VGND sg13g2_decap_8
XFILLER_53_169 VPWR VGND sg13g2_decap_8
XFILLER_78_1595 VPWR VGND sg13g2_decap_8
X_22540_ _22540_/Q clkload6/A _22540_/D fanout2832/X VPWR VGND sg13g2_dfrbpq_1
XFILLER_74_1448 VPWR VGND sg13g2_decap_8
XFILLER_22_545 VPWR VGND sg13g2_decap_8
X_22471_ _22471_/Q clkload8/A _22471_/D fanout2800/X VPWR VGND sg13g2_dfrbpq_1
XFILLER_104_1803 VPWR VGND sg13g2_fill_1
X_24210_ _24210_/Q _24210_/CLK _24210_/D fanout2635/X VPWR VGND sg13g2_dfrbpq_1
XFILLER_13_1719 VPWR VGND sg13g2_fill_1
X_21422_ _21422_/Y _21422_/A _21422_/B VPWR VGND sg13g2_nand2_1
XFILLER_17_1899 VPWR VGND sg13g2_decap_8
XFILLER_33_1178 VPWR VGND sg13g2_fill_1
XFILLER_107_105 VPWR VGND sg13g2_decap_8
X_24141_ _24141_/Q _24205_/CLK _24141_/D fanout2649/X VPWR VGND sg13g2_dfrbpq_1
XFILLER_33_1189 VPWR VGND sg13g2_fill_2
X_21353_ _21353_/Y _21353_/A _21353_/B VPWR VGND sg13g2_nand2_1
XFILLER_30_48 VPWR VGND sg13g2_decap_8
X_20304_ _20305_/C _13808_/B _20304_/B _20304_/C VPWR VGND sg13g2_nand3b_1
XFILLER_85_1522 VPWR VGND sg13g2_decap_8
X_24072_ _24072_/Q _24205_/CLK _24072_/D fanout2649/X VPWR VGND sg13g2_dfrbpq_1
X_21284_ _21284_/Y _21284_/A _21287_/B VPWR VGND sg13g2_nand2_1
XFILLER_102_1593 VPWR VGND sg13g2_decap_8
X_23023_ _23023_/Q clkload6/A _23023_/D fanout2835/X VPWR VGND sg13g2_dfrbpq_1
XFILLER_46_1506 VPWR VGND sg13g2_fill_1
XFILLER_104_823 VPWR VGND sg13g2_fill_1
X_20235_ _20236_/B _20177_/A _19899_/Y _19905_/Y _19474_/X _20234_/Y VPWR VGND sg13g2_a221oi_1
Xfanout2909 fanout2909/X fanout2910/X VPWR VGND sg13g2_buf_1
XFILLER_115_182 VPWR VGND sg13g2_decap_8
XFILLER_89_556 VPWR VGND sg13g2_decap_8
XFILLER_115_1910 VPWR VGND sg13g2_decap_8
XFILLER_103_355 VPWR VGND sg13g2_decap_8
XFILLER_89_578 VPWR VGND sg13g2_decap_4
XFILLER_49_409 VPWR VGND sg13g2_decap_4
XFILLER_63_1842 VPWR VGND sg13g2_fill_1
X_20166_ _20166_/Y _20166_/A _20166_/B _20338_/C VPWR VGND sg13g2_nor3_1
XFILLER_89_589 VPWR VGND sg13g2_decap_4
XFILLER_44_1252 VPWR VGND sg13g2_fill_1
XFILLER_115_1954 VPWR VGND sg13g2_fill_1
XFILLER_103_399 VPWR VGND sg13g2_decap_8
X_20097_ _20097_/Y _24214_/Q _20106_/C VPWR VGND sg13g2_nand2_1
XFILLER_85_751 VPWR VGND sg13g2_fill_1
XFILLER_58_965 VPWR VGND sg13g2_decap_8
XFILLER_58_976 VPWR VGND sg13g2_fill_1
XFILLER_111_1829 VPWR VGND sg13g2_decap_8
X_23925_ _23925_/Q _24113_/CLK _23925_/D fanout2688/X VPWR VGND sg13g2_dfrbpq_1
XFILLER_98_1938 VPWR VGND sg13g2_decap_8
XFILLER_85_784 VPWR VGND sg13g2_decap_8
XFILLER_57_475 VPWR VGND sg13g2_decap_8
XFILLER_73_924 VPWR VGND sg13g2_fill_1
XFILLER_6_1791 VPWR VGND sg13g2_decap_8
X_11870_ _11983_/B _22974_/Q _12471_/B _11984_/C VPWR VGND sg13g2_and3_1
XFILLER_2_1644 VPWR VGND sg13g2_fill_1
XFILLER_44_114 VPWR VGND sg13g2_decap_8
X_23856_ _23856_/Q clkload29/A _23856_/D fanout2670/X VPWR VGND sg13g2_dfrbpq_1
XFILLER_44_136 VPWR VGND sg13g2_decap_8
XFILLER_44_147 VPWR VGND sg13g2_decap_8
XFILLER_57_1613 VPWR VGND sg13g2_decap_8
X_22807_ _22807_/Q clkload10/A _22807_/D fanout2811/X VPWR VGND sg13g2_dfrbpq_1
XFILLER_57_1624 VPWR VGND sg13g2_fill_2
XFILLER_60_629 VPWR VGND sg13g2_fill_2
X_23787_ _23787_/Q clkload49/A _23787_/D fanout2675/X VPWR VGND sg13g2_dfrbpq_1
XFILLER_41_821 VPWR VGND sg13g2_decap_4
XFILLER_13_523 VPWR VGND sg13g2_fill_2
X_13540_ _13540_/Y _13537_/X _13538_/Y _20245_/A _20243_/B _13540_/C1 VPWR VGND sg13g2_a221oi_1
XFILLER_92_1559 VPWR VGND sg13g2_decap_8
X_22738_ _22738_/Q clkload20/A _22738_/D fanout2869/X VPWR VGND sg13g2_dfrbpq_1
XFILLER_38_1056 VPWR VGND sg13g2_fill_1
XFILLER_41_843 VPWR VGND sg13g2_fill_1
XFILLER_111_84 VPWR VGND sg13g2_decap_8
XFILLER_41_854 VPWR VGND sg13g2_decap_8
XFILLER_38_1089 VPWR VGND sg13g2_decap_8
X_13471_ _13539_/C _14144_/C _13904_/B VPWR VGND sg13g2_nand2_1
X_22669_ _22669_/Q _22733_/CLK _22669_/D fanout2879/X VPWR VGND sg13g2_dfrbpq_1
XFILLER_9_527 VPWR VGND sg13g2_fill_1
XFILLER_9_538 VPWR VGND sg13g2_fill_2
XFILLER_107_1460 VPWR VGND sg13g2_fill_2
X_15210_ _17439_/A _16779_/A _15210_/B VPWR VGND sg13g2_and2_1
X_12422_ _12422_/Y _12429_/A _14387_/B VPWR VGND sg13g2_nor2_1
X_16190_ _22509_/D _16145_/B _16188_/Y _16189_/Y VPWR VGND sg13g2_o21ai_1
XFILLER_12_1207 VPWR VGND sg13g2_decap_8
X_12353_ _12354_/C _12353_/A _12353_/B VPWR VGND sg13g2_xnor2_1
XFILLER_51_1289 VPWR VGND sg13g2_decap_4
XFILLER_5_755 VPWR VGND sg13g2_fill_2
X_12284_ _12284_/X _23294_/Q _23326_/Q _23358_/Q _23390_/Q _12459_/S0 _12457_/S1 VPWR
+ VGND sg13g2_mux4_1
XFILLER_107_661 VPWR VGND sg13g2_fill_2
XFILLER_29_1704 VPWR VGND sg13g2_decap_4
XFILLER_68_1753 VPWR VGND sg13g2_decap_4
X_14023_ _14023_/Y _14024_/A _15186_/A _14618_/A VPWR VGND sg13g2_nor3_1
XFILLER_88_1190 VPWR VGND sg13g2_fill_2
X_18900_ _18903_/B _18897_/Y _18924_/C VPWR VGND sg13g2_nand2b_1
XFILLER_113_119 VPWR VGND sg13g2_decap_8
XFILLER_101_1092 VPWR VGND sg13g2_decap_8
XFILLER_4_276 VPWR VGND sg13g2_decap_8
XFILLER_29_1726 VPWR VGND sg13g2_decap_8
XFILLER_107_694 VPWR VGND sg13g2_decap_4
X_19880_ _19880_/Y _19880_/A _19880_/B _19880_/C VPWR VGND sg13g2_nand3_1
XFILLER_49_1163 VPWR VGND sg13g2_decap_8
XFILLER_68_1786 VPWR VGND sg13g2_decap_8
XFILLER_106_182 VPWR VGND sg13g2_decap_8
XFILLER_84_1065 VPWR VGND sg13g2_decap_8
XFILLER_106_193 VPWR VGND sg13g2_fill_2
XFILLER_84_1076 VPWR VGND sg13g2_fill_1
X_18831_ _18832_/C _23071_/Q _18869_/B VPWR VGND sg13g2_nand2_1
XFILLER_7_1500 VPWR VGND sg13g2_decap_4
XFILLER_110_815 VPWR VGND sg13g2_decap_8
XFILLER_81_1953 VPWR VGND sg13g2_fill_2
XFILLER_67_206 VPWR VGND sg13g2_decap_8
XFILLER_96_63 VPWR VGND sg13g2_decap_8
XFILLER_0_460 VPWR VGND sg13g2_fill_2
XFILLER_95_548 VPWR VGND sg13g2_decap_4
X_15974_ _15975_/D _15973_/Y _17056_/A VPWR VGND sg13g2_nand2b_1
XFILLER_23_1314 VPWR VGND sg13g2_decap_8
XFILLER_62_1385 VPWR VGND sg13g2_fill_2
X_17713_ _22894_/D _17825_/B _17711_/Y _17712_/Y VPWR VGND sg13g2_a21oi_1
XFILLER_76_751 VPWR VGND sg13g2_fill_1
X_18693_ _23016_/D _18690_/A _18689_/Y _18692_/Y _18688_/A VPWR VGND sg13g2_a22oi_1
XFILLER_7_1599 VPWR VGND sg13g2_decap_8
XFILLER_23_1358 VPWR VGND sg13g2_decap_8
XFILLER_110_1328 VPWR VGND sg13g2_fill_1
XFILLER_63_412 VPWR VGND sg13g2_decap_8
XFILLER_75_272 VPWR VGND sg13g2_decap_4
X_17644_ _17645_/B _22557_/Q _22556_/Q _17654_/D VPWR VGND sg13g2_nand3_1
X_14856_ _14857_/C _22456_/Q _14874_/B _14855_/Y _14774_/X VPWR VGND sg13g2_a22oi_1
XFILLER_35_136 VPWR VGND sg13g2_fill_1
XFILLER_63_456 VPWR VGND sg13g2_decap_8
XFILLER_90_242 VPWR VGND sg13g2_decap_4
XFILLER_51_607 VPWR VGND sg13g2_decap_8
XFILLER_79_1882 VPWR VGND sg13g2_decap_8
XFILLER_17_862 VPWR VGND sg13g2_fill_2
XFILLER_21_1093 VPWR VGND sg13g2_fill_1
X_13807_ _13808_/B _13867_/B _13867_/C VPWR VGND sg13g2_nor2_1
XFILLER_23_309 VPWR VGND sg13g2_fill_2
XFILLER_35_169 VPWR VGND sg13g2_decap_4
X_17575_ _17593_/B _22551_/Q _22550_/Q _22549_/Q _22946_/Q VPWR VGND sg13g2_and4_1
X_14787_ _14788_/C _14786_/B _14837_/B _14786_/Y VPWR VGND sg13g2_a21oi_1
XFILLER_32_810 VPWR VGND sg13g2_fill_2
XFILLER_75_1746 VPWR VGND sg13g2_decap_4
X_19314_ _22186_/A _22972_/Q _21087_/B VPWR VGND sg13g2_and2_1
X_16526_ _16559_/C _22584_/Q _16711_/A VPWR VGND sg13g2_nor2_1
XFILLER_31_331 VPWR VGND sg13g2_decap_8
X_19245_ _19245_/Y _19265_/A _19265_/B VPWR VGND sg13g2_nor2b_1
XFILLER_56_1189 VPWR VGND sg13g2_decap_8
X_16457_ _22592_/D _16063_/A _16456_/B _16456_/Y VPWR VGND sg13g2_o21ai_1
XFILLER_31_364 VPWR VGND sg13g2_decap_8
X_13669_ _13669_/Y _23696_/Q _13671_/B VPWR VGND sg13g2_nand2b_1
XFILLER_73_1492 VPWR VGND sg13g2_fill_1
X_19176_ _19176_/Y _19176_/A _19176_/B VPWR VGND sg13g2_nand2_1
X_16388_ _16388_/Y _22559_/Q _16388_/B VPWR VGND sg13g2_nand2_1
X_18127_ _22957_/D _18366_/A _22957_/Q _18565_/B VPWR VGND sg13g2_mux2_1
X_15339_ _22453_/D _16052_/A _15338_/X _15497_/S VPWR VGND sg13g2_mux2_1
XFILLER_8_582 VPWR VGND sg13g2_decap_4
XFILLER_12_1785 VPWR VGND sg13g2_decap_8
XFILLER_104_119 VPWR VGND sg13g2_decap_8
X_17009_ _17010_/B _17019_/A _17013_/B VPWR VGND sg13g2_nor2b_1
XFILLER_99_832 VPWR VGND sg13g2_decap_8
XFILLER_67_1263 VPWR VGND sg13g2_fill_2
XFILLER_113_631 VPWR VGND sg13g2_decap_8
XFILLER_67_1285 VPWR VGND sg13g2_decap_4
X_20020_ _20020_/Y _20020_/A VPWR VGND sg13g2_inv_1
XFILLER_115_1206 VPWR VGND sg13g2_decap_8
XFILLER_98_364 VPWR VGND sg13g2_decap_8
XFILLER_101_815 VPWR VGND sg13g2_decap_8
XFILLER_63_1149 VPWR VGND sg13g2_fill_1
XFILLER_101_826 VPWR VGND sg13g2_fill_1
XFILLER_86_526 VPWR VGND sg13g2_decap_4
XFILLER_6_1021 VPWR VGND sg13g2_decap_8
XFILLER_112_196 VPWR VGND sg13g2_decap_8
X_21971_ _23980_/D _21971_/A1 _21976_/B _21970_/Y VPWR VGND sg13g2_o21ai_1
XFILLER_41_1458 VPWR VGND sg13g2_fill_2
XFILLER_55_924 VPWR VGND sg13g2_fill_1
Xclkbuf_leaf_32_clk_i clkload58/A clkload4/A VPWR VGND sg13g2_buf_16
XFILLER_55_935 VPWR VGND sg13g2_decap_4
XFILLER_66_272 VPWR VGND sg13g2_decap_4
X_23710_ _23710_/Q clkload59/A _23710_/D fanout2784/X VPWR VGND sg13g2_dfrbpq_1
XFILLER_3_1953 VPWR VGND sg13g2_fill_2
XFILLER_93_1802 VPWR VGND sg13g2_fill_2
XFILLER_110_1873 VPWR VGND sg13g2_decap_8
XFILLER_82_776 VPWR VGND sg13g2_fill_1
XFILLER_58_1933 VPWR VGND sg13g2_decap_8
X_23641_ _23641_/Q clkload59/A _23641_/D fanout2789/X VPWR VGND sg13g2_dfrbpq_1
X_20853_ _20853_/Y _20853_/A _20853_/B VPWR VGND sg13g2_nand2_1
XFILLER_82_798 VPWR VGND sg13g2_fill_1
XFILLER_81_264 VPWR VGND sg13g2_decap_4
XFILLER_74_1212 VPWR VGND sg13g2_fill_2
XFILLER_78_1392 VPWR VGND sg13g2_fill_2
XFILLER_81_297 VPWR VGND sg13g2_fill_2
XFILLER_23_843 VPWR VGND sg13g2_decap_8
X_23572_ _23572_/Q _24210_/CLK _23572_/D fanout2635/X VPWR VGND sg13g2_dfrbpq_1
Xclkbuf_leaf_47_clk_i _24170_/CLK clkbuf_4_9__f_clk_i/X VPWR VGND sg13g2_buf_16
X_20784_ _20784_/Y _20784_/A _20784_/B VPWR VGND sg13g2_nand2_1
XFILLER_93_1879 VPWR VGND sg13g2_decap_8
XFILLER_106_1909 VPWR VGND sg13g2_decap_8
XFILLER_39_1387 VPWR VGND sg13g2_decap_8
XFILLER_74_1267 VPWR VGND sg13g2_fill_1
X_22523_ _22523_/Q clkload6/A _22523_/D fanout2832/X VPWR VGND sg13g2_dfrbpq_1
XFILLER_22_353 VPWR VGND sg13g2_fill_2
XFILLER_108_1780 VPWR VGND sg13g2_decap_4
XFILLER_104_1611 VPWR VGND sg13g2_decap_8
X_22454_ _22454_/Q clkload18/A _22454_/D fanout2829/X VPWR VGND sg13g2_dfrbpq_1
XFILLER_108_403 VPWR VGND sg13g2_fill_2
X_21405_ _23721_/D _23721_/Q _21965_/A0 _21421_/S VPWR VGND sg13g2_mux2_1
X_22385_ _22385_/X _22430_/A _22385_/B VPWR VGND sg13g2_or2_1
XFILLER_104_1699 VPWR VGND sg13g2_fill_2
X_24124_ _24124_/Q clkload56/A _24124_/D fanout2678/X VPWR VGND sg13g2_dfrbpq_1
X_21336_ _23689_/D _21336_/A0 _23689_/Q _21349_/S VPWR VGND sg13g2_mux2_1
XFILLER_102_1390 VPWR VGND sg13g2_fill_1
X_24055_ _24055_/Q clkload48/A _24055_/D fanout2687/X VPWR VGND sg13g2_dfrbpq_1
Xfanout2706 fanout2706/X fanout2743/X VPWR VGND sg13g2_buf_1
X_21267_ _23655_/D _21333_/A1 _21287_/B _21266_/Y VPWR VGND sg13g2_o21ai_1
XFILLER_104_631 VPWR VGND sg13g2_decap_8
XFILLER_46_1314 VPWR VGND sg13g2_fill_1
Xfanout2717 fanout2717/X fanout2743/X VPWR VGND sg13g2_buf_1
X_23006_ _23006_/Q _23029_/CLK _23006_/D fanout2839/X VPWR VGND sg13g2_dfrbpq_1
Xfanout2728 fanout2728/X fanout2743/X VPWR VGND sg13g2_buf_1
Xfanout2739 fanout2739/X fanout2741/X VPWR VGND sg13g2_buf_1
X_21198_ _23622_/D _21331_/A1 _21197_/B _21197_/Y VPWR VGND sg13g2_o21ai_1
XFILLER_89_375 VPWR VGND sg13g2_decap_4
XFILLER_77_537 VPWR VGND sg13g2_decap_8
XFILLER_8_1853 VPWR VGND sg13g2_decap_8
X_20149_ _20153_/B _13092_/Y _20304_/B _19956_/A VPWR VGND sg13g2_a21oi_1
XFILLER_63_1672 VPWR VGND sg13g2_decap_4
XFILLER_106_84 VPWR VGND sg13g2_decap_8
XFILLER_24_1634 VPWR VGND sg13g2_fill_1
XFILLER_66_33 VPWR VGND sg13g2_decap_8
XFILLER_63_1694 VPWR VGND sg13g2_fill_1
XFILLER_66_44 VPWR VGND sg13g2_fill_2
XFILLER_18_604 VPWR VGND sg13g2_fill_1
XFILLER_115_1784 VPWR VGND sg13g2_decap_8
XFILLER_4_1739 VPWR VGND sg13g2_decap_8
X_12971_ _12971_/X _24070_/Q _24134_/Q _12974_/A VPWR VGND sg13g2_mux2_1
XFILLER_100_870 VPWR VGND sg13g2_decap_8
XFILLER_85_570 VPWR VGND sg13g2_decap_8
XFILLER_73_710 VPWR VGND sg13g2_fill_2
XFILLER_24_1689 VPWR VGND sg13g2_decap_8
XFILLER_17_114 VPWR VGND sg13g2_decap_4
X_14710_ _14710_/Y _14673_/A1 _14710_/B VPWR VGND sg13g2_nand2b_1
XFILLER_111_1659 VPWR VGND sg13g2_decap_8
X_11922_ _11922_/X _11921_/A _11915_/X _11921_/Y VPWR VGND sg13g2_a21o_1
X_23908_ _23908_/Q _24131_/CLK _23908_/D fanout2715/X VPWR VGND sg13g2_dfrbpq_1
X_15690_ _15690_/Y _15690_/A _15690_/B _20120_/A VPWR VGND sg13g2_nor3_1
XFILLER_45_445 VPWR VGND sg13g2_fill_1
XFILLER_61_905 VPWR VGND sg13g2_fill_2
XFILLER_72_242 VPWR VGND sg13g2_fill_2
XFILLER_22_1391 VPWR VGND sg13g2_fill_1
XFILLER_33_607 VPWR VGND sg13g2_decap_8
X_11853_ _11854_/B _23705_/Q _23737_/Q _11855_/S VPWR VGND sg13g2_mux2_1
X_23839_ _23839_/Q clkload43/A _23839_/D fanout2738/X VPWR VGND sg13g2_dfrbpq_1
XFILLER_92_1312 VPWR VGND sg13g2_decap_8
XFILLER_14_810 VPWR VGND sg13g2_fill_1
XFILLER_33_629 VPWR VGND sg13g2_decap_8
XFILLER_72_275 VPWR VGND sg13g2_decap_4
XFILLER_32_117 VPWR VGND sg13g2_fill_2
XFILLER_72_286 VPWR VGND sg13g2_decap_4
XFILLER_96_1492 VPWR VGND sg13g2_decap_4
XFILLER_14_832 VPWR VGND sg13g2_decap_8
X_17360_ _17360_/Y _17360_/A _17367_/B VPWR VGND sg13g2_nand2_1
X_11784_ _11784_/Y _22975_/Q _12471_/B _11984_/C VPWR VGND sg13g2_nand3_1
XFILLER_14_843 VPWR VGND sg13g2_fill_1
X_14572_ _14573_/B _14572_/A _14572_/B VPWR VGND sg13g2_nor2_1
XFILLER_25_191 VPWR VGND sg13g2_decap_8
XFILLER_14_876 VPWR VGND sg13g2_fill_2
X_16311_ _22536_/D _16314_/A _16311_/B VPWR VGND sg13g2_xnor2_1
XFILLER_41_651 VPWR VGND sg13g2_decap_8
XFILLER_53_1329 VPWR VGND sg13g2_fill_2
X_13523_ _13523_/Y _13523_/A _13523_/B VPWR VGND sg13g2_xnor2_1
XFILLER_14_887 VPWR VGND sg13g2_decap_8
X_17291_ _17291_/Y _17291_/A _17291_/B VPWR VGND sg13g2_nand2_1
XFILLER_13_386 VPWR VGND sg13g2_decap_8
X_19030_ _19030_/Y _19041_/A _19030_/B _19030_/C VPWR VGND sg13g2_nand3_1
X_13454_ _13469_/A _13138_/A _13451_/X _13453_/X VPWR VGND sg13g2_o21ai_1
XFILLER_9_357 VPWR VGND sg13g2_decap_8
XFILLER_12_1026 VPWR VGND sg13g2_fill_2
X_12405_ _12406_/B _23551_/Q _11346_/Y _12404_/X _12409_/S1 VPWR VGND sg13g2_a22oi_1
X_16173_ _16175_/A _20245_/B _14434_/Y _15865_/Y VPWR VGND sg13g2_a21oi_1
X_13385_ _13385_/X _23724_/Q _23756_/Q _23788_/Q _23820_/Q _13551_/S0 _12121_/S VPWR
+ VGND sg13g2_mux4_1
X_15124_ _15124_/Y _24230_/Q _18567_/B VPWR VGND sg13g2_nor2_1
X_12336_ _12344_/A _19428_/A _12347_/B VPWR VGND sg13g2_nor2_1
XFILLER_56_7 VPWR VGND sg13g2_decap_8
XFILLER_114_417 VPWR VGND sg13g2_decap_8
XFILLER_5_574 VPWR VGND sg13g2_fill_1
X_19932_ _19932_/X _19932_/A _19932_/B VPWR VGND sg13g2_and2_1
X_12267_ _12350_/C _14321_/A _14296_/A2 _12533_/A _12533_/B _14321_/B VPWR VGND sg13g2_a221oi_1
X_15055_ _15057_/A _22507_/Q _14998_/B _15066_/B1 _22935_/Q VPWR VGND sg13g2_a22oi_1
XFILLER_68_1572 VPWR VGND sg13g2_fill_1
XFILLER_29_1534 VPWR VGND sg13g2_fill_1
XFILLER_64_1425 VPWR VGND sg13g2_decap_8
X_14006_ _14008_/C _14006_/A_N _14006_/B VPWR VGND sg13g2_nand2b_1
X_19863_ _19863_/Y _20162_/A _14340_/A _19861_/A VPWR VGND sg13g2_a21oi_1
X_12198_ _12198_/X _24029_/Q _24061_/Q _24093_/Q _24125_/Q _13551_/S0 _12321_/S VPWR
+ VGND sg13g2_mux4_1
XFILLER_95_301 VPWR VGND sg13g2_decap_4
XFILLER_96_835 VPWR VGND sg13g2_decap_8
XFILLER_110_634 VPWR VGND sg13g2_decap_8
XFILLER_96_857 VPWR VGND sg13g2_decap_4
X_18814_ _23036_/D _18814_/A _18814_/B _18814_/C VPWR VGND sg13g2_nand3_1
X_19794_ _19794_/Y _19872_/A _19794_/B VPWR VGND sg13g2_nor2_1
XFILLER_68_559 VPWR VGND sg13g2_decap_8
XFILLER_3_1205 VPWR VGND sg13g2_fill_2
X_18745_ _18745_/Y _18748_/A _18750_/C _18757_/A VPWR VGND sg13g2_o21ai_1
X_15957_ _16193_/A _18741_/A _15956_/B _15956_/Y VPWR VGND sg13g2_o21ai_1
XFILLER_97_1212 VPWR VGND sg13g2_decap_8
XFILLER_37_935 VPWR VGND sg13g2_decap_8
XFILLER_37_946 VPWR VGND sg13g2_fill_1
X_14908_ _14908_/Y _22522_/Q _15117_/A VPWR VGND sg13g2_nand2_1
XFILLER_3_1249 VPWR VGND sg13g2_decap_8
XFILLER_110_1136 VPWR VGND sg13g2_decap_4
XFILLER_97_1245 VPWR VGND sg13g2_decap_8
XFILLER_23_1188 VPWR VGND sg13g2_fill_2
X_18676_ _18677_/B _18689_/A _18675_/X _23013_/Q VPWR VGND sg13g2_a21oi_1
XFILLER_36_434 VPWR VGND sg13g2_decap_8
X_15888_ _15888_/Y _15980_/S _17192_/A _15887_/Y VPWR VGND sg13g2_o21ai_1
XFILLER_23_1199 VPWR VGND sg13g2_decap_4
X_17627_ _17628_/B _17689_/B1 _17623_/Y _17626_/X _17538_/B VPWR VGND sg13g2_a22oi_1
X_14839_ _14839_/Y _22486_/Q _14848_/B _14794_/X _22455_/Q VPWR VGND sg13g2_a22oi_1
XFILLER_79_1690 VPWR VGND sg13g2_decap_4
XFILLER_51_415 VPWR VGND sg13g2_decap_8
X_17558_ _17558_/Y _16357_/A _17388_/B _17670_/B1 _17557_/Y VPWR VGND sg13g2_a22oi_1
XFILLER_75_1554 VPWR VGND sg13g2_decap_8
XFILLER_16_191 VPWR VGND sg13g2_decap_8
XFILLER_32_651 VPWR VGND sg13g2_decap_8
X_16509_ _22614_/D _17917_/A _16508_/B _16508_/Y VPWR VGND sg13g2_o21ai_1
XFILLER_60_982 VPWR VGND sg13g2_decap_4
XFILLER_75_1598 VPWR VGND sg13g2_decap_8
X_17489_ _17489_/Y _22861_/Q _17489_/B VPWR VGND sg13g2_nand2_1
XFILLER_82_0 VPWR VGND sg13g2_fill_2
X_19228_ _23182_/D _24271_/A _23182_/Q _19232_/B VPWR VGND sg13g2_mux2_1
XFILLER_108_1087 VPWR VGND sg13g2_fill_2
XFILLER_34_1262 VPWR VGND sg13g2_decap_8
XFILLER_30_1104 VPWR VGND sg13g2_decap_8
XFILLER_14_1858 VPWR VGND sg13g2_decap_8
XFILLER_101_1817 VPWR VGND sg13g2_fill_1
X_19159_ _23132_/D _23132_/Q _14893_/Y _19159_/S VPWR VGND sg13g2_mux2_1
XFILLER_69_1303 VPWR VGND sg13g2_decap_4
XFILLER_69_1314 VPWR VGND sg13g2_fill_1
XFILLER_11_28 VPWR VGND sg13g2_fill_1
X_22170_ _22170_/Y _22170_/A _22175_/B VPWR VGND sg13g2_nand2_1
XFILLER_105_406 VPWR VGND sg13g2_fill_1
Xhold4803 _22279_/A _24127_/Q VPWR VGND sg13g2_dlygate4sd3_1
XFILLER_69_1358 VPWR VGND sg13g2_fill_2
Xhold4814 _21308_/A _23676_/Q VPWR VGND sg13g2_dlygate4sd3_1
X_21121_ _21121_/Y _23586_/Q _21121_/B VPWR VGND sg13g2_nand2_1
XFILLER_47_1601 VPWR VGND sg13g2_decap_8
Xhold4825 _20688_/A _23397_/Q VPWR VGND sg13g2_dlygate4sd3_1
Xhold4836 _20890_/A _23491_/Q VPWR VGND sg13g2_dlygate4sd3_1
Xhold4847 _21221_/A _23636_/Q VPWR VGND sg13g2_dlygate4sd3_1
Xhold4858 _21110_/A _23581_/Q VPWR VGND sg13g2_dlygate4sd3_1
XFILLER_82_1525 VPWR VGND sg13g2_fill_2
X_21052_ _23558_/D _22294_/A1 _21079_/B _21051_/Y VPWR VGND sg13g2_o21ai_1
Xhold4869 _21674_/A _23850_/Q VPWR VGND sg13g2_dlygate4sd3_1
XFILLER_59_504 VPWR VGND sg13g2_decap_4
XFILLER_87_824 VPWR VGND sg13g2_decap_8
XFILLER_8_1127 VPWR VGND sg13g2_decap_8
X_20003_ _20003_/Y _20092_/A2 _19719_/B _19663_/X VPWR VGND sg13g2_a21oi_1
XFILLER_47_1689 VPWR VGND sg13g2_decap_8
XFILLER_100_100 VPWR VGND sg13g2_fill_2
XFILLER_98_194 VPWR VGND sg13g2_fill_2
XFILLER_87_857 VPWR VGND sg13g2_decap_8
XFILLER_60_1823 VPWR VGND sg13g2_fill_2
XFILLER_115_1058 VPWR VGND sg13g2_decap_8
XFILLER_101_656 VPWR VGND sg13g2_decap_8
XFILLER_112_1924 VPWR VGND sg13g2_decap_8
XFILLER_21_1807 VPWR VGND sg13g2_decap_4
XFILLER_28_935 VPWR VGND sg13g2_fill_2
XFILLER_36_25 VPWR VGND sg13g2_fill_2
XFILLER_3_1750 VPWR VGND sg13g2_decap_8
XFILLER_36_36 VPWR VGND sg13g2_decap_8
X_21954_ _23971_/D _21954_/A1 _21957_/B _21953_/Y VPWR VGND sg13g2_o21ai_1
X_20905_ _20905_/Y _20905_/A _20913_/B VPWR VGND sg13g2_nand2_1
XFILLER_70_713 VPWR VGND sg13g2_decap_8
X_21885_ _21885_/Y _21885_/A _21885_/B VPWR VGND sg13g2_nand2_1
XFILLER_58_1741 VPWR VGND sg13g2_fill_1
XFILLER_36_990 VPWR VGND sg13g2_decap_8
XFILLER_14_128 VPWR VGND sg13g2_fill_2
X_23624_ _23624_/Q clkload31/A _23624_/D fanout2654/X VPWR VGND sg13g2_dfrbpq_1
X_20836_ _23465_/D _23465_/Q _22433_/A1 _20852_/S VPWR VGND sg13g2_mux2_1
XFILLER_58_1763 VPWR VGND sg13g2_decap_8
XFILLER_70_757 VPWR VGND sg13g2_decap_8
XFILLER_23_640 VPWR VGND sg13g2_decap_4
XFILLER_39_1162 VPWR VGND sg13g2_decap_8
XFILLER_54_1638 VPWR VGND sg13g2_decap_8
X_20767_ _23433_/D _23433_/Q _22433_/A1 _20783_/S VPWR VGND sg13g2_mux2_1
X_23555_ _23555_/Q _24131_/CLK _23555_/D fanout2711/X VPWR VGND sg13g2_dfrbpq_1
XFILLER_106_1728 VPWR VGND sg13g2_fill_1
XFILLER_106_1739 VPWR VGND sg13g2_decap_8
XFILLER_11_857 VPWR VGND sg13g2_decap_8
X_22506_ _22506_/Q _22941_/CLK _22506_/D fanout2795/X VPWR VGND sg13g2_dfrbpq_1
X_23486_ _23486_/Q clkload55/A _23486_/D fanout2778/X VPWR VGND sg13g2_dfrbpq_1
X_20698_ _23402_/D _22435_/A1 _20704_/B _20697_/Y VPWR VGND sg13g2_o21ai_1
XFILLER_11_868 VPWR VGND sg13g2_decap_8
XFILLER_10_356 VPWR VGND sg13g2_decap_8
XFILLER_32_1936 VPWR VGND sg13g2_decap_8
XFILLER_10_367 VPWR VGND sg13g2_fill_2
XFILLER_6_316 VPWR VGND sg13g2_fill_2
X_22437_ _24203_/D _22437_/A1 _22450_/B _22436_/Y VPWR VGND sg13g2_o21ai_1
XFILLER_104_1485 VPWR VGND sg13g2_decap_8
X_13170_ _13170_/X _23849_/Q _23881_/Q _23945_/Q _23977_/Q _13166_/B _13765_/S1 VPWR
+ VGND sg13g2_mux4_1
XFILLER_100_1327 VPWR VGND sg13g2_decap_4
X_22368_ _24170_/D _22435_/A1 _22374_/B _22367_/Y VPWR VGND sg13g2_o21ai_1
XFILLER_30_1671 VPWR VGND sg13g2_decap_8
XFILLER_108_288 VPWR VGND sg13g2_decap_8
XFILLER_87_1469 VPWR VGND sg13g2_fill_2
X_12121_ _12121_/X _24060_/Q _24124_/Q _12121_/S VPWR VGND sg13g2_mux2_1
X_24107_ _24107_/Q _24212_/CLK _24107_/D fanout2633/X VPWR VGND sg13g2_dfrbpq_1
X_21319_ _23680_/D _21587_/A1 _21337_/B _21318_/Y VPWR VGND sg13g2_o21ai_1
XFILLER_69_1870 VPWR VGND sg13g2_fill_1
XFILLER_2_522 VPWR VGND sg13g2_decap_4
X_22299_ _24137_/D _20187_/Y _24137_/Q _22315_/S VPWR VGND sg13g2_mux2_1
XFILLER_2_555 VPWR VGND sg13g2_decap_8
X_24038_ _24038_/Q _24170_/CLK _24038_/D fanout2707/X VPWR VGND sg13g2_dfrbpq_1
XFILLER_65_1745 VPWR VGND sg13g2_fill_1
X_12052_ _12052_/X _12052_/A _12052_/B VPWR VGND sg13g2_or2_1
XFILLER_81_1013 VPWR VGND sg13g2_fill_2
XFILLER_2_566 VPWR VGND sg13g2_fill_2
XFILLER_46_1133 VPWR VGND sg13g2_decap_8
XFILLER_2_588 VPWR VGND sg13g2_fill_2
XFILLER_78_857 VPWR VGND sg13g2_decap_8
XFILLER_46_1177 VPWR VGND sg13g2_fill_1
X_16860_ _17019_/A _16860_/A _16860_/B _16860_/C _17227_/B VPWR VGND sg13g2_nand4_1
XFILLER_81_1079 VPWR VGND sg13g2_decap_4
XFILLER_77_345 VPWR VGND sg13g2_decap_8
XFILLER_78_879 VPWR VGND sg13g2_decap_8
Xclkbuf_3_0_0_clk_i clkbuf_3_0_0_clk_i/X clkbuf_0_clk_i/X VPWR VGND sg13g2_buf_16
X_15811_ _15815_/C _22473_/Q _15900_/A2 _15945_/B1 _22804_/Q VPWR VGND sg13g2_a22oi_1
XFILLER_65_507 VPWR VGND sg13g2_fill_2
XFILLER_93_827 VPWR VGND sg13g2_decap_8
XFILLER_4_1514 VPWR VGND sg13g2_decap_8
X_16791_ _16851_/S _16524_/C _16859_/B VPWR VGND sg13g2_nand2b_1
XFILLER_4_1525 VPWR VGND sg13g2_fill_1
XFILLER_115_1581 VPWR VGND sg13g2_decap_8
XFILLER_19_924 VPWR VGND sg13g2_decap_4
XFILLER_4_1536 VPWR VGND sg13g2_decap_4
XFILLER_58_570 VPWR VGND sg13g2_fill_2
XFILLER_18_423 VPWR VGND sg13g2_decap_8
X_18530_ _18531_/D _18530_/A _18530_/B VPWR VGND sg13g2_nand2_1
XFILLER_19_957 VPWR VGND sg13g2_fill_2
X_15742_ _15745_/B _22501_/Q _15893_/A2 _15804_/B1 _15742_/B2 VPWR VGND sg13g2_a22oi_1
XFILLER_4_1558 VPWR VGND sg13g2_decap_8
XFILLER_19_968 VPWR VGND sg13g2_fill_2
XFILLER_18_456 VPWR VGND sg13g2_fill_2
XFILLER_59_1538 VPWR VGND sg13g2_fill_1
XFILLER_93_75 VPWR VGND sg13g2_decap_8
X_11905_ _11905_/Y _11904_/B _23482_/Q _11904_/Y VPWR VGND sg13g2_o21ai_1
X_18461_ _18461_/Y _18461_/A _18460_/Y VPWR VGND sg13g2_nor2b_1
XFILLER_73_573 VPWR VGND sg13g2_decap_8
XFILLER_45_275 VPWR VGND sg13g2_decap_8
XFILLER_46_798 VPWR VGND sg13g2_decap_8
X_12885_ _12885_/Y _12884_/B _23749_/Q _12884_/Y VPWR VGND sg13g2_o21ai_1
XFILLER_93_97 VPWR VGND sg13g2_fill_1
XFILLER_33_426 VPWR VGND sg13g2_decap_8
XFILLER_61_735 VPWR VGND sg13g2_decap_8
X_17412_ _17412_/Y _22825_/Q _17412_/B VPWR VGND sg13g2_nand2_1
X_14624_ _14625_/B _14699_/B _14637_/B _14616_/Y VPWR VGND sg13g2_a21oi_1
X_18392_ _18797_/B _19120_/A1 _23066_/Q _18462_/S VPWR VGND sg13g2_mux2_1
X_11836_ _11836_/Y _23257_/Q _11836_/B VPWR VGND sg13g2_nand2b_1
XFILLER_61_779 VPWR VGND sg13g2_decap_8
X_17343_ _17343_/Y _17343_/A _17371_/S VPWR VGND sg13g2_nand2_1
XFILLER_60_267 VPWR VGND sg13g2_decap_8
X_14555_ _18880_/C _18602_/B _18616_/D VPWR VGND sg13g2_nor2b_2
X_11767_ _11767_/X _23832_/Q _23864_/Q _23928_/Q _23960_/Q _11768_/S0 _11768_/S1 VPWR
+ VGND sg13g2_mux4_1
Xplace4109 _14341_/B _22991_/Q VPWR VGND sg13g2_buf_1
XFILLER_41_470 VPWR VGND sg13g2_fill_2
XFILLER_9_121 VPWR VGND sg13g2_decap_8
XFILLER_9_132 VPWR VGND sg13g2_fill_2
X_17274_ _17274_/Y _17274_/A _17291_/B VPWR VGND sg13g2_nand2_1
X_14486_ _14497_/B _14486_/A _14486_/B _14486_/C _14486_/D VPWR VGND sg13g2_nor4_1
Xplace3408 _17358_/B _17371_/S VPWR VGND sg13g2_buf_1
Xplace3419 _17266_/B _17246_/B VPWR VGND sg13g2_buf_1
XFILLER_9_154 VPWR VGND sg13g2_fill_1
X_19013_ _19013_/Y _19043_/A _19013_/B _19013_/C VPWR VGND sg13g2_nand3b_1
X_16225_ _16226_/A _22515_/Q _16217_/Y _16224_/Y VPWR VGND sg13g2_o21ai_1
XFILLER_31_1424 VPWR VGND sg13g2_decap_4
XFILLER_70_1473 VPWR VGND sg13g2_fill_1
X_13437_ _13437_/Y _13440_/B _13437_/B VPWR VGND sg13g2_nand2b_1
XFILLER_9_198 VPWR VGND sg13g2_decap_8
X_16156_ _16156_/Y _17899_/A _16156_/B VPWR VGND sg13g2_nor2_1
XFILLER_6_861 VPWR VGND sg13g2_decap_8
X_13368_ _20166_/A _13368_/A VPWR VGND sg13g2_inv_2
XFILLER_115_726 VPWR VGND sg13g2_decap_8
XFILLER_114_203 VPWR VGND sg13g2_decap_8
X_15107_ _15108_/B _17926_/A1 _15107_/A2 _14918_/B VPWR VGND sg13g2_o21ai_1
X_12319_ _12320_/B _24030_/Q _24094_/Q _12321_/S VPWR VGND sg13g2_mux2_1
XFILLER_100_1883 VPWR VGND sg13g2_decap_8
XFILLER_5_393 VPWR VGND sg13g2_decap_4
X_13299_ _13356_/D _13368_/A _14032_/A VPWR VGND sg13g2_xnor2_1
XFILLER_29_1331 VPWR VGND sg13g2_fill_2
X_15038_ _15040_/A _15038_/A1 _18679_/A2 _15037_/Y VPWR VGND sg13g2_a21oi_1
X_19915_ _19916_/B _20249_/A1 _20249_/A3 _20249_/A0 _20249_/A2 _19501_/A _20154_/S1
+ VPWR VGND sg13g2_mux4_1
XFILLER_44_1807 VPWR VGND sg13g2_decap_8
XFILLER_44_1818 VPWR VGND sg13g2_fill_1
XFILLER_64_1244 VPWR VGND sg13g2_decap_8
XFILLER_25_1206 VPWR VGND sg13g2_decap_8
XFILLER_9_1447 VPWR VGND sg13g2_decap_8
XFILLER_29_1386 VPWR VGND sg13g2_decap_8
XFILLER_111_954 VPWR VGND sg13g2_fill_1
XFILLER_9_1469 VPWR VGND sg13g2_decap_8
X_19846_ _19846_/Y _23211_/Q _19881_/A2 _19881_/B1 _23203_/Q VPWR VGND sg13g2_a22oi_1
XFILLER_84_805 VPWR VGND sg13g2_decap_8
XFILLER_68_356 VPWR VGND sg13g2_fill_2
XFILLER_42_1531 VPWR VGND sg13g2_fill_1
XFILLER_110_464 VPWR VGND sg13g2_fill_2
XFILLER_81_1591 VPWR VGND sg13g2_fill_1
XFILLER_96_687 VPWR VGND sg13g2_decap_8
XFILLER_95_164 VPWR VGND sg13g2_decap_4
X_19777_ _19778_/D _19777_/A _19777_/B _19978_/B VPWR VGND sg13g2_nor3_1
XFILLER_84_838 VPWR VGND sg13g2_fill_2
X_16989_ _16989_/Y _22707_/Q _16989_/B VPWR VGND sg13g2_xnor2_1
XFILLER_95_186 VPWR VGND sg13g2_fill_2
XFILLER_42_1564 VPWR VGND sg13g2_fill_1
X_18728_ _23023_/D _18726_/A _18725_/Y _18727_/Y VPWR VGND sg13g2_a21oi_1
XFILLER_97_1031 VPWR VGND sg13g2_fill_1
XFILLER_58_1004 VPWR VGND sg13g2_decap_4
XFILLER_20_1851 VPWR VGND sg13g2_fill_1
X_18659_ _23010_/D _18651_/B _18658_/Y _18659_/B1 VPWR VGND sg13g2_a21oi_1
XFILLER_91_381 VPWR VGND sg13g2_fill_1
X_21670_ _21689_/S _22363_/B _21756_/B VPWR VGND sg13g2_nor2_1
XFILLER_24_448 VPWR VGND sg13g2_fill_2
XFILLER_52_768 VPWR VGND sg13g2_decap_8
XFILLER_75_1362 VPWR VGND sg13g2_decap_8
XFILLER_90_1827 VPWR VGND sg13g2_decap_8
X_20621_ _23364_/D _21327_/A1 _20624_/B _20620_/Y VPWR VGND sg13g2_o21ai_1
X_23340_ _23340_/Q clkload35/A _23340_/D fanout2632/X VPWR VGND sg13g2_dfrbpq_1
XFILLER_36_1368 VPWR VGND sg13g2_decap_8
X_20552_ _23331_/D _20685_/A1 _20565_/B _20551_/Y VPWR VGND sg13g2_o21ai_1
XFILLER_14_1600 VPWR VGND sg13g2_fill_2
XFILLER_20_643 VPWR VGND sg13g2_decap_4
XFILLER_22_16 VPWR VGND sg13g2_fill_1
XFILLER_20_676 VPWR VGND sg13g2_decap_8
XFILLER_34_1070 VPWR VGND sg13g2_fill_2
Xplace3920 _17699_/B1 _17689_/B1 VPWR VGND sg13g2_buf_1
X_23271_ _23271_/Q clkload34/A _23271_/D fanout2696/X VPWR VGND sg13g2_dfrbpq_1
Xplace3931 _14196_/B _15216_/B VPWR VGND sg13g2_buf_1
Xplace3942 _12606_/A _11754_/B1 VPWR VGND sg13g2_buf_1
XFILLER_14_1655 VPWR VGND sg13g2_fill_2
X_20483_ _23302_/D _22427_/A1 _20482_/B _20482_/Y VPWR VGND sg13g2_o21ai_1
XFILLER_88_1723 VPWR VGND sg13g2_decap_8
XFILLER_10_1508 VPWR VGND sg13g2_decap_8
Xplace3953 _19850_/A _19512_/A VPWR VGND sg13g2_buf_1
Xplace3964 _15120_/S _15082_/A VPWR VGND sg13g2_buf_1
X_22222_ _24099_/D _22288_/A1 _22241_/B _22221_/Y VPWR VGND sg13g2_o21ai_1
Xplace3975 _13276_/A _13553_/A1 VPWR VGND sg13g2_buf_1
Xplace3986 _13212_/A place3986/A VPWR VGND sg13g2_buf_1
XFILLER_3_308 VPWR VGND sg13g2_decap_4
Xplace3997 _13266_/A1 _11465_/Y VPWR VGND sg13g2_buf_4
XFILLER_105_203 VPWR VGND sg13g2_decap_4
XFILLER_106_748 VPWR VGND sg13g2_fill_1
XFILLER_69_1199 VPWR VGND sg13g2_decap_4
X_21104_ _21104_/Y _21104_/A _21108_/B VPWR VGND sg13g2_nand2_1
Xhold4644 _17274_/A _22767_/Q VPWR VGND sg13g2_dlygate4sd3_1
XFILLER_86_1491 VPWR VGND sg13g2_decap_4
Xhold4655 _17284_/A _22771_/Q VPWR VGND sg13g2_dlygate4sd3_1
Xhold4666 _17451_/A _22844_/Q VPWR VGND sg13g2_dlygate4sd3_1
X_22084_ _22084_/Y _22084_/A _22084_/B VPWR VGND sg13g2_nand2_1
Xhold4677 _17277_/A _22768_/Q VPWR VGND sg13g2_dlygate4sd3_1
XFILLER_47_1453 VPWR VGND sg13g2_fill_2
XFILLER_62_1907 VPWR VGND sg13g2_decap_4
XFILLER_114_781 VPWR VGND sg13g2_decap_8
Xhold4688 _22300_/A _24138_/Q VPWR VGND sg13g2_dlygate4sd3_1
X_21035_ _21035_/Y _21035_/A _21042_/B VPWR VGND sg13g2_nand2_1
Xhold4699 _17351_/A _22802_/Q VPWR VGND sg13g2_dlygate4sd3_1
XFILLER_102_976 VPWR VGND sg13g2_fill_2
XFILLER_5_1812 VPWR VGND sg13g2_decap_8
XFILLER_25_1740 VPWR VGND sg13g2_decap_8
XFILLER_86_164 VPWR VGND sg13g2_fill_2
XFILLER_112_1721 VPWR VGND sg13g2_decap_8
XFILLER_47_529 VPWR VGND sg13g2_fill_2
XFILLER_60_1653 VPWR VGND sg13g2_decap_8
XFILLER_5_1889 VPWR VGND sg13g2_decap_8
XFILLER_21_1659 VPWR VGND sg13g2_fill_1
XFILLER_41_1085 VPWR VGND sg13g2_decap_8
X_22986_ _22986_/Q clkload29/A _22986_/D fanout2921/X VPWR VGND sg13g2_dfrbpq_2
XFILLER_83_860 VPWR VGND sg13g2_fill_2
XFILLER_28_765 VPWR VGND sg13g2_decap_8
X_21937_ _21937_/Y _23964_/Q _21942_/B VPWR VGND sg13g2_nand2_1
XFILLER_103_63 VPWR VGND sg13g2_decap_8
XFILLER_15_415 VPWR VGND sg13g2_fill_2
XFILLER_42_201 VPWR VGND sg13g2_decap_4
XFILLER_55_584 VPWR VGND sg13g2_fill_2
XFILLER_76_1148 VPWR VGND sg13g2_decap_4
XFILLER_31_908 VPWR VGND sg13g2_decap_8
XFILLER_63_56 VPWR VGND sg13g2_decap_8
X_12670_ _12670_/Y _13708_/B _12674_/C _22988_/Q VPWR VGND sg13g2_nand3b_1
X_21868_ _23930_/D _21934_/A1 _21869_/B _21867_/Y VPWR VGND sg13g2_o21ai_1
XFILLER_54_1402 VPWR VGND sg13g2_decap_8
XFILLER_24_960 VPWR VGND sg13g2_fill_2
XFILLER_63_78 VPWR VGND sg13g2_decap_8
XFILLER_70_565 VPWR VGND sg13g2_decap_4
XFILLER_24_971 VPWR VGND sg13g2_decap_8
X_23607_ _23607_/Q clkload58/A _23607_/D fanout2758/X VPWR VGND sg13g2_dfrbpq_1
X_11621_ _14116_/A _14133_/B _11608_/X _11620_/Y _14117_/B VPWR VGND sg13g2_a22oi_1
X_20819_ _23458_/D _21323_/A1 _20818_/B _20818_/Y VPWR VGND sg13g2_o21ai_1
X_21799_ _23897_/D _22266_/A1 _21802_/B _21798_/Y VPWR VGND sg13g2_o21ai_1
XFILLER_19_1566 VPWR VGND sg13g2_decap_8
XFILLER_23_481 VPWR VGND sg13g2_decap_8
XFILLER_15_1419 VPWR VGND sg13g2_decap_8
X_14340_ _14340_/Y _14340_/A _15255_/B _14340_/C VPWR VGND sg13g2_nand3_1
X_23538_ _23538_/Q clkload29/A _23538_/D fanout2636/X VPWR VGND sg13g2_dfrbpq_1
XFILLER_106_1569 VPWR VGND sg13g2_fill_2
XFILLER_89_1509 VPWR VGND sg13g2_decap_4
XFILLER_13_1110 VPWR VGND sg13g2_decap_8
XFILLER_13_1121 VPWR VGND sg13g2_fill_2
XFILLER_6_102 VPWR VGND sg13g2_fill_1
XFILLER_32_1744 VPWR VGND sg13g2_decap_4
X_11483_ _11483_/Y _11477_/X _11480_/Y _12738_/B VPWR VGND sg13g2_a21oi_1
X_14271_ _14272_/C _22872_/Q _14192_/A _14766_/B _14766_/A VPWR VGND sg13g2_a22oi_1
XFILLER_109_531 VPWR VGND sg13g2_decap_8
X_23469_ _23469_/Q clkload30/A _23469_/D fanout2658/X VPWR VGND sg13g2_dfrbpq_1
XFILLER_10_186 VPWR VGND sg13g2_decap_4
X_16010_ _16011_/B _16871_/C _16010_/B VPWR VGND sg13g2_nor2_1
XFILLER_12_60 VPWR VGND sg13g2_decap_8
X_13222_ _14045_/B _13854_/A _13222_/B VPWR VGND sg13g2_xnor2_1
XFILLER_100_1124 VPWR VGND sg13g2_decap_8
XFILLER_87_1255 VPWR VGND sg13g2_decap_8
X_13153_ _14047_/A _13368_/A _13153_/B VPWR VGND sg13g2_nor2_1
X_12104_ _12104_/Y _12340_/A _12104_/B _12104_/C VPWR VGND sg13g2_nand3_1
X_17961_ _17962_/B _18895_/B _23048_/Q _18052_/S VPWR VGND sg13g2_mux2_1
XFILLER_97_429 VPWR VGND sg13g2_decap_8
XFILLER_111_217 VPWR VGND sg13g2_decap_8
XFILLER_3_897 VPWR VGND sg13g2_fill_1
XFILLER_105_781 VPWR VGND sg13g2_decap_8
XFILLER_78_621 VPWR VGND sg13g2_decap_4
X_16912_ _22692_/D _16927_/S _16910_/Y _16911_/Y VPWR VGND sg13g2_o21ai_1
X_19700_ _19700_/Y _19708_/S _19700_/B VPWR VGND sg13g2_nor2_1
X_17892_ _22928_/D _17892_/A _17892_/B VPWR VGND sg13g2_nand2_1
XFILLER_65_1597 VPWR VGND sg13g2_fill_2
XFILLER_61_1439 VPWR VGND sg13g2_fill_1
XFILLER_78_665 VPWR VGND sg13g2_decap_8
XFILLER_26_1559 VPWR VGND sg13g2_decap_8
XFILLER_43_1840 VPWR VGND sg13g2_fill_2
X_16843_ _22681_/D _16197_/A _16846_/A _16842_/Y VPWR VGND sg13g2_o21ai_1
X_19631_ _19631_/Y _23222_/Q _19857_/B VPWR VGND sg13g2_nand2_1
XFILLER_19_710 VPWR VGND sg13g2_decap_8
XFILLER_19_7 VPWR VGND sg13g2_fill_1
XFILLER_92_112 VPWR VGND sg13g2_decap_4
XFILLER_43_1884 VPWR VGND sg13g2_decap_4
XFILLER_111_1220 VPWR VGND sg13g2_decap_4
X_19562_ _19562_/Y _19563_/B _19368_/Y _19561_/Y VPWR VGND sg13g2_o21ai_1
XFILLER_93_657 VPWR VGND sg13g2_decap_8
XFILLER_98_1340 VPWR VGND sg13g2_decap_4
X_16774_ _16774_/Y _16774_/A _16774_/B _17399_/A _16774_/D VPWR VGND sg13g2_nand4_1
XFILLER_78_1914 VPWR VGND sg13g2_decap_8
XFILLER_18_220 VPWR VGND sg13g2_fill_2
XFILLER_20_1114 VPWR VGND sg13g2_decap_8
X_13986_ _13986_/Y _22983_/Q _13979_/X _13985_/Y VPWR VGND sg13g2_o21ai_1
XFILLER_74_860 VPWR VGND sg13g2_decap_8
X_18513_ _18513_/Y _18297_/B _18224_/B _18530_/B _18517_/A _18512_/Y VPWR VGND sg13g2_a221oi_1
XFILLER_59_1313 VPWR VGND sg13g2_fill_1
X_15725_ _15726_/D _22768_/Q _15940_/B VPWR VGND sg13g2_nand2_1
XFILLER_92_178 VPWR VGND sg13g2_fill_2
XFILLER_18_264 VPWR VGND sg13g2_decap_8
XFILLER_37_90 VPWR VGND sg13g2_decap_8
X_19493_ _19519_/A _19494_/A _19493_/B VPWR VGND sg13g2_nor2_1
XFILLER_18_286 VPWR VGND sg13g2_decap_8
XFILLER_33_212 VPWR VGND sg13g2_decap_8
X_18444_ _22986_/D _18444_/A1 _18432_/B _18443_/Y VPWR VGND sg13g2_a21oi_1
X_15656_ _16121_/A _23013_/Q _22563_/Q _15982_/S VPWR VGND sg13g2_mux2_1
X_12868_ _24260_/A _14956_/A _14956_/B VPWR VGND sg13g2_and2_1
XFILLER_72_1502 VPWR VGND sg13g2_fill_2
X_14607_ _14608_/B _14573_/B _14604_/Y _14606_/Y VPWR VGND sg13g2_a21oi_1
X_11819_ _11819_/Y _12266_/A _11819_/B VPWR VGND sg13g2_nor2_1
X_18375_ _18375_/Y _18415_/B _18259_/B _18562_/B VPWR VGND sg13g2_o21ai_1
X_12799_ _12799_/X _24164_/Q _24196_/Q _23300_/Q _23332_/Q _13243_/S0 _12452_/A VPWR
+ VGND sg13g2_mux4_1
X_17326_ _17326_/Y _17326_/A _17366_/S VPWR VGND sg13g2_nand2_1
X_14538_ _14539_/B _18548_/S _18886_/A _18868_/S VPWR VGND sg13g2_mux2_1
XFILLER_15_1920 VPWR VGND sg13g2_decap_8
Xplace3205 _21323_/A1 _22418_/A1 VPWR VGND sg13g2_buf_1
Xplace3216 _22417_/B _22424_/B VPWR VGND sg13g2_buf_1
XFILLER_102_1912 VPWR VGND sg13g2_decap_8
Xplace3227 _21771_/B _21783_/B VPWR VGND sg13g2_buf_1
X_17257_ _17257_/Y _17257_/A _17266_/B VPWR VGND sg13g2_nand2_1
X_14469_ _14470_/B _18595_/A1 _22996_/Q _24225_/Q VPWR VGND sg13g2_mux2_1
Xplace3238 _21674_/B _21687_/B VPWR VGND sg13g2_buf_1
Xplace3249 _21099_/B _21151_/B VPWR VGND sg13g2_buf_1
XFILLER_50_1866 VPWR VGND sg13g2_decap_4
X_16208_ _16208_/Y _17929_/B2 _16161_/X _16207_/X VPWR VGND sg13g2_a21oi_1
XFILLER_11_1839 VPWR VGND sg13g2_decap_8
XFILLER_50_1899 VPWR VGND sg13g2_decap_8
X_17188_ _22740_/D _17197_/B _17186_/Y _17187_/Y VPWR VGND sg13g2_a21oi_1
XFILLER_85_1907 VPWR VGND sg13g2_decap_8
XFILLER_85_1918 VPWR VGND sg13g2_fill_2
XFILLER_115_523 VPWR VGND sg13g2_decap_8
XFILLER_85_1929 VPWR VGND sg13g2_decap_8
X_16139_ _22500_/D _16177_/B _16137_/Y _16138_/Y VPWR VGND sg13g2_o21ai_1
XFILLER_83_1620 VPWR VGND sg13g2_fill_2
XFILLER_45_0 VPWR VGND sg13g2_fill_2
XFILLER_88_418 VPWR VGND sg13g2_decap_8
XFILLER_102_228 VPWR VGND sg13g2_decap_8
XFILLER_9_1244 VPWR VGND sg13g2_fill_1
XFILLER_25_1003 VPWR VGND sg13g2_decap_8
XFILLER_68_120 VPWR VGND sg13g2_decap_8
XFILLER_69_643 VPWR VGND sg13g2_fill_2
XFILLER_111_751 VPWR VGND sg13g2_decap_8
XFILLER_25_1047 VPWR VGND sg13g2_decap_8
X_19829_ _19830_/B _19869_/A _19654_/B _19828_/Y VPWR VGND sg13g2_o21ai_1
XFILLER_61_1951 VPWR VGND sg13g2_decap_4
XFILLER_25_1069 VPWR VGND sg13g2_decap_8
XFILLER_57_838 VPWR VGND sg13g2_fill_1
XFILLER_68_175 VPWR VGND sg13g2_decap_8
XFILLER_22_1924 VPWR VGND sg13g2_decap_8
XFILLER_56_326 VPWR VGND sg13g2_decap_8
XFILLER_84_646 VPWR VGND sg13g2_decap_8
X_22840_ _22840_/Q clkload25/A _22840_/D fanout2900/X VPWR VGND sg13g2_dfrbpq_1
XFILLER_42_1394 VPWR VGND sg13g2_fill_1
XFILLER_25_713 VPWR VGND sg13g2_decap_8
X_22771_ _22771_/Q _22893_/CLK _22771_/D fanout2818/X VPWR VGND sg13g2_dfrbpq_1
XFILLER_52_521 VPWR VGND sg13g2_decap_8
XFILLER_64_381 VPWR VGND sg13g2_fill_1
X_21722_ _21722_/Y _23869_/Q _21725_/B VPWR VGND sg13g2_nand2_1
XFILLER_80_852 VPWR VGND sg13g2_decap_8
XFILLER_77_1479 VPWR VGND sg13g2_decap_8
XFILLER_13_908 VPWR VGND sg13g2_decap_8
XFILLER_24_245 VPWR VGND sg13g2_fill_2
XFILLER_0_1797 VPWR VGND sg13g2_decap_4
XFILLER_94_1793 VPWR VGND sg13g2_fill_1
X_21653_ _21653_/Y _21653_/A _21657_/B VPWR VGND sg13g2_nand2_1
XFILLER_52_598 VPWR VGND sg13g2_decap_8
XFILLER_55_1755 VPWR VGND sg13g2_decap_4
XFILLER_90_1646 VPWR VGND sg13g2_fill_1
XFILLER_33_790 VPWR VGND sg13g2_decap_4
XFILLER_90_1657 VPWR VGND sg13g2_decap_8
XFILLER_33_59 VPWR VGND sg13g2_fill_1
XFILLER_36_1154 VPWR VGND sg13g2_decap_8
X_21584_ _21584_/Y _21584_/A _21590_/B VPWR VGND sg13g2_nand2_1
XFILLER_107_1867 VPWR VGND sg13g2_decap_8
Xrebuffer5430 rebuffer5430/X _11669_/Y VPWR VGND sg13g2_buf_1
XFILLER_21_985 VPWR VGND sg13g2_decap_8
X_20535_ _20535_/Y _20535_/A _20539_/B VPWR VGND sg13g2_nand2_1
X_23323_ _23323_/Q _24190_/CLK _23323_/D fanout2769/X VPWR VGND sg13g2_dfrbpq_1
Xrebuffer5441 _11821_/A _11981_/A VPWR VGND sg13g2_buf_8
Xrebuffer5452 _13373_/A _13104_/Y VPWR VGND sg13g2_buf_8
Xrebuffer5463 _13932_/A _13501_/Y VPWR VGND sg13g2_buf_2
Xrebuffer5474 _16325_/A _15090_/X VPWR VGND sg13g2_buf_1
Xplace3750 _17822_/A2 _17621_/B VPWR VGND sg13g2_buf_1
Xplace3761 _13520_/A _13528_/A VPWR VGND sg13g2_buf_2
X_23254_ _23254_/Q clkload57/A _23254_/D fanout2761/X VPWR VGND sg13g2_dfrbpq_1
XFILLER_88_1542 VPWR VGND sg13g2_fill_1
Xrebuffer5485 _18659_/B1 _14931_/B1 VPWR VGND sg13g2_buf_1
Xplace3772 _19587_/A _14634_/B VPWR VGND sg13g2_buf_1
Xrebuffer5496 _19448_/A _20243_/B VPWR VGND sg13g2_buf_1
Xhold5120 _21646_/A _23837_/Q VPWR VGND sg13g2_dlygate4sd3_1
Xplace3783 _12535_/A _13854_/A VPWR VGND sg13g2_buf_1
Xplace3794 _16048_/S place3794/A VPWR VGND sg13g2_buf_2
Xhold5131 _21968_/A _23979_/Q VPWR VGND sg13g2_dlygate4sd3_1
X_22205_ _22205_/Y _22205_/A _22210_/B VPWR VGND sg13g2_nand2_1
Xhold5142 _22444_/A _24208_/Q VPWR VGND sg13g2_dlygate4sd3_1
X_23185_ _23185_/Q clkload17/A _23185_/D fanout2858/X VPWR VGND sg13g2_dfrbpq_1
XFILLER_106_545 VPWR VGND sg13g2_decap_8
Xhold5153 _20524_/A _23319_/Q VPWR VGND sg13g2_dlygate4sd3_1
XFILLER_3_138 VPWR VGND sg13g2_decap_8
Xhold5164 _21093_/A _23573_/Q VPWR VGND sg13g2_dlygate4sd3_1
Xhold5175 _20979_/A _23534_/Q VPWR VGND sg13g2_dlygate4sd3_1
X_22136_ _22136_/Y _22136_/A _22136_/B VPWR VGND sg13g2_nand2_1
Xhold5186 _22438_/A _24204_/Q VPWR VGND sg13g2_dlygate4sd3_1
XFILLER_79_418 VPWR VGND sg13g2_decap_8
Xhold5197 _22045_/A _24018_/Q VPWR VGND sg13g2_dlygate4sd3_1
XFILLER_47_1250 VPWR VGND sg13g2_decap_4
XFILLER_47_1261 VPWR VGND sg13g2_fill_2
X_22067_ _22067_/Y _22067_/A _22069_/B VPWR VGND sg13g2_nand2_1
XFILLER_7_1918 VPWR VGND sg13g2_decap_8
XFILLER_59_120 VPWR VGND sg13g2_decap_8
XFILLER_47_304 VPWR VGND sg13g2_decap_4
XFILLER_48_827 VPWR VGND sg13g2_fill_2
XFILLER_47_315 VPWR VGND sg13g2_fill_1
XFILLER_87_495 VPWR VGND sg13g2_decap_8
XFILLER_21_1423 VPWR VGND sg13g2_decap_8
X_13840_ _13840_/X _23442_/Q _23474_/Q _23506_/Q _23538_/Q _13840_/S0 _18432_/A VPWR
+ VGND sg13g2_mux4_1
XFILLER_74_22 VPWR VGND sg13g2_decap_8
XFILLER_114_84 VPWR VGND sg13g2_decap_8
XFILLER_5_1686 VPWR VGND sg13g2_decap_8
XFILLER_90_616 VPWR VGND sg13g2_fill_1
XFILLER_21_1467 VPWR VGND sg13g2_decap_4
X_13771_ _13771_/X _13770_/A _13768_/Y _13770_/Y VPWR VGND sg13g2_a21o_1
X_22969_ _22969_/Q _24212_/CLK _22969_/D fanout2919/X VPWR VGND sg13g2_dfrbpq_2
XFILLER_15_212 VPWR VGND sg13g2_decap_8
X_15510_ _15510_/Y _15577_/A _15498_/Y _15509_/Y VPWR VGND sg13g2_o21ai_1
XFILLER_71_841 VPWR VGND sg13g2_decap_8
X_12722_ _12722_/Y _12722_/A1 _12721_/X _14129_/A VPWR VGND sg13g2_o21ai_1
X_16490_ _16490_/Y _22607_/Q _16508_/B VPWR VGND sg13g2_nand2_1
XFILLER_43_554 VPWR VGND sg13g2_decap_8
XFILLER_71_863 VPWR VGND sg13g2_decap_4
XFILLER_15_256 VPWR VGND sg13g2_decap_8
XFILLER_43_565 VPWR VGND sg13g2_fill_2
XFILLER_71_885 VPWR VGND sg13g2_decap_8
X_15441_ _22456_/D _16065_/A _15440_/X _15497_/S VPWR VGND sg13g2_mux2_1
XFILLER_71_896 VPWR VGND sg13g2_fill_1
XFILLER_73_1833 VPWR VGND sg13g2_decap_8
Xinput4362 _17896_/A1 boot_addr_i[20] VPWR VGND sg13g2_buf_1
X_12653_ _12653_/Y _12460_/A _12650_/X _12652_/X VPWR VGND sg13g2_o21ai_1
XFILLER_34_1806 VPWR VGND sg13g2_decap_4
XFILLER_12_930 VPWR VGND sg13g2_fill_1
Xinput4373 _17929_/A1 boot_addr_i[31] VPWR VGND sg13g2_buf_1
XFILLER_24_790 VPWR VGND sg13g2_fill_2
XFILLER_90_54 VPWR VGND sg13g2_decap_8
Xinput4384 _20098_/A0 data_rdata_i[15] VPWR VGND sg13g2_buf_1
X_18160_ _18210_/B _18494_/A _18479_/C VPWR VGND sg13g2_and2_1
Xinput4395 _20255_/A0 data_rdata_i[25] VPWR VGND sg13g2_buf_1
XFILLER_54_1265 VPWR VGND sg13g2_decap_4
X_15372_ _15373_/D _15372_/A _15372_/B VPWR VGND sg13g2_nor2_1
XFILLER_12_963 VPWR VGND sg13g2_decap_8
X_12584_ _12584_/Y _12899_/S _12584_/B VPWR VGND sg13g2_nor2_1
X_17111_ _17112_/B _17122_/B _17115_/B VPWR VGND sg13g2_nor2b_1
X_14323_ _15478_/B _15447_/B _14369_/D VPWR VGND sg13g2_nand2_1
X_18091_ _22945_/D _18090_/Y _22945_/Q _18096_/C VPWR VGND sg13g2_mux2_1
XFILLER_32_1541 VPWR VGND sg13g2_fill_2
XFILLER_32_1563 VPWR VGND sg13g2_fill_2
X_17042_ _17043_/B _24222_/Q _17042_/B _17042_/C _17042_/D VPWR VGND sg13g2_nand4_1
XFILLER_32_1574 VPWR VGND sg13g2_fill_2
X_14254_ _14254_/Y _22580_/Q _22942_/Q _16365_/A _14742_/B VPWR VGND sg13g2_nor4_1
XFILLER_32_1585 VPWR VGND sg13g2_fill_2
XFILLER_99_63 VPWR VGND sg13g2_decap_8
X_13205_ _13206_/D _13889_/B _13204_/X _13801_/A1 VPWR VGND sg13g2_o21ai_1
X_11397_ _11397_/Y _23798_/Q _11406_/S VPWR VGND sg13g2_nand2b_1
X_14185_ _14187_/C _14175_/Y _14448_/C VPWR VGND sg13g2_nand2b_1
XFILLER_87_1074 VPWR VGND sg13g2_fill_2
XFILLER_10_1872 VPWR VGND sg13g2_decap_8
X_13136_ _14659_/A _13136_/A _13136_/B _13136_/C _13136_/D VPWR VGND sg13g2_nor4_1
XFILLER_45_1902 VPWR VGND sg13g2_fill_1
X_18993_ _18993_/Y _23056_/Q _19019_/A _19048_/B1 VPWR VGND sg13g2_o21ai_1
XFILLER_112_537 VPWR VGND sg13g2_decap_8
XFILLER_80_1815 VPWR VGND sg13g2_fill_2
XFILLER_80_1826 VPWR VGND sg13g2_decap_8
X_17944_ _17944_/Y _17965_/A _19121_/A1 VPWR VGND sg13g2_nor2b_1
X_13067_ _13067_/Y _13072_/A _13067_/B VPWR VGND sg13g2_nand2b_1
XFILLER_94_911 VPWR VGND sg13g2_decap_8
XFILLER_39_816 VPWR VGND sg13g2_decap_8
XFILLER_113_1315 VPWR VGND sg13g2_decap_8
X_12018_ _12019_/B _23451_/Q _23515_/Q _12134_/S VPWR VGND sg13g2_mux2_1
XFILLER_39_827 VPWR VGND sg13g2_fill_1
XFILLER_113_1326 VPWR VGND sg13g2_fill_2
X_17875_ _17877_/A _14936_/A _17926_/A2 _17929_/B1 _17124_/A VPWR VGND sg13g2_a22oi_1
XFILLER_61_1258 VPWR VGND sg13g2_fill_1
X_19614_ _20352_/A _24213_/Q _24214_/Q VPWR VGND sg13g2_nor2_1
X_16826_ _16826_/Y _16830_/A _16826_/B VPWR VGND sg13g2_nand2_1
XFILLER_93_465 VPWR VGND sg13g2_decap_8
XFILLER_94_999 VPWR VGND sg13g2_decap_4
X_16757_ _16796_/C _22666_/Q _22665_/Q _22664_/Q VPWR VGND sg13g2_nand3_1
X_19545_ _20112_/A _19545_/A _19721_/B _19545_/C VPWR VGND sg13g2_nand3_1
X_13969_ _13970_/B _12668_/B _13968_/Y _13383_/C VPWR VGND sg13g2_a21oi_1
XFILLER_19_595 VPWR VGND sg13g2_fill_2
XFILLER_0_63 VPWR VGND sg13g2_decap_8
XFILLER_59_1132 VPWR VGND sg13g2_decap_8
XFILLER_94_1034 VPWR VGND sg13g2_fill_1
X_15708_ _15709_/B _22733_/Q _15708_/A2 _15731_/B1 _22669_/Q VPWR VGND sg13g2_a22oi_1
X_16688_ _22652_/D _17444_/A1 _16760_/A _16687_/Y VPWR VGND sg13g2_a21oi_1
XFILLER_34_554 VPWR VGND sg13g2_fill_2
X_18427_ _18427_/Y _18427_/A _18427_/B _18427_/C VPWR VGND sg13g2_nand3_1
X_15639_ _15649_/B _22465_/Q _15639_/B VPWR VGND sg13g2_nand2_1
XFILLER_72_1310 VPWR VGND sg13g2_decap_4
XFILLER_37_1463 VPWR VGND sg13g2_fill_1
X_18358_ _18358_/X _18022_/X _18778_/B _18358_/S VPWR VGND sg13g2_mux2_1
XFILLER_33_1305 VPWR VGND sg13g2_decap_4
X_17309_ _17309_/Y _22783_/Q _17315_/B VPWR VGND sg13g2_nand2_1
Xplace3002 _22328_/B _22335_/B VPWR VGND sg13g2_buf_1
XFILLER_30_771 VPWR VGND sg13g2_decap_8
Xplace3013 _22310_/B _22316_/B VPWR VGND sg13g2_buf_1
X_18289_ _18289_/Y _18288_/A _18464_/A _18288_/Y VPWR VGND sg13g2_o21ai_1
Xplace3024 _22219_/B _22243_/S VPWR VGND sg13g2_buf_1
Xplace3035 _22069_/B _22065_/B VPWR VGND sg13g2_buf_1
Xplace3046 _22008_/B _22039_/B VPWR VGND sg13g2_buf_1
XFILLER_102_1731 VPWR VGND sg13g2_fill_1
X_20320_ _20320_/Y _14107_/A _20324_/A _20319_/Y VPWR VGND sg13g2_o21ai_1
XFILLER_31_1051 VPWR VGND sg13g2_fill_1
Xplace3057 _21982_/B place3057/A VPWR VGND sg13g2_buf_1
Xplace3068 _21848_/B _21832_/S VPWR VGND sg13g2_buf_1
XFILLER_31_1062 VPWR VGND sg13g2_decap_8
XFILLER_50_1685 VPWR VGND sg13g2_decap_8
Xplace3079 _21621_/B _21612_/B VPWR VGND sg13g2_buf_1
X_20251_ _20251_/Y _20242_/X _20248_/Y _20250_/Y VPWR VGND sg13g2_o21ai_1
XFILLER_85_1759 VPWR VGND sg13g2_decap_8
XFILLER_115_364 VPWR VGND sg13g2_decap_8
XFILLER_66_1147 VPWR VGND sg13g2_fill_2
X_20182_ _20182_/Y _20305_/A _20182_/B _20182_/C _20182_/D VPWR VGND sg13g2_nand4_1
XFILLER_115_397 VPWR VGND sg13g2_decap_8
XFILLER_48_1570 VPWR VGND sg13g2_fill_1
XFILLER_103_548 VPWR VGND sg13g2_decap_8
XFILLER_44_1412 VPWR VGND sg13g2_decap_8
X_23941_ _23941_/Q clkload45/A _23941_/D fanout2732/X VPWR VGND sg13g2_dfrbpq_1
XFILLER_57_624 VPWR VGND sg13g2_fill_1
XFILLER_57_635 VPWR VGND sg13g2_decap_8
XFILLER_61_1792 VPWR VGND sg13g2_fill_1
X_23872_ _23872_/Q clkload43/A _23872_/D fanout2770/X VPWR VGND sg13g2_dfrbpq_1
XFILLER_113_1871 VPWR VGND sg13g2_decap_8
XFILLER_56_156 VPWR VGND sg13g2_decap_8
XFILLER_42_1191 VPWR VGND sg13g2_decap_4
XFILLER_38_871 VPWR VGND sg13g2_decap_8
X_22823_ _22823_/Q _22869_/CLK _22823_/D fanout2796/X VPWR VGND sg13g2_dfrbpq_1
XFILLER_2_1848 VPWR VGND sg13g2_decap_8
XFILLER_25_510 VPWR VGND sg13g2_decap_8
XFILLER_72_638 VPWR VGND sg13g2_decap_4
XFILLER_53_830 VPWR VGND sg13g2_decap_8
XFILLER_25_532 VPWR VGND sg13g2_decap_4
XFILLER_71_148 VPWR VGND sg13g2_decap_4
X_22754_ _22754_/Q clkload25/A _22754_/D fanout2885/X VPWR VGND sg13g2_dfrbpq_1
XFILLER_53_863 VPWR VGND sg13g2_decap_8
XFILLER_109_1918 VPWR VGND sg13g2_decap_8
XFILLER_52_351 VPWR VGND sg13g2_decap_4
XFILLER_25_576 VPWR VGND sg13g2_fill_1
XFILLER_73_1129 VPWR VGND sg13g2_decap_8
XFILLER_44_69 VPWR VGND sg13g2_decap_8
X_22685_ _22685_/Q clkload24/A _22685_/D fanout2889/X VPWR VGND sg13g2_dfrbpq_1
XFILLER_12_226 VPWR VGND sg13g2_decap_8
XFILLER_52_395 VPWR VGND sg13g2_fill_1
XFILLER_100_42 VPWR VGND sg13g2_decap_8
X_21636_ _23832_/D _21930_/A1 _21635_/B _21635_/Y VPWR VGND sg13g2_o21ai_1
XFILLER_8_208 VPWR VGND sg13g2_decap_8
XFILLER_90_1476 VPWR VGND sg13g2_decap_8
X_21567_ _23799_/D _21928_/A1 _21574_/B _21566_/Y VPWR VGND sg13g2_o21ai_1
XFILLER_103_1528 VPWR VGND sg13g2_decap_8
Xplace4270 _11346_/A _13981_/S1 VPWR VGND sg13g2_buf_2
X_23306_ _23306_/Q clkload34/A _23306_/D fanout2696/X VPWR VGND sg13g2_dfrbpq_1
Xrebuffer5260 _13404_/B _13403_/Y VPWR VGND sg13g2_buf_8
Xplace4281 _13671_/B _11387_/A VPWR VGND sg13g2_buf_1
XFILLER_14_1271 VPWR VGND sg13g2_decap_8
Xrebuffer5271 _15033_/A1 _15032_/Y VPWR VGND sg13g2_buf_2
XFILLER_33_1894 VPWR VGND sg13g2_fill_2
Xplace4292 _13621_/S _11387_/A VPWR VGND sg13g2_buf_4
X_21498_ _21498_/Y _23766_/Q _21508_/B VPWR VGND sg13g2_nand2_1
Xrebuffer5282 _13569_/B _13568_/Y VPWR VGND sg13g2_buf_8
XFILLER_68_1913 VPWR VGND sg13g2_decap_8
Xrebuffer5293 _15799_/A _13247_/Y VPWR VGND sg13g2_buf_1
Xplace3580 _20307_/A _20112_/A VPWR VGND sg13g2_buf_1
XFILLER_107_843 VPWR VGND sg13g2_decap_4
Xplace3591 _19872_/A _19757_/A VPWR VGND sg13g2_buf_1
X_11251_ _11251_/Y _11270_/B _11249_/X _19360_/A _11250_/Y VPWR VGND sg13g2_a22oi_1
X_20449_ _20449_/Y _20449_/A _20451_/B VPWR VGND sg13g2_nand2_1
X_23237_ _23237_/Q clkload34/A _23237_/D fanout2699/X VPWR VGND sg13g2_dfrbpq_1
Xrebuffer4570 _12628_/A2 _12461_/Y VPWR VGND sg13g2_buf_8
Xrebuffer4581 _19727_/S _11983_/D VPWR VGND sg13g2_buf_1
XFILLER_10_1168 VPWR VGND sg13g2_fill_1
Xrebuffer4592 _12934_/A _12950_/B VPWR VGND sg13g2_buf_1
XFILLER_109_84 VPWR VGND sg13g2_decap_8
XFILLER_107_876 VPWR VGND sg13g2_decap_8
XFILLER_101_1285 VPWR VGND sg13g2_decap_8
XFILLER_69_44 VPWR VGND sg13g2_fill_2
X_11182_ _11305_/B _22970_/Q _11311_/B VPWR VGND sg13g2_nor2b_1
X_23168_ _23168_/Q clkload15/A _23168_/D fanout2857/X VPWR VGND sg13g2_dfrbpq_1
XFILLER_69_66 VPWR VGND sg13g2_decap_8
XFILLER_0_620 VPWR VGND sg13g2_fill_2
XFILLER_62_1501 VPWR VGND sg13g2_fill_1
XFILLER_7_1704 VPWR VGND sg13g2_decap_8
X_22119_ _22175_/B _22119_/A _22252_/B VPWR VGND sg13g2_nand2_1
X_23099_ _23099_/Q clkload14/A _23099_/D fanout2903/X VPWR VGND sg13g2_dfrbpq_1
X_15990_ _15993_/B _14743_/A _15969_/B _15359_/Y _22835_/Q VPWR VGND sg13g2_a22oi_1
XFILLER_0_653 VPWR VGND sg13g2_fill_2
XFILLER_27_1654 VPWR VGND sg13g2_decap_8
XFILLER_88_771 VPWR VGND sg13g2_decap_4
X_14941_ _14941_/Y _14934_/Y _18602_/A _14940_/Y _14935_/Y VPWR VGND sg13g2_a22oi_1
XFILLER_85_32 VPWR VGND sg13g2_decap_8
XFILLER_85_43 VPWR VGND sg13g2_fill_1
XFILLER_62_1589 VPWR VGND sg13g2_fill_1
XFILLER_47_145 VPWR VGND sg13g2_decap_8
X_14872_ _14872_/Y _14872_/A _22917_/Q VPWR VGND sg13g2_nor2b_1
XFILLER_78_1007 VPWR VGND sg13g2_decap_8
X_16611_ _22637_/D _17480_/A1 _16610_/A _16610_/Y VPWR VGND sg13g2_a21oi_1
XFILLER_35_318 VPWR VGND sg13g2_decap_8
X_13823_ _13823_/X _23730_/Q _23762_/Q _23794_/Q _23826_/Q _13173_/S _13981_/S1 VPWR
+ VGND sg13g2_mux4_1
X_17591_ _17591_/Y _17622_/A _22953_/Q VPWR VGND sg13g2_nand2_1
XFILLER_40_1898 VPWR VGND sg13g2_fill_1
X_16542_ _16542_/Y _16547_/A _16542_/B VPWR VGND sg13g2_nor2_1
X_19330_ _19330_/Y _20034_/A _19412_/B _19329_/Y VPWR VGND sg13g2_a21oi_1
X_13754_ _13755_/D _13753_/A _13753_/Y _13947_/A VPWR VGND sg13g2_mux2_1
XFILLER_31_502 VPWR VGND sg13g2_fill_1
X_19261_ _19262_/B _23192_/Q _19261_/B _19261_/C VPWR VGND sg13g2_nand3_1
XFILLER_44_896 VPWR VGND sg13g2_decap_4
X_12705_ _12705_/X _23843_/Q _23875_/Q _23939_/Q _23971_/Q _12909_/B _13242_/S1 VPWR
+ VGND sg13g2_mux4_1
X_16473_ _22599_/D _17872_/A _16472_/B _16472_/Y VPWR VGND sg13g2_o21ai_1
X_13685_ _13686_/B _23920_/Q _24016_/Q _24112_/Q _24144_/Q _13974_/S _13978_/S1 VPWR
+ VGND sg13g2_mux4_1
XFILLER_73_1630 VPWR VGND sg13g2_decap_4
X_18212_ _18212_/Y _18399_/A _18344_/B _18530_/A VPWR VGND sg13g2_a21oi_1
X_15424_ _16681_/C _15424_/A _15424_/B _15625_/B VPWR VGND sg13g2_and3_1
XFILLER_31_557 VPWR VGND sg13g2_decap_4
XFILLER_19_1171 VPWR VGND sg13g2_decap_8
X_19192_ _19229_/S _14587_/Y _19189_/Y _19191_/Y VPWR VGND sg13g2_a21oi_1
X_12636_ _12636_/Y _12829_/B _12512_/B _12524_/X _19430_/A _12526_/Y VPWR VGND sg13g2_a221oi_1
Xoutput4507 data_wdata_o[13] _14712_/X VPWR VGND sg13g2_buf_1
XFILLER_54_1073 VPWR VGND sg13g2_decap_4
Xoutput4518 data_wdata_o[23] _14731_/X VPWR VGND sg13g2_buf_1
XFILLER_12_793 VPWR VGND sg13g2_fill_1
XFILLER_11_270 VPWR VGND sg13g2_decap_8
Xoutput4529 data_wdata_o[4] _14669_/X VPWR VGND sg13g2_buf_1
X_12567_ _12567_/Y _12567_/A _23905_/Q VPWR VGND sg13g2_nor2b_1
X_11518_ _11518_/X _24021_/Q _24085_/Q _13797_/S VPWR VGND sg13g2_mux2_1
X_18074_ _18074_/Y _18071_/Y _18072_/Y _18553_/A1 VPWR VGND sg13g2_o21ai_1
X_12498_ _12499_/B _24192_/Q _23328_/Q _12498_/S VPWR VGND sg13g2_mux2_1
X_17025_ _17025_/Y _22714_/Q _17025_/B VPWR VGND sg13g2_xnor2_1
X_14237_ _14407_/A _14782_/A _14199_/Y _14236_/Y VPWR VGND sg13g2_o21ai_1
X_11449_ _12486_/A _22984_/Q _11449_/B VPWR VGND sg13g2_nand2_2
XFILLER_98_502 VPWR VGND sg13g2_decap_4
XFILLER_113_813 VPWR VGND sg13g2_decap_8
X_14168_ _16856_/B _14196_/B _14274_/A VPWR VGND sg13g2_nand2_1
XFILLER_112_312 VPWR VGND sg13g2_decap_8
XFILLER_63_1309 VPWR VGND sg13g2_fill_2
XFILLER_98_535 VPWR VGND sg13g2_fill_2
XFILLER_98_546 VPWR VGND sg13g2_decap_8
X_13119_ _13120_/B _23912_/Q _24008_/Q _24104_/Q _24136_/Q _13610_/S0 _13115_/A VPWR
+ VGND sg13g2_mux4_1
Xclkbuf_4_12__f_clk_i clkbuf_leaf_43_clk_i/A clkbuf_3_6_0_clk_i/X VPWR VGND sg13g2_buf_8
X_18976_ _18977_/B _18975_/Y _23055_/Q _19001_/C VPWR VGND sg13g2_mux2_1
X_14099_ _14099_/Y _19608_/A _19480_/B VPWR VGND sg13g2_nand2b_1
XFILLER_61_1011 VPWR VGND sg13g2_fill_2
XFILLER_79_771 VPWR VGND sg13g2_decap_8
XFILLER_100_518 VPWR VGND sg13g2_decap_8
XFILLER_85_229 VPWR VGND sg13g2_decap_8
X_17927_ _17928_/B _22940_/Q _17927_/B VPWR VGND sg13g2_nand2_1
XFILLER_26_1164 VPWR VGND sg13g2_fill_1
XFILLER_39_624 VPWR VGND sg13g2_decap_8
XFILLER_66_410 VPWR VGND sg13g2_fill_1
XFILLER_78_281 VPWR VGND sg13g2_fill_1
XFILLER_61_1066 VPWR VGND sg13g2_fill_2
XFILLER_67_955 VPWR VGND sg13g2_decap_8
XFILLER_26_1197 VPWR VGND sg13g2_decap_8
XFILLER_22_1039 VPWR VGND sg13g2_decap_8
XFILLER_27_819 VPWR VGND sg13g2_decap_8
X_17858_ _17858_/Y _17858_/A _17869_/B VPWR VGND sg13g2_nor2_1
XFILLER_66_476 VPWR VGND sg13g2_decap_8
XFILLER_93_262 VPWR VGND sg13g2_decap_8
XFILLER_82_947 VPWR VGND sg13g2_decap_8
XFILLER_81_413 VPWR VGND sg13g2_fill_1
X_16809_ _16810_/B _16812_/A _16809_/B VPWR VGND sg13g2_xnor2_1
XFILLER_93_284 VPWR VGND sg13g2_decap_8
X_17789_ _17789_/Y _17789_/A _17789_/B VPWR VGND sg13g2_nor2_1
XFILLER_81_446 VPWR VGND sg13g2_fill_2
XFILLER_19_392 VPWR VGND sg13g2_fill_2
XFILLER_53_148 VPWR VGND sg13g2_decap_8
XFILLER_35_852 VPWR VGND sg13g2_decap_8
XFILLER_1_1881 VPWR VGND sg13g2_decap_8
XFILLER_39_1558 VPWR VGND sg13g2_decap_8
XFILLER_50_811 VPWR VGND sg13g2_decap_8
X_19459_ _19459_/X _19704_/A _19459_/B VPWR VGND sg13g2_and2_1
XFILLER_34_384 VPWR VGND sg13g2_decap_4
XFILLER_91_1741 VPWR VGND sg13g2_decap_8
XFILLER_61_192 VPWR VGND sg13g2_decap_8
X_22470_ _22470_/Q clkload8/A _22470_/D fanout2806/X VPWR VGND sg13g2_dfrbpq_1
XFILLER_50_877 VPWR VGND sg13g2_fill_2
X_21421_ _23731_/D _23731_/Q _21781_/A1 _21421_/S VPWR VGND sg13g2_mux2_1
XFILLER_17_1878 VPWR VGND sg13g2_decap_8
XFILLER_104_1859 VPWR VGND sg13g2_decap_8
X_21352_ _23699_/D _22249_/A0 _23699_/Q _21352_/S VPWR VGND sg13g2_mux2_1
X_24140_ _24140_/Q _24210_/CLK _24140_/D fanout2642/X VPWR VGND sg13g2_dfrbpq_1
XFILLER_108_629 VPWR VGND sg13g2_decap_8
XFILLER_50_1493 VPWR VGND sg13g2_decap_8
X_20303_ _20305_/B _13854_/B _19835_/Y _19837_/Y _13864_/Y VPWR VGND sg13g2_a22oi_1
X_21283_ _23665_/D _21617_/A0 _23665_/Q _21286_/S VPWR VGND sg13g2_mux2_1
XFILLER_89_1681 VPWR VGND sg13g2_fill_1
X_24071_ _24071_/Q _24170_/CLK _24071_/D fanout2708/X VPWR VGND sg13g2_dfrbpq_1
XFILLER_85_1545 VPWR VGND sg13g2_decap_4
X_23022_ _23022_/Q clkload11/A _23022_/D fanout2836/X VPWR VGND sg13g2_dfrbpq_1
X_20234_ _20234_/Y _20234_/A _20234_/B VPWR VGND sg13g2_nand2_1
XFILLER_115_161 VPWR VGND sg13g2_decap_8
XFILLER_104_835 VPWR VGND sg13g2_fill_1
XFILLER_104_846 VPWR VGND sg13g2_fill_1
XFILLER_89_546 VPWR VGND sg13g2_decap_4
XFILLER_104_868 VPWR VGND sg13g2_fill_2
X_20165_ _20165_/Y _20166_/B _20163_/Y _20164_/Y VPWR VGND sg13g2_o21ai_1
XFILLER_76_207 VPWR VGND sg13g2_decap_8
XFILLER_39_69 VPWR VGND sg13g2_decap_8
X_20096_ _20106_/C _19911_/X _20095_/X _23195_/Q VPWR VGND sg13g2_mux2_1
XFILLER_58_944 VPWR VGND sg13g2_decap_8
XFILLER_69_281 VPWR VGND sg13g2_decap_4
XFILLER_111_1808 VPWR VGND sg13g2_decap_8
XFILLER_57_432 VPWR VGND sg13g2_fill_1
XFILLER_98_1917 VPWR VGND sg13g2_decap_8
XFILLER_18_808 VPWR VGND sg13g2_fill_2
X_23924_ _23924_/Q clkload16/A _23924_/D fanout2623/X VPWR VGND sg13g2_dfrbpq_1
XFILLER_73_903 VPWR VGND sg13g2_decap_8
XFILLER_6_1770 VPWR VGND sg13g2_decap_8
XFILLER_17_307 VPWR VGND sg13g2_decap_8
XFILLER_22_1540 VPWR VGND sg13g2_decap_8
X_23855_ _23855_/Q clkload31/A _23855_/D fanout2656/X VPWR VGND sg13g2_dfrbpq_1
XFILLER_73_969 VPWR VGND sg13g2_decap_4
XFILLER_2_1667 VPWR VGND sg13g2_fill_2
X_22806_ _22806_/Q clkload10/A _22806_/D fanout2813/X VPWR VGND sg13g2_dfrbpq_1
XFILLER_72_457 VPWR VGND sg13g2_decap_8
X_23786_ _23786_/Q clkload45/A _23786_/D fanout2733/X VPWR VGND sg13g2_dfrbpq_1
X_20998_ _23541_/D _19526_/Y _21013_/B _20997_/Y VPWR VGND sg13g2_o21ai_1
XFILLER_81_980 VPWR VGND sg13g2_decap_4
XFILLER_77_1073 VPWR VGND sg13g2_fill_2
XFILLER_26_885 VPWR VGND sg13g2_decap_8
XFILLER_92_1538 VPWR VGND sg13g2_decap_4
XFILLER_18_1609 VPWR VGND sg13g2_decap_8
XFILLER_38_1035 VPWR VGND sg13g2_decap_8
XFILLER_57_1658 VPWR VGND sg13g2_decap_4
XFILLER_111_63 VPWR VGND sg13g2_decap_8
X_22737_ _22737_/Q clkload21/A _22737_/D fanout2874/X VPWR VGND sg13g2_dfrbpq_1
XFILLER_35_1901 VPWR VGND sg13g2_fill_1
XFILLER_25_395 VPWR VGND sg13g2_fill_1
XFILLER_40_332 VPWR VGND sg13g2_decap_8
XFILLER_41_877 VPWR VGND sg13g2_fill_2
X_13470_ _13539_/B _13649_/A _14645_/A VPWR VGND sg13g2_nand2_1
XFILLER_70_1814 VPWR VGND sg13g2_fill_2
X_22668_ _22668_/Q _22733_/CLK _22668_/D fanout2880/X VPWR VGND sg13g2_dfrbpq_1
XFILLER_51_1202 VPWR VGND sg13g2_decap_8
XFILLER_55_1382 VPWR VGND sg13g2_fill_2
XFILLER_90_1273 VPWR VGND sg13g2_fill_2
X_12421_ _19930_/A _19928_/A _19928_/B VPWR VGND sg13g2_nand2b_1
X_21619_ _23826_/D _21619_/A1 _21621_/B _21618_/Y VPWR VGND sg13g2_o21ai_1
XFILLER_107_1483 VPWR VGND sg13g2_decap_8
X_22599_ _22599_/Q clkload28/A _22599_/D fanout2873/X VPWR VGND sg13g2_dfrbpq_1
XFILLER_51_1268 VPWR VGND sg13g2_fill_2
X_15140_ _15447_/C _15140_/A _15140_/B _15140_/C VPWR VGND sg13g2_or3_1
X_12352_ _12353_/B _12352_/A _12352_/B VPWR VGND sg13g2_nand2_1
XFILLER_5_723 VPWR VGND sg13g2_fill_1
XFILLER_112_0 VPWR VGND sg13g2_decap_8
XFILLER_5_734 VPWR VGND sg13g2_decap_8
X_11303_ _19361_/A _11254_/Y _11265_/Y _11302_/X VPWR VGND sg13g2_a21o_1
X_15071_ _16318_/A _15071_/A _15071_/B VPWR VGND sg13g2_or2_2
X_12283_ _12300_/A _12606_/A _12283_/B VPWR VGND sg13g2_nor2_1
X_24269_ _24269_/X _24269_/A VPWR VGND sg13g2_buf_1
XFILLER_49_1131 VPWR VGND sg13g2_fill_2
X_14022_ _14618_/A _14634_/B _14022_/B VPWR VGND sg13g2_nand2_1
XFILLER_84_1033 VPWR VGND sg13g2_fill_2
X_11234_ _11234_/X _11502_/A _11234_/B _11234_/C VPWR VGND sg13g2_and3_1
XFILLER_106_161 VPWR VGND sg13g2_decap_8
XFILLER_45_1017 VPWR VGND sg13g2_fill_2
X_18830_ _18832_/B _18828_/Y _18829_/Y _18857_/S VPWR VGND sg13g2_mux2_1
XFILLER_45_1028 VPWR VGND sg13g2_decap_8
XFILLER_96_42 VPWR VGND sg13g2_decap_8
XFILLER_95_505 VPWR VGND sg13g2_decap_8
XFILLER_84_1099 VPWR VGND sg13g2_decap_8
X_15973_ _15973_/Y _22681_/Q _16774_/D _17056_/C _22745_/Q VPWR VGND sg13g2_a22oi_1
X_18761_ _18865_/C _18048_/S _18587_/C _18771_/B VPWR VGND sg13g2_o21ai_1
XFILLER_48_432 VPWR VGND sg13g2_fill_2
XFILLER_114_1454 VPWR VGND sg13g2_fill_2
X_17712_ _17712_/Y _17712_/A _17825_/B VPWR VGND sg13g2_nor2_1
X_18692_ _18692_/Y _18694_/B _18692_/B VPWR VGND sg13g2_nand2b_1
XFILLER_49_988 VPWR VGND sg13g2_decap_8
XFILLER_49_999 VPWR VGND sg13g2_fill_2
XFILLER_64_925 VPWR VGND sg13g2_fill_2
XFILLER_76_796 VPWR VGND sg13g2_decap_4
X_14855_ _14855_/Y _14872_/A _14853_/Y _14854_/Y VPWR VGND sg13g2_a21oi_1
X_17643_ _22887_/D _17642_/B _17641_/Y _17642_/Y VPWR VGND sg13g2_a21oi_1
XFILLER_21_1050 VPWR VGND sg13g2_fill_2
XFILLER_40_1673 VPWR VGND sg13g2_decap_8
XFILLER_91_744 VPWR VGND sg13g2_fill_1
XFILLER_90_221 VPWR VGND sg13g2_decap_8
XFILLER_79_1861 VPWR VGND sg13g2_decap_8
XFILLER_21_1072 VPWR VGND sg13g2_decap_8
X_13806_ _13867_/C _13717_/B _13805_/Y _13350_/A VPWR VGND sg13g2_a21oi_1
X_17574_ _17574_/Y _14121_/A _17573_/A _17573_/Y VPWR VGND sg13g2_o21ai_1
XFILLER_51_619 VPWR VGND sg13g2_fill_1
X_14786_ _14786_/Y _22942_/Q _14786_/B VPWR VGND sg13g2_nor2_1
XFILLER_75_1725 VPWR VGND sg13g2_decap_8
X_11998_ _12084_/C _11998_/A _12965_/B VPWR VGND sg13g2_and2_1
X_19313_ _21087_/B _20367_/A _20367_/B _22971_/Q VPWR VGND sg13g2_a21oi_1
XFILLER_44_682 VPWR VGND sg13g2_decap_8
XFILLER_45_90 VPWR VGND sg13g2_decap_4
X_13737_ _13877_/B _13732_/Y _13735_/Y _13736_/Y VPWR VGND sg13g2_a21o_1
XFILLER_95_1195 VPWR VGND sg13g2_decap_4
XFILLER_32_833 VPWR VGND sg13g2_decap_8
XFILLER_71_490 VPWR VGND sg13g2_decap_8
XFILLER_32_866 VPWR VGND sg13g2_fill_2
X_16456_ _16456_/Y _22592_/Q _16456_/B VPWR VGND sg13g2_nand2_1
X_19244_ _19244_/Y _19257_/B _19263_/A VPWR VGND sg13g2_nor2b_1
X_13668_ _13668_/Y _22575_/Q _13692_/B _13988_/B1 VPWR VGND sg13g2_o21ai_1
XFILLER_38_1580 VPWR VGND sg13g2_decap_8
X_15407_ _15407_/Y _15407_/A _15950_/B VPWR VGND sg13g2_nor2_1
X_19175_ _23146_/D _23146_/Q _15033_/X _19181_/S VPWR VGND sg13g2_mux2_1
X_16387_ _22558_/D _23008_/Q _22558_/Q _18657_/B VPWR VGND sg13g2_mux2_1
X_13599_ _13599_/Y _23181_/Q _13988_/A2 _13924_/B1 _13598_/X VPWR VGND sg13g2_a22oi_1
X_18126_ _22956_/D _18140_/B _18071_/A _18125_/Y VPWR VGND sg13g2_o21ai_1
X_15338_ _15338_/X _16879_/A _22453_/Q _15589_/S VPWR VGND sg13g2_mux2_1
X_18057_ _18189_/B _18071_/A _18174_/B VPWR VGND sg13g2_and2_1
X_15269_ _17056_/B _16789_/A _15269_/B _16789_/C _17042_/C VPWR VGND sg13g2_and4_1
XFILLER_99_811 VPWR VGND sg13g2_decap_8
X_17008_ _17013_/B _22710_/Q _22709_/Q _22708_/Q _17008_/D VPWR VGND sg13g2_and4_1
XFILLER_47_1816 VPWR VGND sg13g2_fill_2
XFILLER_67_1242 VPWR VGND sg13g2_decap_8
XFILLER_113_610 VPWR VGND sg13g2_decap_8
XFILLER_99_855 VPWR VGND sg13g2_fill_1
XFILLER_63_1128 VPWR VGND sg13g2_fill_2
XFILLER_28_1259 VPWR VGND sg13g2_fill_1
XFILLER_59_719 VPWR VGND sg13g2_decap_4
XFILLER_86_505 VPWR VGND sg13g2_decap_8
XFILLER_45_1540 VPWR VGND sg13g2_decap_8
XFILLER_113_687 VPWR VGND sg13g2_decap_8
XFILLER_112_175 VPWR VGND sg13g2_decap_8
XFILLER_86_538 VPWR VGND sg13g2_decap_8
XFILLER_86_549 VPWR VGND sg13g2_fill_2
X_18959_ _18959_/Y _18959_/A _23085_/Q _18959_/C VPWR VGND sg13g2_nand3_1
XFILLER_39_421 VPWR VGND sg13g2_decap_8
XFILLER_67_730 VPWR VGND sg13g2_fill_1
XFILLER_6_1055 VPWR VGND sg13g2_decap_8
XFILLER_39_443 VPWR VGND sg13g2_decap_8
XFILLER_80_1497 VPWR VGND sg13g2_decap_8
X_21970_ _21970_/Y _21970_/A _21976_/B VPWR VGND sg13g2_nand2_1
XFILLER_6_1077 VPWR VGND sg13g2_decap_8
XFILLER_27_616 VPWR VGND sg13g2_decap_4
XFILLER_3_1932 VPWR VGND sg13g2_decap_8
XFILLER_6_1099 VPWR VGND sg13g2_decap_8
X_20921_ _20921_/Y _22252_/A _20921_/B VPWR VGND sg13g2_nand2_1
XFILLER_54_424 VPWR VGND sg13g2_decap_4
XFILLER_110_1852 VPWR VGND sg13g2_decap_8
XFILLER_54_446 VPWR VGND sg13g2_decap_8
X_23640_ _23640_/Q clkload57/A _23640_/D fanout2764/X VPWR VGND sg13g2_dfrbpq_1
X_20852_ _23475_/D _23475_/Q _21781_/A1 _20852_/S VPWR VGND sg13g2_mux2_1
XFILLER_54_468 VPWR VGND sg13g2_decap_8
XFILLER_42_619 VPWR VGND sg13g2_decap_8
XFILLER_70_928 VPWR VGND sg13g2_fill_2
XFILLER_78_1382 VPWR VGND sg13g2_fill_1
XFILLER_70_939 VPWR VGND sg13g2_fill_2
XFILLER_25_49 VPWR VGND sg13g2_decap_8
XFILLER_23_822 VPWR VGND sg13g2_fill_2
X_23571_ _23571_/Q clkload47/A _23571_/D fanout2662/X VPWR VGND sg13g2_dfrbpq_1
XFILLER_41_129 VPWR VGND sg13g2_decap_8
X_20783_ _23443_/D _23443_/Q _21781_/A1 _20783_/S VPWR VGND sg13g2_mux2_1
XFILLER_39_1366 VPWR VGND sg13g2_decap_8
XFILLER_62_490 VPWR VGND sg13g2_decap_4
XFILLER_74_1257 VPWR VGND sg13g2_decap_4
XFILLER_34_192 VPWR VGND sg13g2_decap_8
X_22522_ _22522_/Q clkload11/A _22522_/D fanout2834/X VPWR VGND sg13g2_dfrbpq_1
XFILLER_50_652 VPWR VGND sg13g2_fill_2
XFILLER_50_674 VPWR VGND sg13g2_decap_8
XFILLER_52_1511 VPWR VGND sg13g2_decap_8
XFILLER_52_1522 VPWR VGND sg13g2_fill_1
XFILLER_50_696 VPWR VGND sg13g2_fill_2
XFILLER_52_1544 VPWR VGND sg13g2_decap_8
X_22453_ _22453_/Q clkload28/A _22453_/D fanout2829/X VPWR VGND sg13g2_dfrbpq_1
XFILLER_13_1517 VPWR VGND sg13g2_decap_8
XFILLER_52_1566 VPWR VGND sg13g2_fill_1
X_21404_ _23720_/D _23720_/Q _21898_/A0 _21421_/S VPWR VGND sg13g2_mux2_1
X_22384_ _24180_/D _22451_/A1 _22383_/B _22383_/Y VPWR VGND sg13g2_o21ai_1
X_24123_ _24123_/Q clkload48/A _24123_/D fanout2691/X VPWR VGND sg13g2_dfrbpq_1
X_21335_ _23688_/D _21335_/A0 _23688_/Q _21352_/S VPWR VGND sg13g2_mux2_1
XFILLER_85_1320 VPWR VGND sg13g2_fill_1
XFILLER_30_1897 VPWR VGND sg13g2_decap_4
XFILLER_104_610 VPWR VGND sg13g2_decap_8
XFILLER_65_1916 VPWR VGND sg13g2_fill_2
X_24054_ _24054_/Q clkload46/A _24054_/D fanout2676/X VPWR VGND sg13g2_dfrbpq_1
XFILLER_89_310 VPWR VGND sg13g2_decap_8
X_21266_ _21266_/Y _21266_/A _21266_/B VPWR VGND sg13g2_nand2_1
Xfanout2707 fanout2707/X fanout2709/X VPWR VGND sg13g2_buf_1
Xfanout2718 fanout2718/X fanout2721/X VPWR VGND sg13g2_buf_1
X_23005_ _23005_/Q clkload15/A _23005_/D fanout2853/X VPWR VGND sg13g2_dfrbpq_1
Xfanout2729 fanout2729/X fanout2731/X VPWR VGND sg13g2_buf_1
X_20217_ _20217_/Y _20207_/Y _20214_/Y _20216_/Y _20266_/A1 VPWR VGND sg13g2_a22oi_1
XFILLER_89_354 VPWR VGND sg13g2_decap_8
X_21197_ _21197_/Y _21197_/A _21197_/B VPWR VGND sg13g2_nand2_1
XFILLER_46_1359 VPWR VGND sg13g2_decap_8
XFILLER_8_1832 VPWR VGND sg13g2_decap_8
X_20148_ _20153_/A _13077_/D _19835_/Y _19837_/Y _20147_/Y VPWR VGND sg13g2_a22oi_1
XFILLER_106_63 VPWR VGND sg13g2_decap_8
XFILLER_103_175 VPWR VGND sg13g2_fill_1
XFILLER_44_1072 VPWR VGND sg13g2_decap_8
XFILLER_115_1763 VPWR VGND sg13g2_decap_8
XFILLER_4_1718 VPWR VGND sg13g2_decap_8
XFILLER_58_752 VPWR VGND sg13g2_fill_1
X_20079_ _23235_/D _20269_/B _20685_/A1 _20078_/Y VPWR VGND sg13g2_o21ai_1
XFILLER_57_262 VPWR VGND sg13g2_fill_2
XFILLER_66_78 VPWR VGND sg13g2_decap_8
X_11921_ _11921_/Y _11921_/A _11921_/B _11921_/C VPWR VGND sg13g2_nor3_1
X_23907_ _23907_/Q _24131_/CLK _23907_/D fanout2745/X VPWR VGND sg13g2_dfrbpq_1
XFILLER_66_89 VPWR VGND sg13g2_decap_8
XFILLER_18_638 VPWR VGND sg13g2_decap_8
XFILLER_46_947 VPWR VGND sg13g2_fill_2
XFILLER_98_1769 VPWR VGND sg13g2_fill_1
XFILLER_46_958 VPWR VGND sg13g2_decap_4
X_14640_ _14640_/Y _14631_/B _14637_/Y _14639_/Y VPWR VGND sg13g2_o21ai_1
X_23838_ _23838_/Q _23966_/CLK _23838_/D fanout2784/X VPWR VGND sg13g2_dfrbpq_1
X_11852_ _11857_/B _12245_/A _11852_/B VPWR VGND sg13g2_nor2_1
XFILLER_26_660 VPWR VGND sg13g2_fill_1
XFILLER_109_1512 VPWR VGND sg13g2_fill_1
X_14571_ _14572_/B _14571_/A _14571_/B VPWR VGND sg13g2_nor2_1
X_23769_ _23769_/Q _23966_/CLK _23769_/D fanout2783/X VPWR VGND sg13g2_dfrbpq_1
XFILLER_13_332 VPWR VGND sg13g2_decap_4
X_16310_ _16314_/A _16323_/C VPWR VGND sg13g2_inv_1
XFILLER_92_1368 VPWR VGND sg13g2_fill_1
X_13522_ _13523_/A _13522_/A _13522_/B _13522_/C _13522_/D VPWR VGND sg13g2_nor4_1
X_17290_ _22774_/D _16175_/A _17293_/B _17289_/Y VPWR VGND sg13g2_o21ai_1
XFILLER_74_1780 VPWR VGND sg13g2_fill_1
X_16241_ _16253_/C _16241_/A _16241_/B _16241_/C _16241_/D VPWR VGND sg13g2_nand4_1
X_13453_ _13453_/X _13632_/A _13453_/B VPWR VGND sg13g2_or2_1
XFILLER_31_1617 VPWR VGND sg13g2_fill_2
XFILLER_40_195 VPWR VGND sg13g2_decap_4
XFILLER_12_1005 VPWR VGND sg13g2_decap_8
X_12404_ _12404_/X _23903_/Q _23999_/Q _12404_/S VPWR VGND sg13g2_mux2_1
X_16172_ _22505_/D _16145_/B _16170_/Y _16171_/Y VPWR VGND sg13g2_o21ai_1
X_15123_ _15123_/Y _19150_/A _15123_/B VPWR VGND sg13g2_nand2_1
XFILLER_5_520 VPWR VGND sg13g2_decap_8
XFILLER_115_908 VPWR VGND sg13g2_decap_8
XFILLER_86_1117 VPWR VGND sg13g2_decap_8
X_12335_ _12347_/B _12428_/C _14387_/B VPWR VGND sg13g2_xnor2_1
XFILLER_103_1188 VPWR VGND sg13g2_fill_1
XFILLER_86_1128 VPWR VGND sg13g2_fill_2
XFILLER_108_960 VPWR VGND sg13g2_fill_2
X_19931_ _19941_/B _19861_/B _19929_/Y _19930_/Y VPWR VGND sg13g2_a21oi_1
X_15054_ _15054_/Y _22537_/Q VPWR VGND sg13g2_inv_1
XFILLER_99_129 VPWR VGND sg13g2_decap_8
X_12266_ _14321_/B _12266_/A _14686_/A VPWR VGND sg13g2_nor2_1
XFILLER_49_7 VPWR VGND sg13g2_decap_8
XFILLER_64_1404 VPWR VGND sg13g2_decap_8
XFILLER_107_492 VPWR VGND sg13g2_decap_8
X_14005_ _14008_/B _14005_/A _14005_/B VPWR VGND sg13g2_or2_1
X_11217_ _11217_/Y _14240_/A _11258_/B _11212_/Y _11205_/A _11243_/A VPWR VGND sg13g2_a221oi_1
X_19862_ _19862_/Y _19861_/A _19978_/B _19861_/Y VPWR VGND sg13g2_o21ai_1
X_12197_ _12197_/Y _23901_/Q _13798_/A2 _12196_/X _13551_/S0 VPWR VGND sg13g2_a22oi_1
XFILLER_96_825 VPWR VGND sg13g2_decap_4
XFILLER_64_1459 VPWR VGND sg13g2_decap_4
XFILLER_110_613 VPWR VGND sg13g2_decap_8
XFILLER_46_1860 VPWR VGND sg13g2_fill_2
XFILLER_81_1751 VPWR VGND sg13g2_decap_8
X_18813_ _18814_/C _23068_/Q _18825_/B VPWR VGND sg13g2_nand2_1
XFILLER_95_324 VPWR VGND sg13g2_decap_8
X_19793_ _19793_/X _20028_/B _19932_/B _19581_/Y _19592_/Y _20030_/S _19932_/A VPWR
+ VGND sg13g2_mux4_1
XFILLER_7_1353 VPWR VGND sg13g2_decap_8
X_18744_ _23026_/D _18744_/A _18744_/B VPWR VGND sg13g2_nor2_1
XFILLER_7_1364 VPWR VGND sg13g2_decap_8
XFILLER_62_1183 VPWR VGND sg13g2_fill_1
XFILLER_83_519 VPWR VGND sg13g2_decap_8
X_15956_ _15956_/Y _22576_/Q _15956_/B VPWR VGND sg13g2_nand2_1
XFILLER_64_700 VPWR VGND sg13g2_fill_1
XFILLER_3_1228 VPWR VGND sg13g2_decap_8
XFILLER_48_262 VPWR VGND sg13g2_fill_2
X_14907_ _16257_/B _17867_/A1 _14801_/B _15068_/A VPWR VGND sg13g2_o21ai_1
XFILLER_23_1178 VPWR VGND sg13g2_fill_1
X_15887_ _15887_/Y _22476_/Q _15980_/S VPWR VGND sg13g2_nand2b_1
X_18675_ _18675_/X _23012_/Q _18670_/C _18673_/Y VPWR VGND sg13g2_a21o_1
XFILLER_37_958 VPWR VGND sg13g2_decap_8
XFILLER_37_969 VPWR VGND sg13g2_fill_2
XFILLER_91_541 VPWR VGND sg13g2_fill_2
XFILLER_24_608 VPWR VGND sg13g2_decap_8
X_17626_ _17626_/X _22556_/Q _17654_/D VPWR VGND sg13g2_xor2_1
X_14838_ _14838_/Y _17540_/A _14837_/Y _14788_/B VPWR VGND sg13g2_o21ai_1
XFILLER_17_682 VPWR VGND sg13g2_fill_2
XFILLER_23_118 VPWR VGND sg13g2_fill_1
XFILLER_45_991 VPWR VGND sg13g2_decap_8
XFILLER_108_1000 VPWR VGND sg13g2_fill_2
X_17557_ _17557_/Y _17557_/A _17557_/B VPWR VGND sg13g2_nand2_1
X_14769_ _14885_/B _14788_/A _14767_/Y _14768_/Y VPWR VGND sg13g2_a21oi_1
XFILLER_16_181 VPWR VGND sg13g2_decap_4
XFILLER_44_490 VPWR VGND sg13g2_fill_1
X_16508_ _16508_/Y _22614_/Q _16508_/B VPWR VGND sg13g2_nand2_1
XFILLER_75_1588 VPWR VGND sg13g2_decap_4
X_17488_ _22860_/D _16150_/A _17502_/S _17487_/Y VPWR VGND sg13g2_o21ai_1
XFILLER_31_140 VPWR VGND sg13g2_decap_8
XFILLER_20_836 VPWR VGND sg13g2_fill_1
XFILLER_32_696 VPWR VGND sg13g2_fill_1
X_19227_ _23181_/D _24270_/A _23181_/Q _19232_/B VPWR VGND sg13g2_mux2_1
X_16439_ _16440_/S _16439_/A _16518_/C _16441_/B VPWR VGND sg13g2_nand3_1
XFILLER_31_184 VPWR VGND sg13g2_decap_8
XFILLER_14_1837 VPWR VGND sg13g2_decap_8
XFILLER_105_1954 VPWR VGND sg13g2_fill_1
X_19158_ _23131_/D _23131_/Q _14878_/X _19159_/S VPWR VGND sg13g2_mux2_1
XFILLER_88_1927 VPWR VGND sg13g2_fill_1
X_18109_ _22949_/D _18119_/S _18504_/A _18108_/Y VPWR VGND sg13g2_o21ai_1
X_19089_ _19089_/X _18907_/B _23113_/Q _19098_/S VPWR VGND sg13g2_mux2_1
XFILLER_69_1348 VPWR VGND sg13g2_fill_1
Xhold4804 _21790_/A _23893_/Q VPWR VGND sg13g2_dlygate4sd3_1
Xhold4815 _20864_/A _23479_/Q VPWR VGND sg13g2_dlygate4sd3_1
X_21120_ _23585_/D _21321_/A1 _21121_/B _21119_/Y VPWR VGND sg13g2_o21ai_1
XFILLER_86_1651 VPWR VGND sg13g2_decap_8
Xhold4826 _20159_/A _23239_/Q VPWR VGND sg13g2_dlygate4sd3_1
Xhold4837 _21970_/A _23980_/Q VPWR VGND sg13g2_dlygate4sd3_1
Xhold4848 _20790_/A _23445_/Q VPWR VGND sg13g2_dlygate4sd3_1
Xcore_wrap data_addr_o[0] VPWR VGND sg13g2_tielo
XFILLER_28_1012 VPWR VGND sg13g2_decap_8
Xhold4859 _22025_/A _24006_/Q VPWR VGND sg13g2_dlygate4sd3_1
X_21051_ _21051_/Y _23558_/Q _21051_/B VPWR VGND sg13g2_nand2_1
XFILLER_47_1657 VPWR VGND sg13g2_decap_8
X_20002_ _20016_/A _24257_/A _20286_/B VPWR VGND sg13g2_nand2_1
XFILLER_59_527 VPWR VGND sg13g2_decap_8
XFILLER_113_484 VPWR VGND sg13g2_decap_8
XFILLER_98_173 VPWR VGND sg13g2_decap_8
XFILLER_101_635 VPWR VGND sg13g2_decap_8
XFILLER_115_1037 VPWR VGND sg13g2_decap_8
XFILLER_28_1089 VPWR VGND sg13g2_fill_2
XFILLER_112_1903 VPWR VGND sg13g2_decap_8
XFILLER_80_1261 VPWR VGND sg13g2_decap_4
XFILLER_45_1381 VPWR VGND sg13g2_fill_2
XFILLER_100_145 VPWR VGND sg13g2_decap_8
XFILLER_101_679 VPWR VGND sg13g2_fill_2
XFILLER_39_240 VPWR VGND sg13g2_decap_8
XFILLER_60_1868 VPWR VGND sg13g2_fill_1
XFILLER_27_413 VPWR VGND sg13g2_decap_8
XFILLER_41_1256 VPWR VGND sg13g2_fill_2
XFILLER_100_189 VPWR VGND sg13g2_fill_2
X_21953_ _21953_/Y _21953_/A _21957_/B VPWR VGND sg13g2_nand2_1
XFILLER_54_232 VPWR VGND sg13g2_decap_4
X_20904_ _23498_/D _20972_/A1 _20903_/B _20903_/Y VPWR VGND sg13g2_o21ai_1
XFILLER_54_243 VPWR VGND sg13g2_fill_1
XFILLER_93_1611 VPWR VGND sg13g2_decap_8
XFILLER_15_619 VPWR VGND sg13g2_fill_2
XFILLER_43_928 VPWR VGND sg13g2_fill_1
X_21884_ _23937_/D _21950_/A1 _21885_/B _21883_/Y VPWR VGND sg13g2_o21ai_1
XFILLER_36_980 VPWR VGND sg13g2_fill_1
X_23623_ _23623_/Q _24170_/CLK _23623_/D fanout2697/X VPWR VGND sg13g2_dfrbpq_1
X_20835_ _23464_/D _23464_/Q _21335_/A0 _20852_/S VPWR VGND sg13g2_mux2_1
XFILLER_35_490 VPWR VGND sg13g2_decap_8
XFILLER_93_1677 VPWR VGND sg13g2_decap_8
XFILLER_51_961 VPWR VGND sg13g2_fill_1
XFILLER_54_1628 VPWR VGND sg13g2_fill_1
XFILLER_58_1797 VPWR VGND sg13g2_decap_8
X_23554_ _23554_/Q _24131_/CLK _23554_/D fanout2715/X VPWR VGND sg13g2_dfrbpq_1
XFILLER_93_1699 VPWR VGND sg13g2_decap_8
X_20766_ _23432_/D _23432_/Q _21335_/A0 _20783_/S VPWR VGND sg13g2_mux2_1
XFILLER_52_47 VPWR VGND sg13g2_decap_8
XFILLER_22_162 VPWR VGND sg13g2_decap_8
X_22505_ _22505_/Q _22941_/CLK _22505_/D fanout2796/X VPWR VGND sg13g2_dfrbpq_1
XFILLER_11_847 VPWR VGND sg13g2_decap_4
XFILLER_32_1904 VPWR VGND sg13g2_decap_8
XFILLER_50_493 VPWR VGND sg13g2_decap_8
X_23485_ _23485_/Q clkload55/A _23485_/D fanout2777/X VPWR VGND sg13g2_dfrbpq_1
XFILLER_7_807 VPWR VGND sg13g2_decap_8
XFILLER_7_818 VPWR VGND sg13g2_fill_2
X_20697_ _20697_/Y _23402_/Q _20704_/B VPWR VGND sg13g2_nand2_1
XFILLER_109_713 VPWR VGND sg13g2_decap_4
XFILLER_52_1374 VPWR VGND sg13g2_decap_8
X_22436_ _22436_/Y _22436_/A _22450_/B VPWR VGND sg13g2_nand2_1
XFILLER_104_1475 VPWR VGND sg13g2_fill_1
XFILLER_109_768 VPWR VGND sg13g2_fill_2
X_22367_ _22367_/Y _22367_/A _22374_/B VPWR VGND sg13g2_nand2_1
XFILLER_2_501 VPWR VGND sg13g2_fill_2
X_24106_ _24106_/Q clkload36/A _24106_/D fanout2710/X VPWR VGND sg13g2_dfrbpq_1
X_12120_ _12120_/X _24028_/Q _24092_/Q _12121_/S VPWR VGND sg13g2_mux2_1
X_21318_ _21318_/Y _21318_/A _21337_/B VPWR VGND sg13g2_nand2_1
X_22298_ _24136_/D _22298_/A0 _24136_/Q _22315_/S VPWR VGND sg13g2_mux2_1
XFILLER_65_1724 VPWR VGND sg13g2_fill_2
X_24037_ _24037_/Q clkload37/A _24037_/D fanout2714/X VPWR VGND sg13g2_dfrbpq_1
XFILLER_78_803 VPWR VGND sg13g2_decap_4
XFILLER_78_847 VPWR VGND sg13g2_decap_4
XFILLER_77_55 VPWR VGND sg13g2_decap_8
XFILLER_89_195 VPWR VGND sg13g2_decap_8
XFILLER_46_1189 VPWR VGND sg13g2_decap_8
X_15810_ _15815_/B _15944_/A _15810_/B VPWR VGND sg13g2_or2_1
XFILLER_115_1560 VPWR VGND sg13g2_decap_8
X_16790_ _16859_/B _16790_/A _16871_/B VPWR VGND sg13g2_nor2_1
XFILLER_19_903 VPWR VGND sg13g2_decap_8
XFILLER_19_936 VPWR VGND sg13g2_decap_8
XFILLER_46_711 VPWR VGND sg13g2_fill_1
X_15741_ _15745_/A _22897_/Q _15825_/B VPWR VGND sg13g2_nand2_1
XFILLER_19_947 VPWR VGND sg13g2_fill_2
XFILLER_45_210 VPWR VGND sg13g2_decap_8
X_12953_ _13098_/A _12949_/X _12950_/X _12951_/Y _12952_/Y VPWR VGND sg13g2_a22oi_1
XFILLER_111_1446 VPWR VGND sg13g2_decap_8
XFILLER_93_32 VPWR VGND sg13g2_fill_1
XFILLER_46_744 VPWR VGND sg13g2_decap_8
XFILLER_59_1506 VPWR VGND sg13g2_fill_1
XFILLER_45_221 VPWR VGND sg13g2_fill_2
X_11904_ _11904_/Y _23514_/Q _11904_/B VPWR VGND sg13g2_nand2b_1
X_18460_ _18460_/Y _18144_/A _18530_/B _18301_/A VPWR VGND sg13g2_o21ai_1
X_15672_ _17135_/A _17881_/A VPWR VGND sg13g2_inv_1
XFILLER_46_777 VPWR VGND sg13g2_fill_2
XFILLER_73_563 VPWR VGND sg13g2_decap_4
XFILLER_33_405 VPWR VGND sg13g2_decap_8
X_12884_ _12884_/Y _23813_/Q _12884_/B VPWR VGND sg13g2_nand2b_1
X_17411_ _22824_/D _16142_/A _17412_/B _17410_/Y VPWR VGND sg13g2_o21ai_1
X_11835_ _11835_/Y _11393_/Y _11830_/Y _11832_/Y _13234_/B2 _11834_/Y VPWR VGND sg13g2_a221oi_1
X_18391_ _22983_/D _11355_/A _18286_/A _18390_/Y VPWR VGND sg13g2_a21oi_1
XFILLER_37_1815 VPWR VGND sg13g2_fill_1
XFILLER_53_1105 VPWR VGND sg13g2_fill_2
X_17342_ _22798_/D _15693_/A _17341_/B _17341_/Y VPWR VGND sg13g2_o21ai_1
XFILLER_14_663 VPWR VGND sg13g2_decap_8
XFILLER_76_1897 VPWR VGND sg13g2_fill_1
X_11766_ _11766_/Y _11379_/Y _11763_/Y _12288_/B VPWR VGND sg13g2_a21oi_1
XFILLER_13_140 VPWR VGND sg13g2_fill_2
XFILLER_72_1739 VPWR VGND sg13g2_decap_8
XFILLER_14_674 VPWR VGND sg13g2_fill_2
X_13505_ _13932_/C _13526_/D _13748_/C VPWR VGND sg13g2_nand2_1
XFILLER_109_1386 VPWR VGND sg13g2_decap_8
X_17273_ _22766_/D _15693_/A _17284_/B _17272_/Y VPWR VGND sg13g2_o21ai_1
XFILLER_13_184 VPWR VGND sg13g2_fill_2
X_14485_ _14486_/D _22588_/Q _22999_/Q VPWR VGND sg13g2_xor2_1
XFILLER_105_1239 VPWR VGND sg13g2_decap_8
X_11697_ _11701_/C _13212_/A _11697_/B VPWR VGND sg13g2_nor2_1
Xplace3409 _17371_/S _17321_/B VPWR VGND sg13g2_buf_1
X_16224_ _16224_/Y _18613_/A _16218_/Y _16237_/D VPWR VGND sg13g2_a21oi_1
X_19012_ _19013_/C _23058_/Q _19047_/A _19044_/B VPWR VGND sg13g2_or3_1
X_13436_ _13436_/Y _13436_/A _13510_/B VPWR VGND sg13g2_nor2_1
XFILLER_70_1485 VPWR VGND sg13g2_decap_4
XFILLER_31_1447 VPWR VGND sg13g2_decap_8
Xclkbuf_leaf_31_clk_i clkload57/A clkload4/A VPWR VGND sg13g2_buf_16
XFILLER_6_840 VPWR VGND sg13g2_decap_8
XFILLER_115_705 VPWR VGND sg13g2_decap_8
X_13367_ _13379_/A _13359_/Y _13361_/Y _13363_/Y _13366_/X VPWR VGND sg13g2_a22oi_1
X_15106_ _15108_/A _24275_/A _15025_/B _15105_/Y VPWR VGND sg13g2_a21oi_1
XFILLER_13_1892 VPWR VGND sg13g2_decap_8
X_12318_ _12323_/B _12318_/A _12318_/B VPWR VGND sg13g2_nor2_1
XFILLER_5_372 VPWR VGND sg13g2_fill_2
X_13298_ _13298_/Y _13289_/Y _13297_/Y _13286_/Y _20179_/A VPWR VGND sg13g2_a22oi_1
XFILLER_29_1310 VPWR VGND sg13g2_fill_2
XFILLER_29_1321 VPWR VGND sg13g2_fill_2
XFILLER_114_259 VPWR VGND sg13g2_decap_8
X_15037_ _15037_/Y _15037_/A _15037_/B VPWR VGND sg13g2_nand2_1
XFILLER_64_1212 VPWR VGND sg13g2_decap_8
X_12249_ _12250_/D _12249_/A1 _12248_/X _12249_/B1 VPWR VGND sg13g2_o21ai_1
XFILLER_69_803 VPWR VGND sg13g2_decap_8
Xclkbuf_4_0__f_clk_i clkbuf_leaf_0_clk_i/A clkbuf_3_0_0_clk_i/X VPWR VGND sg13g2_buf_8
XFILLER_9_1415 VPWR VGND sg13g2_fill_1
XFILLER_29_1365 VPWR VGND sg13g2_decap_8
XFILLER_96_622 VPWR VGND sg13g2_fill_1
XFILLER_83_1879 VPWR VGND sg13g2_fill_2
Xclkbuf_leaf_46_clk_i clkload36/A clkbuf_4_9__f_clk_i/X VPWR VGND sg13g2_buf_16
XFILLER_64_1256 VPWR VGND sg13g2_decap_8
X_19845_ _19854_/A _19956_/A _15467_/C _19842_/Y _19844_/Y _20345_/A1 VPWR VGND sg13g2_a221oi_1
XFILLER_68_335 VPWR VGND sg13g2_decap_8
XFILLER_110_432 VPWR VGND sg13g2_decap_8
XFILLER_69_869 VPWR VGND sg13g2_decap_4
XFILLER_81_1570 VPWR VGND sg13g2_fill_1
XFILLER_56_519 VPWR VGND sg13g2_decap_8
XFILLER_3_1003 VPWR VGND sg13g2_decap_4
XFILLER_49_560 VPWR VGND sg13g2_fill_1
X_16988_ _16989_/B _16993_/B _17004_/B _16993_/C VPWR VGND sg13g2_nor3_1
XFILLER_95_198 VPWR VGND sg13g2_decap_4
X_18727_ _18727_/Y _18713_/A _18726_/Y _23023_/Q VPWR VGND sg13g2_a21oi_1
X_15939_ _15941_/C _22868_/Q _16005_/B _16004_/B1 _22833_/Q VPWR VGND sg13g2_a22oi_1
XFILLER_3_1047 VPWR VGND sg13g2_fill_1
XFILLER_37_744 VPWR VGND sg13g2_fill_2
XFILLER_97_1043 VPWR VGND sg13g2_fill_2
XFILLER_3_1058 VPWR VGND sg13g2_decap_8
XFILLER_64_552 VPWR VGND sg13g2_decap_8
XFILLER_37_777 VPWR VGND sg13g2_fill_1
XFILLER_25_928 VPWR VGND sg13g2_decap_8
X_18658_ _18658_/Y _23010_/Q _18658_/B VPWR VGND sg13g2_xnor2_1
XFILLER_0_1935 VPWR VGND sg13g2_decap_8
XFILLER_52_725 VPWR VGND sg13g2_decap_8
XFILLER_94_1942 VPWR VGND sg13g2_decap_8
XFILLER_36_298 VPWR VGND sg13g2_decap_4
X_17609_ _17609_/Y _17087_/A _17670_/A2 _17670_/B1 _17608_/Y VPWR VGND sg13g2_a22oi_1
XFILLER_94_1953 VPWR VGND sg13g2_fill_2
XFILLER_91_393 VPWR VGND sg13g2_decap_4
XFILLER_51_224 VPWR VGND sg13g2_decap_8
XFILLER_55_1926 VPWR VGND sg13g2_fill_1
X_20620_ _20620_/Y _23364_/Q _20624_/B VPWR VGND sg13g2_nand2_1
XFILLER_51_268 VPWR VGND sg13g2_decap_8
XFILLER_71_1216 VPWR VGND sg13g2_fill_1
XFILLER_36_1347 VPWR VGND sg13g2_decap_8
XFILLER_71_1238 VPWR VGND sg13g2_fill_2
X_20551_ _20551_/Y _23331_/Q _20565_/B VPWR VGND sg13g2_nand2_1
XFILLER_20_633 VPWR VGND sg13g2_decap_4
XFILLER_18_1770 VPWR VGND sg13g2_fill_2
Xplace3910 _18498_/B _18155_/B VPWR VGND sg13g2_buf_1
XFILLER_53_1683 VPWR VGND sg13g2_decap_8
XFILLER_105_1762 VPWR VGND sg13g2_decap_8
X_23270_ _23270_/Q clkload33/A _23270_/D fanout2699/X VPWR VGND sg13g2_dfrbpq_1
Xplace3921 _17689_/B1 _17706_/B VPWR VGND sg13g2_buf_1
X_20482_ _20482_/Y _20482_/A _20482_/B VPWR VGND sg13g2_nand2_1
Xplace3932 _15216_/B _11314_/B VPWR VGND sg13g2_buf_1
Xplace3943 _13675_/B2 _13587_/B2 VPWR VGND sg13g2_buf_2
Xplace3954 _20344_/A1 _19497_/X VPWR VGND sg13g2_buf_1
XFILLER_101_1626 VPWR VGND sg13g2_fill_2
Xplace3965 _15082_/A _16215_/A VPWR VGND sg13g2_buf_1
X_22221_ _22221_/Y _24099_/Q _22241_/B VPWR VGND sg13g2_nand2_1
Xplace3976 _12873_/A place3976/A VPWR VGND sg13g2_buf_1
XFILLER_69_1134 VPWR VGND sg13g2_decap_4
Xplace3987 _13208_/A _12774_/B VPWR VGND sg13g2_buf_2
Xplace3998 _13889_/B _12486_/A VPWR VGND sg13g2_buf_2
XFILLER_69_1145 VPWR VGND sg13g2_decap_8
X_22152_ _24066_/D _22286_/A1 _22151_/B _22151_/Y VPWR VGND sg13g2_o21ai_1
X_21103_ _23577_/D _21237_/A1 _21112_/B _21102_/Y VPWR VGND sg13g2_o21ai_1
XFILLER_86_1470 VPWR VGND sg13g2_decap_8
Xhold4645 _17449_/A _22843_/Q VPWR VGND sg13g2_dlygate4sd3_1
Xhold4656 _17246_/A _22754_/Q VPWR VGND sg13g2_dlygate4sd3_1
XFILLER_114_760 VPWR VGND sg13g2_decap_8
XFILLER_82_1323 VPWR VGND sg13g2_decap_8
X_22083_ _24033_/D _22284_/A1 _22084_/B _22082_/Y VPWR VGND sg13g2_o21ai_1
Xhold4667 _17268_/A _22764_/Q VPWR VGND sg13g2_dlygate4sd3_1
Xhold4678 _17496_/A _22865_/Q VPWR VGND sg13g2_dlygate4sd3_1
XFILLER_47_1465 VPWR VGND sg13g2_fill_1
XFILLER_59_302 VPWR VGND sg13g2_decap_8
Xhold4689 _17279_/A _22769_/Q VPWR VGND sg13g2_dlygate4sd3_1
XFILLER_102_933 VPWR VGND sg13g2_decap_8
XFILLER_59_324 VPWR VGND sg13g2_fill_1
XFILLER_86_143 VPWR VGND sg13g2_decap_4
XFILLER_75_828 VPWR VGND sg13g2_decap_8
XFILLER_59_379 VPWR VGND sg13g2_decap_4
XFILLER_86_187 VPWR VGND sg13g2_fill_1
XFILLER_21_1616 VPWR VGND sg13g2_fill_1
XFILLER_47_58 VPWR VGND sg13g2_fill_2
XFILLER_99_1842 VPWR VGND sg13g2_decap_8
XFILLER_5_1868 VPWR VGND sg13g2_decap_8
XFILLER_41_1064 VPWR VGND sg13g2_decap_8
X_22985_ _22985_/Q clkload36/A _22985_/D fanout2935/X VPWR VGND sg13g2_dfrbpq_2
XFILLER_55_530 VPWR VGND sg13g2_fill_2
XFILLER_74_349 VPWR VGND sg13g2_decap_4
XFILLER_112_1777 VPWR VGND sg13g2_fill_1
XFILLER_103_42 VPWR VGND sg13g2_decap_8
X_21936_ _23963_/D _21936_/A1 _21935_/B _21935_/Y VPWR VGND sg13g2_o21ai_1
XFILLER_3_1581 VPWR VGND sg13g2_decap_8
XFILLER_27_276 VPWR VGND sg13g2_fill_2
XFILLER_43_725 VPWR VGND sg13g2_fill_1
XFILLER_27_287 VPWR VGND sg13g2_decap_8
XFILLER_63_35 VPWR VGND sg13g2_decap_8
XFILLER_93_1430 VPWR VGND sg13g2_decap_8
XFILLER_43_747 VPWR VGND sg13g2_decap_4
X_21867_ _21867_/Y _23930_/Q _21869_/B VPWR VGND sg13g2_nand2_1
XFILLER_43_769 VPWR VGND sg13g2_decap_8
X_23606_ _23606_/Q clkload57/A _23606_/D fanout2761/X VPWR VGND sg13g2_dfrbpq_1
X_11620_ _11620_/Y _14117_/A _11614_/B _11619_/Y VPWR VGND sg13g2_o21ai_1
X_20818_ _20818_/Y _23458_/Q _20818_/B VPWR VGND sg13g2_nand2_1
X_21798_ _21798_/Y _23897_/Q _21802_/B VPWR VGND sg13g2_nand2_1
XFILLER_23_460 VPWR VGND sg13g2_fill_1
XFILLER_70_599 VPWR VGND sg13g2_decap_8
XFILLER_51_780 VPWR VGND sg13g2_decap_8
X_23537_ _23537_/Q _24113_/CLK _23537_/D fanout2684/X VPWR VGND sg13g2_dfrbpq_1
XFILLER_10_110 VPWR VGND sg13g2_fill_2
XFILLER_23_493 VPWR VGND sg13g2_decap_4
X_11551_ _11551_/Y _11308_/X _11310_/Y _11316_/Y VPWR VGND sg13g2_a21oi_1
XFILLER_106_1548 VPWR VGND sg13g2_fill_2
X_20749_ _20749_/Y _20749_/A _20751_/B VPWR VGND sg13g2_nand2_1
XFILLER_10_143 VPWR VGND sg13g2_decap_4
XFILLER_109_510 VPWR VGND sg13g2_decap_8
XFILLER_10_154 VPWR VGND sg13g2_decap_4
X_14270_ _17043_/A _14463_/B _14270_/B VPWR VGND sg13g2_or2_1
XFILLER_52_1160 VPWR VGND sg13g2_fill_2
X_23468_ _23468_/Q _24170_/CLK _23468_/D fanout2640/X VPWR VGND sg13g2_dfrbpq_1
XFILLER_104_1294 VPWR VGND sg13g2_decap_8
XFILLER_87_1234 VPWR VGND sg13g2_fill_2
X_23399_ _23399_/Q clkload35/A _23399_/D fanout2696/X VPWR VGND sg13g2_dfrbpq_1
XFILLER_67_1808 VPWR VGND sg13g2_fill_2
XFILLER_109_587 VPWR VGND sg13g2_decap_8
XFILLER_88_32 VPWR VGND sg13g2_decap_8
XFILLER_3_832 VPWR VGND sg13g2_fill_1
X_12103_ _12104_/C _15227_/A _19373_/A VPWR VGND sg13g2_nand2_1
XFILLER_5_0 VPWR VGND sg13g2_decap_8
XFILLER_112_719 VPWR VGND sg13g2_decap_8
XFILLER_88_65 VPWR VGND sg13g2_decap_8
X_17960_ _17960_/Y _17965_/A _23032_/Q _17959_/Y VPWR VGND sg13g2_a21oi_1
X_13083_ _13083_/Y _13078_/B _13078_/A _12861_/A VPWR VGND sg13g2_o21ai_1
XFILLER_3_876 VPWR VGND sg13g2_decap_8
XFILLER_26_1505 VPWR VGND sg13g2_decap_8
XFILLER_26_1516 VPWR VGND sg13g2_fill_1
X_16911_ _16911_/Y _17098_/A _17032_/B VPWR VGND sg13g2_nand2b_1
X_12034_ _12034_/Y _14438_/C _14296_/A2 _12033_/Y VPWR VGND sg13g2_a21oi_1
X_17891_ _17892_/B _22928_/Q _17909_/B VPWR VGND sg13g2_nand2_1
XFILLER_104_292 VPWR VGND sg13g2_fill_2
X_16842_ _16842_/Y _16846_/A _16842_/B VPWR VGND sg13g2_nand2_1
XFILLER_77_154 VPWR VGND sg13g2_decap_8
XFILLER_78_699 VPWR VGND sg13g2_decap_8
X_19561_ _19561_/Y _19563_/B _19561_/B VPWR VGND sg13g2_nand2_1
X_16773_ _22670_/D _16136_/A _16818_/A _16772_/Y VPWR VGND sg13g2_a21oi_1
X_13985_ _13985_/Y _13984_/X _13985_/B VPWR VGND sg13g2_nand2b_1
XFILLER_65_349 VPWR VGND sg13g2_decap_8
XFILLER_92_157 VPWR VGND sg13g2_decap_8
XFILLER_19_766 VPWR VGND sg13g2_decap_8
X_18512_ _18512_/Y _18512_/A VPWR VGND sg13g2_inv_1
XFILLER_18_254 VPWR VGND sg13g2_fill_1
X_15724_ _15726_/C _22858_/Q _15966_/B1 _16004_/B1 _22823_/Q VPWR VGND sg13g2_a22oi_1
X_12936_ _12939_/C _13723_/A _20085_/A _12936_/C _14053_/C VPWR VGND sg13g2_nand4_1
XFILLER_80_319 VPWR VGND sg13g2_decap_4
XFILLER_20_1159 VPWR VGND sg13g2_fill_1
X_19492_ _19493_/B _19582_/A _19603_/B _19491_/Y VPWR VGND sg13g2_a21oi_1
X_18443_ _18443_/Y _18443_/A _18443_/B _18443_/C VPWR VGND sg13g2_nor3_1
XFILLER_73_393 VPWR VGND sg13g2_decap_4
X_15655_ _22465_/D _16117_/A _15653_/X _15695_/S VPWR VGND sg13g2_mux2_1
X_12867_ _14956_/B _14053_/A _14053_/B _14053_/C VPWR VGND sg13g2_nand3_1
XFILLER_22_909 VPWR VGND sg13g2_decap_8
X_11818_ _11818_/Y _11818_/A _11818_/B _11818_/C _11818_/D VPWR VGND sg13g2_nor4_2
XFILLER_21_408 VPWR VGND sg13g2_decap_8
X_14606_ _14606_/Y _14194_/B _14605_/Y _14247_/Y VPWR VGND sg13g2_o21ai_1
X_18374_ _18382_/B _18370_/Y _18373_/Y _18562_/A VPWR VGND sg13g2_a21oi_1
XFILLER_33_279 VPWR VGND sg13g2_decap_8
XFILLER_37_1645 VPWR VGND sg13g2_fill_2
XFILLER_57_1071 VPWR VGND sg13g2_fill_1
X_15586_ _17517_/C _15585_/A _15785_/B _19984_/A _15585_/Y VPWR VGND sg13g2_a22oi_1
X_17325_ _22790_/D _17098_/A _17324_/B _17324_/Y VPWR VGND sg13g2_o21ai_1
X_11749_ _11750_/B _23416_/Q _23448_/Q _11749_/S VPWR VGND sg13g2_mux2_1
XFILLER_18_1066 VPWR VGND sg13g2_fill_1
Xcore_wrap_4567 data_addr_o[1] VPWR VGND sg13g2_tielo
Xplace3206 _22418_/A1 _20049_/Y VPWR VGND sg13g2_buf_1
Xplace3217 _22424_/B _22434_/B VPWR VGND sg13g2_buf_1
X_17256_ _22758_/D _17098_/A _17262_/B _17255_/Y VPWR VGND sg13g2_o21ai_1
Xplace3228 _21783_/B _21779_/B VPWR VGND sg13g2_buf_1
XFILLER_88_1009 VPWR VGND sg13g2_decap_8
XFILLER_70_1271 VPWR VGND sg13g2_fill_2
Xplace3239 _21221_/B _21209_/B VPWR VGND sg13g2_buf_1
XFILLER_11_1818 VPWR VGND sg13g2_decap_8
X_16207_ _16207_/X _22513_/Q _16207_/B VPWR VGND sg13g2_and2_1
X_13419_ _13428_/C _13419_/A _13419_/B VPWR VGND sg13g2_nor2_1
X_17187_ _17187_/Y _17187_/A _17197_/B VPWR VGND sg13g2_nor2_1
X_14399_ _14399_/Y _17532_/A _14399_/B _14399_/C VPWR VGND sg13g2_nand3_1
XFILLER_115_502 VPWR VGND sg13g2_decap_8
X_16138_ _16138_/Y _16138_/A _16177_/B VPWR VGND sg13g2_nand2_1
XFILLER_115_579 VPWR VGND sg13g2_decap_8
X_16069_ _16069_/Y _16069_/A _16073_/B VPWR VGND sg13g2_nand2_1
XFILLER_48_1752 VPWR VGND sg13g2_decap_4
XFILLER_69_600 VPWR VGND sg13g2_decap_8
XFILLER_9_1223 VPWR VGND sg13g2_decap_8
XFILLER_48_1774 VPWR VGND sg13g2_decap_8
XFILLER_29_1162 VPWR VGND sg13g2_decap_8
XFILLER_38_0 VPWR VGND sg13g2_decap_8
XFILLER_111_730 VPWR VGND sg13g2_decap_8
XFILLER_9_1256 VPWR VGND sg13g2_decap_4
XFILLER_25_1026 VPWR VGND sg13g2_decap_8
XFILLER_61_1930 VPWR VGND sg13g2_decap_8
XFILLER_64_1086 VPWR VGND sg13g2_decap_8
X_19828_ _19828_/Y _19869_/A _19828_/B VPWR VGND sg13g2_nand2_1
XFILLER_96_463 VPWR VGND sg13g2_fill_2
XFILLER_68_154 VPWR VGND sg13g2_fill_1
Xfanout2890 fanout2890/X fanout2891/X VPWR VGND sg13g2_buf_1
XFILLER_22_1903 VPWR VGND sg13g2_decap_8
XFILLER_56_305 VPWR VGND sg13g2_decap_8
XFILLER_99_1116 VPWR VGND sg13g2_decap_4
XFILLER_84_625 VPWR VGND sg13g2_decap_8
X_19759_ _19759_/Y _20005_/A _20005_/B _19758_/Y VPWR VGND sg13g2_a21oi_1
XFILLER_83_135 VPWR VGND sg13g2_decap_8
XFILLER_17_17 VPWR VGND sg13g2_decap_8
XFILLER_65_872 VPWR VGND sg13g2_decap_8
X_22770_ _22770_/Q clkload10/A _22770_/D fanout2811/X VPWR VGND sg13g2_dfrbpq_1
XFILLER_64_360 VPWR VGND sg13g2_decap_8
XFILLER_65_883 VPWR VGND sg13g2_decap_8
XFILLER_80_831 VPWR VGND sg13g2_fill_1
XFILLER_24_224 VPWR VGND sg13g2_decap_8
XFILLER_0_1765 VPWR VGND sg13g2_decap_4
XFILLER_20_1693 VPWR VGND sg13g2_fill_1
XFILLER_52_544 VPWR VGND sg13g2_fill_2
XFILLER_52_566 VPWR VGND sg13g2_decap_8
XFILLER_80_886 VPWR VGND sg13g2_decap_4
XFILLER_90_1614 VPWR VGND sg13g2_fill_1
X_21652_ _23839_/D _21946_/A1 _21657_/B _21651_/Y VPWR VGND sg13g2_o21ai_1
XFILLER_33_27 VPWR VGND sg13g2_fill_1
XFILLER_90_1636 VPWR VGND sg13g2_fill_2
XFILLER_71_1013 VPWR VGND sg13g2_decap_4
XFILLER_21_931 VPWR VGND sg13g2_decap_8
X_20603_ _23356_/D _22405_/A1 _20607_/B _20602_/Y VPWR VGND sg13g2_o21ai_1
XFILLER_107_1846 VPWR VGND sg13g2_decap_8
XFILLER_20_430 VPWR VGND sg13g2_fill_1
Xrebuffer5420 _12387_/B _12385_/X VPWR VGND sg13g2_buf_8
X_23322_ _23322_/Q clkload44/A _23322_/D fanout2750/X VPWR VGND sg13g2_dfrbpq_1
Xrebuffer5431 _11979_/B _12112_/A VPWR VGND sg13g2_buf_1
X_20534_ _23323_/D _22403_/A1 _20533_/B _20533_/Y VPWR VGND sg13g2_o21ai_1
Xrebuffer5442 _11981_/A _11784_/Y VPWR VGND sg13g2_buf_2
XFILLER_20_474 VPWR VGND sg13g2_decap_8
Xrebuffer5453 _12772_/B place3986/A VPWR VGND sg13g2_buf_1
Xrebuffer5464 _13740_/B1 _13438_/Y VPWR VGND sg13g2_buf_1
Xplace3740 _20177_/A _19325_/X VPWR VGND sg13g2_buf_1
X_23253_ _23253_/Q clkload48/A _23253_/D fanout2754/X VPWR VGND sg13g2_dfrbpq_1
XFILLER_14_1475 VPWR VGND sg13g2_decap_8
Xrebuffer5475 _16326_/A _15090_/X VPWR VGND sg13g2_buf_1
Xplace3751 _17734_/A2 _17590_/B VPWR VGND sg13g2_buf_1
Xrebuffer5486 _14931_/B1 _14930_/Y VPWR VGND sg13g2_buf_2
Xplace3762 _13528_/A _14103_/A VPWR VGND sg13g2_buf_1
X_20465_ _23294_/D _22409_/A1 _20464_/B _20464_/Y VPWR VGND sg13g2_o21ai_1
Xplace3773 _19573_/S _19563_/B VPWR VGND sg13g2_buf_1
Xrebuffer5497 _14740_/A1 _11219_/Y VPWR VGND sg13g2_buf_1
Xhold5110 _21955_/A _23972_/Q VPWR VGND sg13g2_dlygate4sd3_1
Xplace3784 _13854_/A _11983_/A VPWR VGND sg13g2_buf_4
XFILLER_14_1497 VPWR VGND sg13g2_fill_1
X_22204_ _24091_/D _22270_/A1 _22203_/B _22203_/Y VPWR VGND sg13g2_o21ai_1
XFILLER_49_1516 VPWR VGND sg13g2_fill_2
Xhold5121 _21422_/A _23732_/Q VPWR VGND sg13g2_dlygate4sd3_1
XFILLER_106_524 VPWR VGND sg13g2_decap_8
Xhold5132 _20940_/A _23516_/Q VPWR VGND sg13g2_dlygate4sd3_1
XFILLER_3_117 VPWR VGND sg13g2_decap_8
Xplace3795 _20338_/C _20287_/B VPWR VGND sg13g2_buf_1
XFILLER_88_1576 VPWR VGND sg13g2_decap_8
X_23184_ _23184_/Q clkload17/A _23184_/D fanout2848/X VPWR VGND sg13g2_dfrbpq_1
Xhold5143 _21450_/A _23743_/Q VPWR VGND sg13g2_dlygate4sd3_1
XFILLER_88_1587 VPWR VGND sg13g2_fill_2
X_20396_ _23262_/D _22409_/A1 _20395_/B _20395_/Y VPWR VGND sg13g2_o21ai_1
Xhold5154 _21347_/A _23696_/Q VPWR VGND sg13g2_dlygate4sd3_1
Xhold5165 _20462_/A _23293_/Q VPWR VGND sg13g2_dlygate4sd3_1
X_22135_ _24058_/D _22268_/A1 _22136_/B _22134_/Y VPWR VGND sg13g2_o21ai_1
Xhold5176 _20736_/A _23419_/Q VPWR VGND sg13g2_dlygate4sd3_1
Xhold5187 _20837_/A _23466_/Q VPWR VGND sg13g2_dlygate4sd3_1
Xhold5198 _20654_/A _23381_/Q VPWR VGND sg13g2_dlygate4sd3_1
XFILLER_58_13 VPWR VGND sg13g2_decap_8
X_22066_ _24025_/D _22266_/A1 _22065_/B _22065_/Y VPWR VGND sg13g2_o21ai_1
XFILLER_62_1727 VPWR VGND sg13g2_fill_1
XFILLER_88_975 VPWR VGND sg13g2_fill_2
XFILLER_102_763 VPWR VGND sg13g2_decap_8
X_21017_ _23547_/D _22270_/A1 _21019_/B _21016_/Y VPWR VGND sg13g2_o21ai_1
XFILLER_114_1839 VPWR VGND sg13g2_decap_8
XFILLER_21_1402 VPWR VGND sg13g2_fill_2
XFILLER_5_1654 VPWR VGND sg13g2_decap_8
XFILLER_114_63 VPWR VGND sg13g2_decap_8
XFILLER_5_1665 VPWR VGND sg13g2_fill_1
XFILLER_99_1672 VPWR VGND sg13g2_fill_2
XFILLER_112_1574 VPWR VGND sg13g2_fill_1
X_13770_ _13770_/Y _13770_/A _13770_/B VPWR VGND sg13g2_nor2_1
XFILLER_43_500 VPWR VGND sg13g2_decap_8
X_22968_ _22968_/Q clkload16/A _22968_/D fanout2920/X VPWR VGND sg13g2_dfrbpq_1
XFILLER_74_179 VPWR VGND sg13g2_decap_8
XFILLER_95_1536 VPWR VGND sg13g2_decap_8
XFILLER_55_382 VPWR VGND sg13g2_fill_2
X_12721_ _12721_/X _24099_/Q _24131_/Q _12721_/S VPWR VGND sg13g2_mux2_1
XFILLER_43_533 VPWR VGND sg13g2_decap_8
X_22899_ _22899_/Q clkload9/A _22899_/D fanout2816/X VPWR VGND sg13g2_dfrbpq_1
XFILLER_54_1200 VPWR VGND sg13g2_fill_1
X_15440_ _15440_/X _17080_/A _22456_/Q _15496_/S VPWR VGND sg13g2_mux2_1
XFILLER_70_352 VPWR VGND sg13g2_decap_8
XFILLER_31_717 VPWR VGND sg13g2_decap_8
X_12652_ _12652_/X _13607_/A _12652_/B VPWR VGND sg13g2_or2_1
XFILLER_90_22 VPWR VGND sg13g2_fill_2
Xinput4352 _17867_/A1 boot_addr_i[10] VPWR VGND sg13g2_buf_1
XFILLER_30_205 VPWR VGND sg13g2_decap_8
Xinput4363 _17900_/A1 boot_addr_i[21] VPWR VGND sg13g2_buf_1
Xinput4374 _17859_/A1 boot_addr_i[8] VPWR VGND sg13g2_buf_1
Xinput4385 _20249_/A3 data_rdata_i[16] VPWR VGND sg13g2_buf_1
X_11603_ _14117_/C _22978_/Q _11634_/A VPWR VGND sg13g2_nor2b_1
X_15371_ _15372_/B _15923_/A _15368_/Y _15370_/Y VPWR VGND sg13g2_o21ai_1
Xinput4396 _20278_/A0 data_rdata_i[26] VPWR VGND sg13g2_buf_1
X_12583_ _12584_/B _22995_/Q _13280_/B _12583_/C _12870_/B VPWR VGND sg13g2_nand4_1
XFILLER_11_441 VPWR VGND sg13g2_decap_8
X_17110_ _17115_/B _17110_/A _17110_/B _17110_/C VPWR VGND sg13g2_nor3_1
X_14322_ _14369_/D _15447_/A _15140_/A _15140_/B _15140_/C VPWR VGND sg13g2_nor4_2
X_11534_ _11534_/X _23413_/Q _23445_/Q _23477_/Q _23509_/Q _11416_/B _12297_/S1 VPWR
+ VGND sg13g2_mux4_1
X_18090_ _18090_/Y _18084_/Y _18087_/Y _18089_/Y VPWR VGND sg13g2_a21oi_1
XFILLER_23_60 VPWR VGND sg13g2_fill_1
XFILLER_32_1520 VPWR VGND sg13g2_decap_8
XFILLER_54_1299 VPWR VGND sg13g2_decap_8
XFILLER_23_71 VPWR VGND sg13g2_decap_8
X_17041_ _17045_/B _17041_/A _17041_/B _17041_/C VPWR VGND sg13g2_or3_1
X_14253_ _14742_/B _14253_/A _14861_/B VPWR VGND sg13g2_nand2_1
X_11465_ _11465_/Y _11465_/A _12567_/A VPWR VGND sg13g2_nor2b_1
XFILLER_104_1080 VPWR VGND sg13g2_fill_2
XFILLER_99_42 VPWR VGND sg13g2_decap_8
X_13204_ _13204_/X _23817_/Q _23977_/Q _13796_/B VPWR VGND sg13g2_mux2_1
XFILLER_32_1597 VPWR VGND sg13g2_decap_8
XFILLER_67_1616 VPWR VGND sg13g2_decap_4
X_14184_ _14448_/C _16438_/B _14184_/B VPWR VGND sg13g2_nand2_1
X_11396_ _11396_/Y _11406_/S _23830_/Q _11395_/Y VPWR VGND sg13g2_o21ai_1
XFILLER_10_1851 VPWR VGND sg13g2_decap_8
XFILLER_99_97 VPWR VGND sg13g2_decap_4
X_13135_ _13136_/D _13636_/A _13135_/B VPWR VGND sg13g2_nor2_1
X_18992_ _18992_/Y _19003_/A _23088_/Q _19047_/C VPWR VGND sg13g2_nand3_1
XFILLER_48_1059 VPWR VGND sg13g2_decap_8
XFILLER_112_516 VPWR VGND sg13g2_decap_8
X_17943_ _18476_/A _18549_/S _17939_/X _17942_/Y VPWR VGND sg13g2_a21oi_1
XFILLER_2_172 VPWR VGND sg13g2_decap_4
XFILLER_26_1346 VPWR VGND sg13g2_fill_1
X_12017_ _12032_/B _12017_/A _12017_/B _12017_/C _12017_/D VPWR VGND sg13g2_nor4_2
XFILLER_93_400 VPWR VGND sg13g2_decap_4
X_17874_ _22922_/D _17874_/A VPWR VGND sg13g2_inv_1
X_19613_ _19613_/Y _20335_/A _19544_/Y _19612_/Y VPWR VGND sg13g2_o21ai_1
XFILLER_93_433 VPWR VGND sg13g2_decap_8
X_16825_ _16826_/B _22677_/Q _16825_/B VPWR VGND sg13g2_xnor2_1
XFILLER_65_135 VPWR VGND sg13g2_decap_8
XFILLER_43_1693 VPWR VGND sg13g2_decap_8
XFILLER_54_809 VPWR VGND sg13g2_fill_2
XFILLER_59_1100 VPWR VGND sg13g2_fill_2
X_19544_ _19544_/Y _19663_/A _19542_/Y _19543_/Y VPWR VGND sg13g2_o21ai_1
XFILLER_98_1160 VPWR VGND sg13g2_fill_1
X_16756_ _22666_/D _17878_/A _16760_/A _16755_/Y VPWR VGND sg13g2_a21oi_1
XFILLER_0_42 VPWR VGND sg13g2_decap_8
XFILLER_53_319 VPWR VGND sg13g2_decap_8
XFILLER_81_639 VPWR VGND sg13g2_decap_8
X_13968_ _13968_/Y _11500_/S _13968_/B VPWR VGND sg13g2_nand2b_1
XFILLER_98_1182 VPWR VGND sg13g2_decap_4
XFILLER_78_1756 VPWR VGND sg13g2_decap_8
XFILLER_34_511 VPWR VGND sg13g2_fill_1
XFILLER_111_1084 VPWR VGND sg13g2_decap_8
X_15707_ _15711_/B _22468_/Q _15945_/A2 _15992_/A2 _22604_/Q VPWR VGND sg13g2_a22oi_1
X_12919_ _12919_/Y _12921_/S _24101_/Q _12918_/Y VPWR VGND sg13g2_o21ai_1
X_13899_ _13899_/X _23859_/Q _23891_/Q _23955_/Q _23987_/Q _13900_/S0 _13900_/S1 VPWR
+ VGND sg13g2_mux4_1
X_16687_ _16687_/Y _16760_/A _16687_/B VPWR VGND sg13g2_nor2_1
XFILLER_78_1789 VPWR VGND sg13g2_decap_8
X_18426_ _18427_/C _18426_/A _18426_/B VPWR VGND sg13g2_nand2_1
XFILLER_22_717 VPWR VGND sg13g2_decap_8
XFILLER_91_1934 VPWR VGND sg13g2_decap_8
XFILLER_34_588 VPWR VGND sg13g2_decap_4
X_15638_ _15649_/A _22764_/Q _15700_/B _16007_/B _22796_/Q VPWR VGND sg13g2_a22oi_1
XFILLER_72_1333 VPWR VGND sg13g2_decap_8
X_18357_ _18778_/B _18024_/B _23063_/Q _18462_/S VPWR VGND sg13g2_mux2_1
XFILLER_72_1355 VPWR VGND sg13g2_decap_4
X_15569_ _18657_/A _23009_/Q VPWR VGND sg13g2_inv_1
X_17308_ _22782_/D _17444_/A1 _17315_/B _17307_/Y VPWR VGND sg13g2_o21ai_1
Xplace3003 _22341_/B _22335_/B VPWR VGND sg13g2_buf_1
XFILLER_50_1620 VPWR VGND sg13g2_decap_8
Xplace3014 _22285_/B _22291_/B VPWR VGND sg13g2_buf_1
X_18288_ _18288_/Y _18288_/A _18395_/A VPWR VGND sg13g2_nand2_1
Xplace3025 _22243_/S _22229_/B VPWR VGND sg13g2_buf_1
Xplace3036 _22065_/B _22075_/B VPWR VGND sg13g2_buf_1
XFILLER_89_1830 VPWR VGND sg13g2_decap_8
Xplace3047 _22039_/B _22048_/B VPWR VGND sg13g2_buf_1
Xplace3058 _21876_/B _21869_/B VPWR VGND sg13g2_buf_1
X_17239_ _22750_/D _17444_/A1 _17252_/B _17238_/Y VPWR VGND sg13g2_o21ai_1
Xplace3069 _21843_/B _21850_/B VPWR VGND sg13g2_buf_1
XFILLER_11_1648 VPWR VGND sg13g2_decap_4
XFILLER_50_1697 VPWR VGND sg13g2_fill_2
XFILLER_102_1765 VPWR VGND sg13g2_fill_1
X_20250_ _20250_/Y _20344_/A1 _20249_/X _20107_/Y VPWR VGND sg13g2_o21ai_1
XFILLER_115_343 VPWR VGND sg13g2_decap_8
X_20181_ _20182_/D _20181_/A _20319_/B VPWR VGND sg13g2_nand2_1
XFILLER_115_376 VPWR VGND sg13g2_decap_8
XFILLER_0_109 VPWR VGND sg13g2_decap_4
XFILLER_103_527 VPWR VGND sg13g2_decap_8
XFILLER_9_1020 VPWR VGND sg13g2_decap_8
XFILLER_69_452 VPWR VGND sg13g2_decap_4
X_23940_ _23940_/Q clkload40/A _23940_/D fanout2731/X VPWR VGND sg13g2_dfrbpq_1
XFILLER_97_794 VPWR VGND sg13g2_fill_2
XFILLER_96_271 VPWR VGND sg13g2_decap_8
XFILLER_22_1700 VPWR VGND sg13g2_decap_4
XFILLER_6_1952 VPWR VGND sg13g2_fill_2
XFILLER_61_1771 VPWR VGND sg13g2_decap_4
X_23871_ _23871_/Q _24190_/CLK _23871_/D fanout2773/X VPWR VGND sg13g2_dfrbpq_1
XFILLER_113_1850 VPWR VGND sg13g2_decap_8
XFILLER_85_989 VPWR VGND sg13g2_decap_8
XFILLER_2_1827 VPWR VGND sg13g2_decap_8
XFILLER_96_1823 VPWR VGND sg13g2_decap_8
X_22822_ _22822_/Q _22869_/CLK _22822_/D fanout2793/X VPWR VGND sg13g2_dfrbpq_1
XFILLER_37_360 VPWR VGND sg13g2_fill_2
XFILLER_96_1856 VPWR VGND sg13g2_decap_8
XFILLER_37_393 VPWR VGND sg13g2_decap_4
X_22753_ _22753_/Q clkload19/A _22753_/D fanout2864/X VPWR VGND sg13g2_dfrbpq_1
XFILLER_0_1551 VPWR VGND sg13g2_fill_1
XFILLER_25_555 VPWR VGND sg13g2_decap_8
XFILLER_38_1217 VPWR VGND sg13g2_decap_8
X_21704_ _23863_/D _21928_/A1 _21713_/B _21703_/Y VPWR VGND sg13g2_o21ai_1
X_22684_ _22684_/Q clkload23/A _22684_/D fanout2887/X VPWR VGND sg13g2_dfrbpq_1
XFILLER_12_205 VPWR VGND sg13g2_decap_8
XFILLER_52_374 VPWR VGND sg13g2_decap_8
XFILLER_80_694 VPWR VGND sg13g2_decap_4
XFILLER_100_21 VPWR VGND sg13g2_decap_8
XFILLER_94_1591 VPWR VGND sg13g2_decap_8
X_21635_ _21635_/Y _21635_/A _21635_/B VPWR VGND sg13g2_nand2_1
XFILLER_55_1575 VPWR VGND sg13g2_fill_2
XFILLER_107_1665 VPWR VGND sg13g2_decap_4
XFILLER_55_1597 VPWR VGND sg13g2_decap_4
XFILLER_103_1507 VPWR VGND sg13g2_fill_2
X_21566_ _21566_/Y _21566_/A _21574_/B VPWR VGND sg13g2_nand2_1
XFILLER_107_1698 VPWR VGND sg13g2_fill_1
XFILLER_33_1862 VPWR VGND sg13g2_fill_1
Xplace4260 _12457_/S1 _12409_/S1 VPWR VGND sg13g2_buf_4
X_23305_ _23305_/Q _24205_/CLK _23305_/D fanout2650/X VPWR VGND sg13g2_dfrbpq_1
Xrebuffer5250 _17934_/C _14155_/Y VPWR VGND sg13g2_buf_2
Xplace4271 _13981_/S1 _22980_/Q VPWR VGND sg13g2_buf_8
Xplace4282 _13983_/S0 _13910_/S VPWR VGND sg13g2_buf_2
XFILLER_33_1873 VPWR VGND sg13g2_decap_8
Xrebuffer5261 _14699_/A _13858_/B VPWR VGND sg13g2_buf_1
Xplace4293 _11737_/S _11387_/A VPWR VGND sg13g2_buf_1
Xrebuffer5272 _15000_/B2 _13155_/Y VPWR VGND sg13g2_buf_8
X_21497_ _23765_/D _21924_/A1 _21502_/B _21496_/Y VPWR VGND sg13g2_o21ai_1
XFILLER_101_1231 VPWR VGND sg13g2_fill_2
Xrebuffer5283 _11661_/B place3728/A VPWR VGND sg13g2_buf_1
Xplace3570 _20082_/A _20031_/A VPWR VGND sg13g2_buf_1
Xrebuffer5294 _15096_/A1 _13886_/Y VPWR VGND sg13g2_buf_8
Xplace3581 _20062_/B _19474_/X VPWR VGND sg13g2_buf_1
X_23236_ _23236_/Q _24196_/CLK _23236_/D fanout2704/X VPWR VGND sg13g2_dfrbpq_1
X_11250_ _11250_/Y _11250_/A _22970_/Q VPWR VGND sg13g2_nor2b_1
Xplace3592 _20005_/A _19762_/A VPWR VGND sg13g2_buf_1
X_20448_ _23286_/D _19628_/Y _20458_/B _20447_/Y VPWR VGND sg13g2_o21ai_1
Xrebuffer4571 _20360_/B2 _13996_/Y VPWR VGND sg13g2_buf_1
XFILLER_109_63 VPWR VGND sg13g2_decap_8
Xrebuffer4582 _11983_/D _11776_/Y VPWR VGND sg13g2_buf_2
XFILLER_10_1158 VPWR VGND sg13g2_fill_1
Xrebuffer4593 _12950_/B _12797_/Y VPWR VGND sg13g2_buf_2
XFILLER_106_365 VPWR VGND sg13g2_decap_4
X_23167_ _23167_/Q clkload17/A _23167_/D fanout2857/X VPWR VGND sg13g2_dfrbpq_1
X_20379_ _23254_/D _21297_/A1 _20388_/B _20378_/Y VPWR VGND sg13g2_o21ai_1
XFILLER_49_1379 VPWR VGND sg13g2_decap_4
XFILLER_27_1622 VPWR VGND sg13g2_fill_1
X_22118_ _24052_/D _22317_/A1 _22117_/B _22117_/Y VPWR VGND sg13g2_o21ai_1
X_23098_ _23098_/Q clkload14/A _23098_/D fanout2903/X VPWR VGND sg13g2_dfrbpq_1
XFILLER_66_1693 VPWR VGND sg13g2_decap_4
XFILLER_76_912 VPWR VGND sg13g2_fill_1
XFILLER_23_1508 VPWR VGND sg13g2_decap_8
X_14940_ _14940_/Y _14940_/A VPWR VGND sg13g2_inv_1
X_22049_ _24020_/D _22317_/A1 _22048_/B _22048_/Y VPWR VGND sg13g2_o21ai_1
XFILLER_87_271 VPWR VGND sg13g2_decap_8
XFILLER_0_687 VPWR VGND sg13g2_fill_2
XFILLER_48_625 VPWR VGND sg13g2_decap_8
XFILLER_102_582 VPWR VGND sg13g2_decap_8
XFILLER_48_636 VPWR VGND sg13g2_fill_1
XFILLER_75_422 VPWR VGND sg13g2_fill_1
XFILLER_76_956 VPWR VGND sg13g2_fill_1
XFILLER_40_1833 VPWR VGND sg13g2_decap_4
X_14871_ _14871_/Y _14871_/A _14871_/B _14956_/C VPWR VGND sg13g2_nand3_1
XFILLER_60_1270 VPWR VGND sg13g2_decap_4
X_16610_ _16610_/Y _16610_/A _16610_/B VPWR VGND sg13g2_nor2_1
XFILLER_112_1360 VPWR VGND sg13g2_fill_2
XFILLER_85_99 VPWR VGND sg13g2_decap_8
XFILLER_29_872 VPWR VGND sg13g2_decap_8
X_13822_ _13822_/X _23858_/Q _23890_/Q _23954_/Q _23986_/Q _13173_/S _13981_/S1 VPWR
+ VGND sg13g2_mux4_1
X_17590_ _17597_/A _23161_/Q _17590_/B VPWR VGND sg13g2_nand2_1
XFILLER_47_179 VPWR VGND sg13g2_decap_8
XFILLER_5_1495 VPWR VGND sg13g2_fill_1
XFILLER_62_116 VPWR VGND sg13g2_decap_4
XFILLER_63_639 VPWR VGND sg13g2_decap_8
X_16541_ _16542_/B _22623_/Q _16541_/B VPWR VGND sg13g2_xnor2_1
X_13753_ _13753_/Y _13753_/A _13753_/B VPWR VGND sg13g2_nand2_1
XFILLER_43_330 VPWR VGND sg13g2_decap_8
XFILLER_56_1317 VPWR VGND sg13g2_fill_1
XFILLER_44_875 VPWR VGND sg13g2_decap_8
X_12704_ _12726_/A _23170_/Q _12640_/B _13182_/B2 _12703_/X VPWR VGND sg13g2_a22oi_1
X_19260_ _19262_/A _19259_/Y _19260_/B VPWR VGND sg13g2_nand2b_1
X_13684_ _13684_/Y _23568_/Q _13975_/A2 _13683_/X _13978_/S1 VPWR VGND sg13g2_a22oi_1
X_16472_ _16472_/Y _22599_/Q _16472_/B VPWR VGND sg13g2_nand2_1
X_15423_ _15423_/Y _22689_/Q _15487_/A2 _15487_/B1 _22625_/Q VPWR VGND sg13g2_a22oi_1
XFILLER_19_1150 VPWR VGND sg13g2_fill_1
XFILLER_34_1604 VPWR VGND sg13g2_decap_8
X_12635_ _12635_/Y _12829_/B _14358_/B _12766_/A _20013_/B _12759_/A VPWR VGND sg13g2_a221oi_1
XFILLER_19_1161 VPWR VGND sg13g2_decap_4
X_19191_ _19191_/Y _19237_/S _19190_/Y _23192_/Q VPWR VGND sg13g2_a21oi_1
XFILLER_54_1052 VPWR VGND sg13g2_decap_8
XFILLER_12_761 VPWR VGND sg13g2_fill_2
XFILLER_12_772 VPWR VGND sg13g2_decap_8
Xoutput4508 data_wdata_o[14] _14717_/X VPWR VGND sg13g2_buf_1
X_18142_ _18144_/A _18498_/A _18274_/B VPWR VGND sg13g2_nor2_1
Xoutput4519 data_wdata_o[24] _14732_/X VPWR VGND sg13g2_buf_1
X_12566_ _12566_/X _23553_/Q _24001_/Q _12570_/S VPWR VGND sg13g2_mux2_1
XFILLER_79_7 VPWR VGND sg13g2_decap_4
XFILLER_106_1186 VPWR VGND sg13g2_fill_2
X_11517_ _11517_/X _11515_/X _11516_/X _11517_/S VPWR VGND sg13g2_mux2_1
X_14305_ _16776_/B _16781_/A _15294_/C _15165_/C VPWR VGND sg13g2_a21o_1
XFILLER_11_293 VPWR VGND sg13g2_decap_8
XFILLER_106_1197 VPWR VGND sg13g2_fill_1
XFILLER_8_776 VPWR VGND sg13g2_decap_8
XFILLER_7_242 VPWR VGND sg13g2_decap_8
X_12497_ _12504_/A _12774_/B _12497_/B VPWR VGND sg13g2_nor2_1
XFILLER_12_1946 VPWR VGND sg13g2_decap_8
XFILLER_7_264 VPWR VGND sg13g2_fill_2
X_17024_ _17025_/B _17024_/A _17028_/B VPWR VGND sg13g2_nor2b_1
X_14236_ _14236_/Y _24220_/Q _15133_/B _14400_/B VPWR VGND sg13g2_nor3_1
XFILLER_67_1402 VPWR VGND sg13g2_decap_4
X_11448_ _11448_/X _11681_/A _11501_/B VPWR VGND sg13g2_and2_1
XFILLER_67_1413 VPWR VGND sg13g2_fill_1
X_14167_ _14184_/B _14167_/A VPWR VGND sg13g2_inv_1
X_11379_ _11379_/Y _11393_/A _11915_/S VPWR VGND sg13g2_nor2_2
X_13118_ _13118_/Y _23560_/Q _13975_/A2 _13117_/X _13115_/A VPWR VGND sg13g2_a22oi_1
XFILLER_112_335 VPWR VGND sg13g2_fill_1
XFILLER_113_869 VPWR VGND sg13g2_decap_8
X_18975_ _18975_/Y _19008_/A _18975_/B _18975_/C VPWR VGND sg13g2_nand3_1
X_14098_ _14428_/A _14098_/A _14098_/B _14098_/C VPWR VGND sg13g2_nor3_1
XFILLER_98_569 VPWR VGND sg13g2_decap_8
XFILLER_79_750 VPWR VGND sg13g2_decap_8
XFILLER_45_1755 VPWR VGND sg13g2_fill_1
X_17926_ _17928_/A _17926_/A1 _17926_/A2 _17929_/B1 _17220_/A VPWR VGND sg13g2_a22oi_1
XFILLER_39_603 VPWR VGND sg13g2_fill_2
X_13049_ _13049_/X _23719_/Q _23751_/Q _23783_/Q _23815_/Q _13232_/S _13042_/A VPWR
+ VGND sg13g2_mux4_1
XFILLER_26_1154 VPWR VGND sg13g2_decap_4
XFILLER_66_400 VPWR VGND sg13g2_fill_1
XFILLER_67_923 VPWR VGND sg13g2_decap_8
XFILLER_61_1045 VPWR VGND sg13g2_decap_8
XFILLER_6_1237 VPWR VGND sg13g2_decap_8
XFILLER_94_731 VPWR VGND sg13g2_fill_2
XFILLER_26_1176 VPWR VGND sg13g2_decap_8
XFILLER_78_293 VPWR VGND sg13g2_fill_1
XFILLER_66_433 VPWR VGND sg13g2_decap_4
XFILLER_38_146 VPWR VGND sg13g2_fill_2
XFILLER_66_455 VPWR VGND sg13g2_decap_8
XFILLER_93_241 VPWR VGND sg13g2_decap_8
XFILLER_82_915 VPWR VGND sg13g2_decap_8
XFILLER_96_1108 VPWR VGND sg13g2_decap_8
X_16808_ _16809_/B _16833_/A _16812_/C VPWR VGND sg13g2_nor2_1
X_17788_ _17788_/Y _17197_/A _17810_/A2 _17810_/B1 _17787_/Y VPWR VGND sg13g2_a22oi_1
XFILLER_78_1553 VPWR VGND sg13g2_fill_1
XFILLER_39_1504 VPWR VGND sg13g2_decap_8
X_16739_ _16740_/B _22662_/Q _16748_/C VPWR VGND sg13g2_nand2_1
XFILLER_39_1515 VPWR VGND sg13g2_fill_2
XFILLER_1_1860 VPWR VGND sg13g2_decap_8
XFILLER_34_352 VPWR VGND sg13g2_decap_8
X_19458_ _19459_/B _19455_/Y _19457_/Y _19587_/A VPWR VGND sg13g2_mux2_1
XFILLER_35_897 VPWR VGND sg13g2_decap_8
XFILLER_22_525 VPWR VGND sg13g2_decap_8
X_18409_ _18410_/C _18562_/A _18402_/Y _18408_/Y VPWR VGND sg13g2_o21ai_1
X_19389_ _19389_/Y _19673_/B _19367_/B _19388_/Y VPWR VGND sg13g2_a21oi_1
XFILLER_17_1857 VPWR VGND sg13g2_decap_8
X_21420_ _23730_/D _21619_/A1 _21422_/B _21419_/Y VPWR VGND sg13g2_o21ai_1
XFILLER_104_1838 VPWR VGND sg13g2_decap_8
XFILLER_108_608 VPWR VGND sg13g2_decap_8
X_21351_ _23698_/D _21619_/A1 _21353_/B _21350_/Y VPWR VGND sg13g2_o21ai_1
XFILLER_11_1423 VPWR VGND sg13g2_decap_8
XFILLER_50_1483 VPWR VGND sg13g2_fill_2
X_20302_ _20302_/X _19956_/A _15950_/C _20345_/A1 VPWR VGND sg13g2_a21o_1
X_24070_ _24070_/Q clkload37/A _24070_/D fanout2707/X VPWR VGND sg13g2_dfrbpq_1
X_21282_ _23664_/D _21616_/A1 _21281_/B _21281_/Y VPWR VGND sg13g2_o21ai_1
XFILLER_85_1513 VPWR VGND sg13g2_fill_1
X_23021_ _23021_/Q clkload11/A _23021_/D fanout2808/X VPWR VGND sg13g2_dfrbpq_1
XFILLER_115_140 VPWR VGND sg13g2_decap_8
X_20233_ _20234_/B _13517_/B _20233_/A2 _20232_/Y VPWR VGND sg13g2_a21oi_1
XFILLER_89_525 VPWR VGND sg13g2_fill_2
XFILLER_28_1942 VPWR VGND sg13g2_decap_8
X_20164_ _20164_/Y _20164_/A _20166_/B _20338_/C VPWR VGND sg13g2_nand3_1
XFILLER_28_1953 VPWR VGND sg13g2_fill_2
XFILLER_44_1210 VPWR VGND sg13g2_decap_4
XFILLER_39_48 VPWR VGND sg13g2_decap_8
XFILLER_58_923 VPWR VGND sg13g2_decap_8
XFILLER_115_1945 VPWR VGND sg13g2_decap_8
XFILLER_112_880 VPWR VGND sg13g2_decap_8
X_20095_ _20095_/X _20095_/A0 _20098_/A3 _23196_/Q VPWR VGND sg13g2_mux2_1
XFILLER_69_260 VPWR VGND sg13g2_decap_8
XFILLER_97_580 VPWR VGND sg13g2_decap_8
XFILLER_85_720 VPWR VGND sg13g2_fill_2
XFILLER_40_1118 VPWR VGND sg13g2_decap_8
X_23923_ _23923_/Q clkload47/A _23923_/D fanout2662/X VPWR VGND sg13g2_dfrbpq_1
XFILLER_29_157 VPWR VGND sg13g2_fill_1
XFILLER_58_989 VPWR VGND sg13g2_fill_1
XFILLER_72_403 VPWR VGND sg13g2_decap_8
XFILLER_2_1624 VPWR VGND sg13g2_decap_4
XFILLER_45_628 VPWR VGND sg13g2_decap_8
X_23854_ _23854_/Q clkload49/A _23854_/D fanout2674/X VPWR VGND sg13g2_dfrbpq_1
XFILLER_45_639 VPWR VGND sg13g2_fill_2
XFILLER_73_948 VPWR VGND sg13g2_decap_8
XFILLER_84_296 VPWR VGND sg13g2_decap_4
X_22805_ _22805_/Q clkload10/A _22805_/D fanout2811/X VPWR VGND sg13g2_dfrbpq_1
XFILLER_77_1030 VPWR VGND sg13g2_decap_8
X_23785_ _23785_/Q _24113_/CLK _23785_/D fanout2684/X VPWR VGND sg13g2_dfrbpq_1
X_20997_ _20997_/Y _20997_/A _21013_/B VPWR VGND sg13g2_nand2_1
XFILLER_26_864 VPWR VGND sg13g2_decap_4
XFILLER_111_42 VPWR VGND sg13g2_decap_8
XFILLER_96_1697 VPWR VGND sg13g2_decap_8
X_22736_ _22736_/Q clkload20/A _22736_/D fanout2868/X VPWR VGND sg13g2_dfrbpq_1
XFILLER_53_683 VPWR VGND sg13g2_decap_8
XFILLER_0_1381 VPWR VGND sg13g2_decap_4
XFILLER_40_311 VPWR VGND sg13g2_decap_4
X_22667_ _22667_/Q _22733_/CLK _22667_/D fanout2880/X VPWR VGND sg13g2_dfrbpq_1
XFILLER_9_518 VPWR VGND sg13g2_decap_8
XFILLER_90_1252 VPWR VGND sg13g2_decap_8
X_12420_ _12435_/B _12429_/A _12515_/B VPWR VGND sg13g2_xnor2_1
XFILLER_71_79 VPWR VGND sg13g2_fill_2
XFILLER_107_1462 VPWR VGND sg13g2_fill_1
XFILLER_40_377 VPWR VGND sg13g2_decap_8
X_21618_ _21618_/Y _21618_/A _21621_/B VPWR VGND sg13g2_nand2_1
X_22598_ _22598_/Q clkload22/A _22598_/D fanout2875/X VPWR VGND sg13g2_dfrbpq_1
X_12351_ _12352_/B _12349_/Y _12350_/Y _15491_/A VPWR VGND sg13g2_o21ai_1
XFILLER_16_1389 VPWR VGND sg13g2_decap_8
X_21549_ _21549_/Y _21549_/A _21549_/B VPWR VGND sg13g2_nand2_1
Xplace4090 _19884_/A _19912_/S VPWR VGND sg13g2_buf_1
X_11302_ _11302_/X _13858_/A _11302_/B VPWR VGND sg13g2_and2_1
X_15070_ _15071_/B _22538_/Q _15070_/B VPWR VGND sg13g2_nor2_1
X_12282_ _12283_/B _12280_/X _12281_/X _12406_/A VPWR VGND sg13g2_mux2_1
X_24268_ _24268_/X _24268_/A VPWR VGND sg13g2_buf_1
XFILLER_4_223 VPWR VGND sg13g2_decap_8
XFILLER_5_757 VPWR VGND sg13g2_fill_1
XFILLER_5_768 VPWR VGND sg13g2_fill_2
XFILLER_105_0 VPWR VGND sg13g2_decap_8
X_14021_ _14022_/B _14039_/A _14021_/B VPWR VGND sg13g2_xnor2_1
XFILLER_49_1121 VPWR VGND sg13g2_decap_4
XFILLER_107_663 VPWR VGND sg13g2_fill_1
XFILLER_106_140 VPWR VGND sg13g2_decap_8
X_23219_ _23219_/Q clkload33/A _23219_/D fanout2931/X VPWR VGND sg13g2_dfrbpq_1
X_11233_ _11234_/C _14124_/A _11602_/B _19360_/A _11233_/D VPWR VGND sg13g2_or4_1
XFILLER_88_1192 VPWR VGND sg13g2_fill_1
XFILLER_20_72 VPWR VGND sg13g2_fill_1
X_24199_ _24199_/Q clkload38/A _24199_/D fanout2697/X VPWR VGND sg13g2_dfrbpq_1
XFILLER_96_21 VPWR VGND sg13g2_decap_8
XFILLER_49_901 VPWR VGND sg13g2_fill_2
XFILLER_7_1513 VPWR VGND sg13g2_fill_2
XFILLER_49_912 VPWR VGND sg13g2_fill_1
XFILLER_62_1332 VPWR VGND sg13g2_fill_2
XFILLER_7_1524 VPWR VGND sg13g2_decap_8
X_15972_ _15975_/C _15971_/Y _15972_/B VPWR VGND sg13g2_nand2b_1
XFILLER_27_1463 VPWR VGND sg13g2_fill_2
XFILLER_42_1917 VPWR VGND sg13g2_fill_2
XFILLER_76_731 VPWR VGND sg13g2_decap_8
X_17711_ _17711_/Y _17141_/A _17382_/A _17580_/B _17710_/Y VPWR VGND sg13g2_a22oi_1
XFILLER_49_956 VPWR VGND sg13g2_decap_8
X_14923_ _14923_/Y _22524_/Q VPWR VGND sg13g2_inv_1
X_18691_ _18694_/B _18697_/A _18696_/B VPWR VGND sg13g2_nor2b_1
XFILLER_29_81 VPWR VGND sg13g2_decap_8
XFILLER_64_904 VPWR VGND sg13g2_decap_8
XFILLER_110_1308 VPWR VGND sg13g2_fill_2
XFILLER_29_92 VPWR VGND sg13g2_fill_2
XFILLER_76_775 VPWR VGND sg13g2_fill_1
XFILLER_36_628 VPWR VGND sg13g2_decap_4
X_17642_ _17642_/Y _22887_/Q _17642_/B VPWR VGND sg13g2_nor2_1
X_14854_ _14854_/Y _22915_/Q _14854_/B VPWR VGND sg13g2_nor2_1
XFILLER_91_734 VPWR VGND sg13g2_fill_2
XFILLER_17_831 VPWR VGND sg13g2_fill_2
XFILLER_64_959 VPWR VGND sg13g2_decap_8
X_13805_ _13805_/Y _14321_/A _13904_/B VPWR VGND sg13g2_nand2_1
XFILLER_17_853 VPWR VGND sg13g2_fill_1
X_17573_ _17573_/Y _17573_/A _22951_/Q VPWR VGND sg13g2_nand2_1
X_14785_ _14956_/C _14790_/B _14789_/B VPWR VGND sg13g2_nor2_1
XFILLER_16_341 VPWR VGND sg13g2_decap_4
XFILLER_44_661 VPWR VGND sg13g2_decap_8
X_16524_ _16565_/B _17034_/B _17034_/D _16524_/C VPWR VGND sg13g2_nor3_1
XFILLER_90_277 VPWR VGND sg13g2_decap_8
XFILLER_90_288 VPWR VGND sg13g2_decap_8
XFILLER_17_897 VPWR VGND sg13g2_fill_2
X_13736_ _13736_/Y _13736_/A _13736_/B VPWR VGND sg13g2_xnor2_1
XFILLER_75_1759 VPWR VGND sg13g2_fill_2
XFILLER_90_299 VPWR VGND sg13g2_fill_2
XFILLER_32_845 VPWR VGND sg13g2_decap_8
X_19243_ _19243_/Y _19263_/A _19243_/B VPWR VGND sg13g2_nor2_1
X_16455_ _22591_/D _16058_/A _16470_/B _16454_/Y VPWR VGND sg13g2_o21ai_1
XFILLER_38_1570 VPWR VGND sg13g2_decap_4
XFILLER_31_355 VPWR VGND sg13g2_fill_1
XFILLER_32_878 VPWR VGND sg13g2_decap_8
X_13667_ _13667_/Y _23183_/Q _19197_/A VPWR VGND sg13g2_nand2_1
X_15406_ _15406_/X _15410_/A _15996_/A VPWR VGND sg13g2_and2_1
X_19174_ _23145_/D _23145_/Q _15023_/X _19181_/S VPWR VGND sg13g2_mux2_1
X_13598_ _13598_/X _13778_/A1 _13923_/A2 _22573_/Q VPWR VGND sg13g2_a21o_1
X_16386_ _22557_/D _15545_/Y _16388_/B _16385_/Y VPWR VGND sg13g2_o21ai_1
X_18125_ _18125_/Y _18125_/A _18140_/B VPWR VGND sg13g2_nand2_1
X_18056_ _18174_/B _18494_/A _18479_/C _18366_/A _18332_/A VPWR VGND sg13g2_nor4_1
XANTENNA_1 _20140_/Y VPWR VGND sg13g2_antennanp
XFILLER_103_1882 VPWR VGND sg13g2_decap_8
X_15268_ _16789_/C _15268_/A _15268_/B VPWR VGND sg13g2_nor2_1
XFILLER_86_1833 VPWR VGND sg13g2_decap_8
X_17007_ _22710_/D _17007_/A1 _17005_/Y _17006_/Y VPWR VGND sg13g2_o21ai_1
X_14219_ _14220_/B _14219_/A _14219_/B VPWR VGND sg13g2_and2_1
XFILLER_67_1232 VPWR VGND sg13g2_fill_1
XFILLER_82_1719 VPWR VGND sg13g2_decap_8
XFILLER_99_878 VPWR VGND sg13g2_fill_2
XFILLER_113_666 VPWR VGND sg13g2_decap_8
XFILLER_112_154 VPWR VGND sg13g2_decap_8
XFILLER_80_1421 VPWR VGND sg13g2_fill_2
X_18958_ _18958_/Y _18955_/A _18958_/B _18958_/C VPWR VGND sg13g2_nand3b_1
XFILLER_20_0 VPWR VGND sg13g2_fill_1
XFILLER_6_1034 VPWR VGND sg13g2_decap_8
X_17909_ _17910_/B _22934_/Q _17909_/B VPWR VGND sg13g2_nand2_1
X_18889_ _18891_/B _18886_/Y _18889_/B VPWR VGND sg13g2_nand2b_1
XFILLER_67_764 VPWR VGND sg13g2_fill_2
XFILLER_3_1911 VPWR VGND sg13g2_decap_8
XFILLER_27_606 VPWR VGND sg13g2_fill_1
XFILLER_55_915 VPWR VGND sg13g2_fill_2
XFILLER_94_572 VPWR VGND sg13g2_decap_8
XFILLER_39_477 VPWR VGND sg13g2_decap_8
XFILLER_54_403 VPWR VGND sg13g2_decap_8
X_20920_ _23508_/D _21983_/A1 _20919_/B _20919_/Y VPWR VGND sg13g2_o21ai_1
XFILLER_39_488 VPWR VGND sg13g2_fill_1
XFILLER_110_1831 VPWR VGND sg13g2_decap_8
XFILLER_93_1804 VPWR VGND sg13g2_fill_1
X_20851_ _23474_/D _21980_/A1 _20853_/B _20850_/Y VPWR VGND sg13g2_o21ai_1
XFILLER_70_907 VPWR VGND sg13g2_decap_8
XFILLER_82_789 VPWR VGND sg13g2_fill_2
XFILLER_25_28 VPWR VGND sg13g2_decap_8
XFILLER_39_1323 VPWR VGND sg13g2_decap_4
XFILLER_93_1837 VPWR VGND sg13g2_decap_8
XFILLER_41_108 VPWR VGND sg13g2_decap_8
XFILLER_19_1919 VPWR VGND sg13g2_decap_8
X_23570_ _23570_/Q _24210_/CLK _23570_/D fanout2624/X VPWR VGND sg13g2_dfrbpq_1
XFILLER_81_299 VPWR VGND sg13g2_fill_1
X_20782_ _23442_/D _21980_/A1 _20784_/B _20781_/Y VPWR VGND sg13g2_o21ai_1
XFILLER_34_171 VPWR VGND sg13g2_decap_8
XFILLER_50_620 VPWR VGND sg13g2_fill_1
X_22521_ _22521_/Q clkload6/A _22521_/D fanout2834/X VPWR VGND sg13g2_dfrbpq_1
XFILLER_23_878 VPWR VGND sg13g2_decap_8
XFILLER_22_355 VPWR VGND sg13g2_fill_1
XFILLER_91_1572 VPWR VGND sg13g2_decap_4
XFILLER_22_366 VPWR VGND sg13g2_decap_4
X_22452_ _22452_/Q clkload28/A _22452_/D fanout2855/X VPWR VGND sg13g2_dfrbpq_1
XFILLER_109_917 VPWR VGND sg13g2_decap_8
XFILLER_104_1646 VPWR VGND sg13g2_decap_8
X_22383_ _22383_/Y _22383_/A _22383_/B VPWR VGND sg13g2_nand2_1
XFILLER_87_1608 VPWR VGND sg13g2_decap_8
XFILLER_104_1679 VPWR VGND sg13g2_fill_2
X_24122_ _24122_/Q clkload48/A _24122_/D fanout2689/X VPWR VGND sg13g2_dfrbpq_1
XFILLER_11_1253 VPWR VGND sg13g2_fill_1
X_24053_ _24053_/Q clkload48/A _24053_/D fanout2681/X VPWR VGND sg13g2_dfrbpq_1
XFILLER_89_300 VPWR VGND sg13g2_fill_1
X_21265_ _23654_/D _21331_/A1 _21264_/B _21264_/Y VPWR VGND sg13g2_o21ai_1
XFILLER_9_7 VPWR VGND sg13g2_fill_2
XFILLER_1_215 VPWR VGND sg13g2_fill_1
Xfanout2708 fanout2708/X fanout2712/X VPWR VGND sg13g2_buf_1
X_23004_ _23004_/Q clkload26/A _23004_/D fanout2853/X VPWR VGND sg13g2_dfrbpq_1
XFILLER_65_1939 VPWR VGND sg13g2_decap_8
Xfanout2719 fanout2719/X fanout2721/X VPWR VGND sg13g2_buf_1
X_20216_ _20216_/Y _20215_/X _20352_/A VPWR VGND sg13g2_nand2b_1
XFILLER_46_1327 VPWR VGND sg13g2_decap_8
X_21196_ _23621_/D _21329_/A1 _21197_/B _21195_/Y VPWR VGND sg13g2_o21ai_1
XFILLER_104_666 VPWR VGND sg13g2_decap_8
XFILLER_8_1811 VPWR VGND sg13g2_decap_8
XFILLER_28_1750 VPWR VGND sg13g2_fill_2
XFILLER_106_42 VPWR VGND sg13g2_decap_8
X_20147_ _20147_/Y _20147_/A _20147_/B VPWR VGND sg13g2_nand2_1
XFILLER_103_187 VPWR VGND sg13g2_decap_4
XFILLER_115_1742 VPWR VGND sg13g2_decap_8
XFILLER_98_1704 VPWR VGND sg13g2_fill_2
XFILLER_8_1888 VPWR VGND sg13g2_decap_8
X_20078_ _20078_/Y _20078_/A _20269_/B VPWR VGND sg13g2_nand2_1
XFILLER_57_241 VPWR VGND sg13g2_fill_2
XFILLER_66_57 VPWR VGND sg13g2_decap_8
X_11920_ _11921_/C _23546_/Q _12922_/A2 _11919_/X _12039_/A _11920_/C1 VPWR VGND sg13g2_a221oi_1
XFILLER_45_414 VPWR VGND sg13g2_fill_2
X_23906_ _23906_/Q _24131_/CLK _23906_/D fanout2749/X VPWR VGND sg13g2_dfrbpq_1
XFILLER_73_734 VPWR VGND sg13g2_decap_8
XFILLER_45_436 VPWR VGND sg13g2_decap_8
XFILLER_73_745 VPWR VGND sg13g2_fill_1
X_11851_ _11852_/B _23769_/Q _23801_/Q _11855_/S VPWR VGND sg13g2_mux2_1
X_23837_ _23837_/Q clkload59/A _23837_/D fanout2784/X VPWR VGND sg13g2_dfrbpq_1
XFILLER_57_1401 VPWR VGND sg13g2_fill_2
XFILLER_72_244 VPWR VGND sg13g2_fill_1
XFILLER_57_1412 VPWR VGND sg13g2_fill_2
XFILLER_32_119 VPWR VGND sg13g2_fill_1
XFILLER_60_428 VPWR VGND sg13g2_decap_8
X_23768_ _23768_/Q _24113_/CLK _23768_/D fanout2688/X VPWR VGND sg13g2_dfrbpq_1
X_11782_ _24248_/A _11782_/A _11782_/B VPWR VGND sg13g2_or2_1
XFILLER_53_480 VPWR VGND sg13g2_fill_1
XFILLER_82_78 VPWR VGND sg13g2_decap_4
XFILLER_13_322 VPWR VGND sg13g2_fill_2
XFILLER_41_631 VPWR VGND sg13g2_decap_8
XFILLER_53_491 VPWR VGND sg13g2_decap_8
XFILLER_15_50 VPWR VGND sg13g2_decap_8
X_13521_ _13522_/D _13521_/A1 _13519_/Y _13520_/X VPWR VGND sg13g2_a21o_1
X_22719_ _22719_/Q clkload23/A _22719_/D fanout2887/X VPWR VGND sg13g2_dfrbpq_1
XFILLER_15_61 VPWR VGND sg13g2_fill_2
X_23699_ _23699_/Q clkload51/A _23699_/D fanout2664/X VPWR VGND sg13g2_dfrbpq_1
XFILLER_41_675 VPWR VGND sg13g2_decap_8
XFILLER_70_1612 VPWR VGND sg13g2_fill_2
X_13452_ _13453_/B _23853_/Q _23885_/Q _23949_/Q _23981_/Q _13635_/S0 _13631_/S1 VPWR
+ VGND sg13g2_mux4_1
X_16240_ _16243_/A _16240_/A _16240_/B VPWR VGND sg13g2_nor2_1
XFILLER_70_1634 VPWR VGND sg13g2_decap_4
XFILLER_41_697 VPWR VGND sg13g2_decap_8
XFILLER_90_1082 VPWR VGND sg13g2_decap_8
X_12403_ _12403_/Y _13234_/B2 _12400_/Y _12402_/Y _13587_/B2 VPWR VGND sg13g2_a22oi_1
XFILLER_70_1667 VPWR VGND sg13g2_fill_2
XFILLER_51_1055 VPWR VGND sg13g2_decap_8
X_16171_ _16171_/Y _16171_/A _16177_/B VPWR VGND sg13g2_nand2_1
XFILLER_51_1066 VPWR VGND sg13g2_fill_1
X_13383_ _13651_/A _13383_/A _13383_/B _13383_/C VPWR VGND sg13g2_or3_1
XFILLER_103_1134 VPWR VGND sg13g2_fill_1
XFILLER_103_1145 VPWR VGND sg13g2_decap_8
X_15122_ _15126_/B _15123_/B _15121_/X _24231_/Q VPWR VGND sg13g2_a21oi_1
XFILLER_99_108 VPWR VGND sg13g2_decap_8
X_19930_ _19930_/Y _19930_/A _19930_/B VPWR VGND sg13g2_nor2_1
XFILLER_5_565 VPWR VGND sg13g2_decap_8
X_15053_ _15053_/X _23148_/Q _16323_/C _15120_/S VPWR VGND sg13g2_mux2_1
XFILLER_107_460 VPWR VGND sg13g2_fill_2
XFILLER_107_471 VPWR VGND sg13g2_decap_8
X_14004_ _14008_/A _14005_/A _14004_/B _14006_/B VPWR VGND sg13g2_nand3_1
X_11216_ _11243_/A _14124_/A _11596_/C _11326_/D VPWR VGND sg13g2_nor3_2
XFILLER_68_1585 VPWR VGND sg13g2_decap_4
X_19861_ _19861_/Y _19861_/A _19861_/B VPWR VGND sg13g2_nand2_1
X_12196_ _12196_/X _23549_/Q _23997_/Q _12321_/S VPWR VGND sg13g2_mux2_1
XFILLER_96_804 VPWR VGND sg13g2_decap_8
X_18812_ _18814_/B _18809_/Y _18810_/Y _18824_/S VPWR VGND sg13g2_mux2_1
XFILLER_68_517 VPWR VGND sg13g2_decap_8
X_19792_ _23225_/D _19950_/B _19788_/Y _19791_/Y VPWR VGND sg13g2_o21ai_1
X_18743_ _18744_/B _18602_/A _18742_/Y _15089_/Y VPWR VGND sg13g2_a21oi_1
XFILLER_0_281 VPWR VGND sg13g2_fill_1
XFILLER_23_1113 VPWR VGND sg13g2_decap_8
XFILLER_49_742 VPWR VGND sg13g2_decap_8
XFILLER_110_669 VPWR VGND sg13g2_decap_8
X_15955_ _18741_/A _23026_/Q VPWR VGND sg13g2_inv_1
XFILLER_49_753 VPWR VGND sg13g2_fill_1
XFILLER_76_561 VPWR VGND sg13g2_decap_8
X_14906_ _16257_/A _24255_/A _18635_/A2 _14905_/Y VPWR VGND sg13g2_a21oi_1
XFILLER_76_572 VPWR VGND sg13g2_fill_2
X_18674_ _18677_/A _14990_/B _18678_/B _18673_/Y VPWR VGND sg13g2_a21oi_1
XFILLER_36_425 VPWR VGND sg13g2_decap_4
X_14837_ _14837_/Y _16438_/B _14837_/B VPWR VGND sg13g2_nand2_1
XFILLER_36_469 VPWR VGND sg13g2_fill_2
XFILLER_17_661 VPWR VGND sg13g2_decap_4
XFILLER_63_277 VPWR VGND sg13g2_decap_8
X_17556_ _17557_/B _17699_/B1 _17554_/X _17555_/X _17538_/B VPWR VGND sg13g2_a22oi_1
XFILLER_63_288 VPWR VGND sg13g2_fill_1
X_14768_ _14768_/Y _24224_/Q _14837_/B VPWR VGND sg13g2_nand2b_1
XFILLER_108_1012 VPWR VGND sg13g2_decap_8
XFILLER_36_1529 VPWR VGND sg13g2_decap_8
X_16507_ _22613_/D _16504_/Y _16506_/B _16506_/Y VPWR VGND sg13g2_o21ai_1
XFILLER_71_1409 VPWR VGND sg13g2_decap_4
X_17487_ _17487_/Y _17487_/A _17502_/S VPWR VGND sg13g2_nand2_1
X_14699_ _14699_/Y _14699_/A _14699_/B VPWR VGND sg13g2_nand2_1
X_19226_ _23180_/D _24269_/A _23180_/Q _19232_/B VPWR VGND sg13g2_mux2_1
XFILLER_32_686 VPWR VGND sg13g2_decap_4
X_16438_ _16441_/B _22619_/Q _16438_/B _17034_/D VPWR VGND sg13g2_nor3_1
XFILLER_105_1933 VPWR VGND sg13g2_decap_8
XFILLER_14_1816 VPWR VGND sg13g2_decap_8
XFILLER_20_859 VPWR VGND sg13g2_decap_8
XFILLER_34_1242 VPWR VGND sg13g2_decap_8
X_19157_ _23130_/D _23130_/Q _14869_/X _19159_/S VPWR VGND sg13g2_mux2_1
XFILLER_34_1275 VPWR VGND sg13g2_fill_2
XFILLER_30_1117 VPWR VGND sg13g2_decap_4
X_16369_ _22547_/D _16369_/A VPWR VGND sg13g2_inv_1
XFILLER_8_370 VPWR VGND sg13g2_decap_8
X_18108_ _18108_/Y _18108_/A _18119_/S VPWR VGND sg13g2_nand2_1
XFILLER_68_0 VPWR VGND sg13g2_decap_8
X_19088_ _23080_/D _23080_/Q _19087_/X _19099_/S VPWR VGND sg13g2_mux2_1
Xhold4805 _22001_/A _23995_/Q VPWR VGND sg13g2_dlygate4sd3_1
XFILLER_105_419 VPWR VGND sg13g2_fill_1
X_18039_ _18039_/X _18962_/A _23054_/Q _18052_/S VPWR VGND sg13g2_mux2_1
XFILLER_12_1595 VPWR VGND sg13g2_decap_8
Xhold4816 _22213_/A _24095_/Q VPWR VGND sg13g2_dlygate4sd3_1
Xhold4827 _21594_/A _23812_/Q VPWR VGND sg13g2_dlygate4sd3_1
XFILLER_47_1614 VPWR VGND sg13g2_decap_8
Xhold4838 _21392_/A _23715_/Q VPWR VGND sg13g2_dlygate4sd3_1
XFILLER_99_631 VPWR VGND sg13g2_decap_8
Xhold4849 _21032_/A _23552_/Q VPWR VGND sg13g2_dlygate4sd3_1
XFILLER_67_1051 VPWR VGND sg13g2_decap_4
XFILLER_86_1685 VPWR VGND sg13g2_fill_1
XFILLER_82_1527 VPWR VGND sg13g2_fill_1
XFILLER_87_804 VPWR VGND sg13g2_decap_4
XFILLER_113_463 VPWR VGND sg13g2_decap_8
XFILLER_98_152 VPWR VGND sg13g2_decap_8
X_20001_ _23232_/D _20052_/B _22414_/A1 _20000_/Y VPWR VGND sg13g2_o21ai_1
XFILLER_101_614 VPWR VGND sg13g2_decap_8
XFILLER_98_163 VPWR VGND sg13g2_fill_1
XFILLER_115_1016 VPWR VGND sg13g2_decap_8
XFILLER_80_1251 VPWR VGND sg13g2_fill_1
XFILLER_74_509 VPWR VGND sg13g2_fill_1
XFILLER_80_1284 VPWR VGND sg13g2_decap_8
XFILLER_55_701 VPWR VGND sg13g2_decap_8
XFILLER_28_937 VPWR VGND sg13g2_fill_1
X_21952_ _23970_/D _21952_/A1 _21951_/B _21951_/Y VPWR VGND sg13g2_o21ai_1
XFILLER_54_200 VPWR VGND sg13g2_decap_8
XFILLER_23_1691 VPWR VGND sg13g2_fill_2
X_20903_ _20903_/Y _20903_/A _20903_/B VPWR VGND sg13g2_nand2_1
XFILLER_36_49 VPWR VGND sg13g2_decap_8
XFILLER_27_458 VPWR VGND sg13g2_fill_1
XFILLER_55_767 VPWR VGND sg13g2_fill_1
X_21883_ _21883_/Y _21883_/A _21885_/B VPWR VGND sg13g2_nand2_1
XFILLER_82_564 VPWR VGND sg13g2_decap_8
XFILLER_3_1785 VPWR VGND sg13g2_decap_8
XFILLER_58_1721 VPWR VGND sg13g2_decap_4
XFILLER_82_575 VPWR VGND sg13g2_fill_2
XFILLER_14_108 VPWR VGND sg13g2_fill_2
X_23622_ _23622_/Q clkload42/A _23622_/D fanout2720/X VPWR VGND sg13g2_dfrbpq_1
XFILLER_19_1705 VPWR VGND sg13g2_decap_8
XFILLER_78_1191 VPWR VGND sg13g2_decap_8
XFILLER_93_1667 VPWR VGND sg13g2_decap_4
XFILLER_51_951 VPWR VGND sg13g2_fill_1
X_23553_ _23553_/Q _24131_/CLK _23553_/D fanout2715/X VPWR VGND sg13g2_dfrbpq_1
XFILLER_74_1055 VPWR VGND sg13g2_decap_8
XFILLER_11_815 VPWR VGND sg13g2_decap_8
XFILLER_35_1028 VPWR VGND sg13g2_decap_8
XFILLER_50_461 VPWR VGND sg13g2_decap_8
XFILLER_51_984 VPWR VGND sg13g2_decap_4
X_22504_ _22504_/Q _22941_/CLK _22504_/D fanout2802/X VPWR VGND sg13g2_dfrbpq_1
XFILLER_74_1088 VPWR VGND sg13g2_fill_2
X_23484_ _23484_/Q clkload53/A _23484_/D fanout2787/X VPWR VGND sg13g2_dfrbpq_1
XFILLER_91_1380 VPWR VGND sg13g2_decap_4
X_20696_ _23401_/D _22233_/A0 _23401_/Q _20706_/S VPWR VGND sg13g2_mux2_1
XFILLER_104_1421 VPWR VGND sg13g2_decap_8
XFILLER_13_1315 VPWR VGND sg13g2_decap_8
X_22435_ _24202_/D _22435_/A1 _22434_/B _22434_/Y VPWR VGND sg13g2_o21ai_1
XFILLER_13_1326 VPWR VGND sg13g2_fill_1
XFILLER_104_1454 VPWR VGND sg13g2_decap_8
XFILLER_6_329 VPWR VGND sg13g2_fill_2
XFILLER_108_224 VPWR VGND sg13g2_fill_2
XFILLER_108_235 VPWR VGND sg13g2_decap_4
X_22366_ _24169_/D _24169_/Q _22433_/A1 _22382_/S VPWR VGND sg13g2_mux2_1
XFILLER_11_1050 VPWR VGND sg13g2_decap_4
X_24105_ _24105_/Q _24205_/CLK _24105_/D fanout2671/X VPWR VGND sg13g2_dfrbpq_1
X_21317_ _23679_/D _21317_/A1 _21337_/B _21316_/Y VPWR VGND sg13g2_o21ai_1
X_12050_ _12050_/Y _13985_/B _12050_/B _12050_/C VPWR VGND sg13g2_nand3b_1
X_24036_ _24036_/Q clkload45/A _24036_/D fanout2715/X VPWR VGND sg13g2_dfrbpq_1
X_21248_ _23646_/D _21314_/A1 _21247_/B _21247_/Y VPWR VGND sg13g2_o21ai_1
XFILLER_81_1015 VPWR VGND sg13g2_fill_1
XFILLER_78_815 VPWR VGND sg13g2_decap_8
XFILLER_78_826 VPWR VGND sg13g2_fill_1
XFILLER_77_303 VPWR VGND sg13g2_decap_8
XFILLER_89_174 VPWR VGND sg13g2_decap_8
X_21179_ _21179_/Y _23614_/Q _21179_/B VPWR VGND sg13g2_nand2_1
XFILLER_46_1168 VPWR VGND sg13g2_decap_8
XFILLER_77_325 VPWR VGND sg13g2_decap_8
XFILLER_28_1591 VPWR VGND sg13g2_decap_8
XFILLER_92_306 VPWR VGND sg13g2_fill_1
XFILLER_86_870 VPWR VGND sg13g2_fill_2
XFILLER_58_572 VPWR VGND sg13g2_fill_1
X_15740_ _16145_/A _23017_/Q _22567_/Q _15982_/S VPWR VGND sg13g2_mux2_1
XFILLER_24_1488 VPWR VGND sg13g2_decap_8
X_12952_ _12952_/Y _20117_/B _12952_/B VPWR VGND sg13g2_nand2b_1
XFILLER_19_959 VPWR VGND sg13g2_fill_1
XFILLER_46_756 VPWR VGND sg13g2_decap_8
X_12883_ _12883_/Y _12884_/B _23717_/Q _12882_/Y VPWR VGND sg13g2_o21ai_1
X_17410_ _17410_/Y _22824_/Q _17412_/B VPWR VGND sg13g2_nand2_1
XFILLER_76_1832 VPWR VGND sg13g2_decap_8
X_14622_ _14622_/X _14615_/Y _14616_/Y _14622_/S VPWR VGND sg13g2_mux2_1
X_11834_ _11834_/Y _12243_/A _11834_/B VPWR VGND sg13g2_nor2_1
X_18390_ _18390_/Y _18103_/B _18386_/Y _18389_/Y _18232_/B _18194_/A VPWR VGND sg13g2_a221oi_1
XFILLER_76_1876 VPWR VGND sg13g2_decap_8
X_17341_ _17341_/Y _17341_/A _17341_/B VPWR VGND sg13g2_nand2_1
X_14553_ _14553_/Y _18742_/B _18742_/A VPWR VGND sg13g2_nand2_2
XFILLER_42_962 VPWR VGND sg13g2_decap_8
XFILLER_42_973 VPWR VGND sg13g2_fill_1
XFILLER_42_984 VPWR VGND sg13g2_decap_8
XFILLER_9_101 VPWR VGND sg13g2_fill_1
XFILLER_42_995 VPWR VGND sg13g2_fill_1
XFILLER_57_1297 VPWR VGND sg13g2_fill_1
XFILLER_41_472 VPWR VGND sg13g2_fill_1
X_17272_ _17272_/Y _17272_/A _17291_/B VPWR VGND sg13g2_nand2_1
XFILLER_109_1398 VPWR VGND sg13g2_decap_4
X_11696_ _11697_/B _23224_/Q _23352_/Q _11699_/S VPWR VGND sg13g2_mux2_1
X_14484_ _14486_/C _22615_/Q _23026_/Q VPWR VGND sg13g2_xor2_1
XFILLER_70_1431 VPWR VGND sg13g2_decap_4
X_19011_ _19013_/B _19008_/Y _19044_/B VPWR VGND sg13g2_nand2b_1
X_13435_ _13436_/A _13437_/B _13440_/B VPWR VGND sg13g2_nor2b_1
XFILLER_70_1464 VPWR VGND sg13g2_decap_8
XFILLER_9_178 VPWR VGND sg13g2_fill_2
XFILLER_31_1437 VPWR VGND sg13g2_decap_4
XFILLER_10_870 VPWR VGND sg13g2_fill_1
XFILLER_10_892 VPWR VGND sg13g2_decap_8
XFILLER_61_7 VPWR VGND sg13g2_fill_1
X_16154_ _16154_/X _16154_/A _16154_/B VPWR VGND sg13g2_and2_1
X_13366_ _13366_/X _15785_/A _20181_/A _13366_/C VPWR VGND sg13g2_or3_1
XFILLER_13_1871 VPWR VGND sg13g2_decap_8
X_15105_ _15105_/Y _15105_/A _15105_/B VPWR VGND sg13g2_nand2_1
XFILLER_6_885 VPWR VGND sg13g2_fill_2
X_12317_ _12318_/B _24062_/Q _24126_/Q _12321_/S VPWR VGND sg13g2_mux2_1
X_13297_ _13297_/Y _13293_/Y _13297_/B VPWR VGND sg13g2_nand2b_1
XFILLER_108_780 VPWR VGND sg13g2_decap_4
XFILLER_48_1923 VPWR VGND sg13g2_decap_4
XFILLER_114_238 VPWR VGND sg13g2_decap_8
XFILLER_64_1202 VPWR VGND sg13g2_decap_4
X_12248_ _12248_/X _23645_/Q _23677_/Q _12248_/S VPWR VGND sg13g2_mux2_1
X_19913_ _19913_/Y _19909_/X _19912_/X _20352_/A VPWR VGND sg13g2_a21oi_1
X_15036_ _15037_/B _22474_/Q _15006_/B _14966_/B VPWR VGND sg13g2_a21oi_1
XFILLER_9_1427 VPWR VGND sg13g2_decap_8
X_19844_ _19844_/Y _24251_/A _20286_/B VPWR VGND sg13g2_nand2_1
X_12179_ _19861_/A _12628_/A1 _12176_/Y _12178_/Y VPWR VGND sg13g2_a21o_1
XFILLER_3_42 VPWR VGND sg13g2_decap_8
XFILLER_69_848 VPWR VGND sg13g2_decap_8
XFILLER_64_1279 VPWR VGND sg13g2_fill_2
XFILLER_96_667 VPWR VGND sg13g2_decap_4
XFILLER_68_358 VPWR VGND sg13g2_fill_1
X_19775_ _19778_/C _20038_/A _19775_/B VPWR VGND sg13g2_nor2_1
XFILLER_81_1582 VPWR VGND sg13g2_decap_8
X_16987_ _16993_/B _22706_/Q VPWR VGND sg13g2_inv_1
XFILLER_110_466 VPWR VGND sg13g2_fill_1
XFILLER_83_306 VPWR VGND sg13g2_decap_8
XFILLER_7_1162 VPWR VGND sg13g2_decap_8
X_18726_ _18726_/Y _18726_/A _18726_/B VPWR VGND sg13g2_nand2_1
XFILLER_37_712 VPWR VGND sg13g2_decap_8
X_15938_ _15941_/B _22510_/Q _15767_/B _15969_/B _14208_/A VPWR VGND sg13g2_a22oi_1
XFILLER_37_734 VPWR VGND sg13g2_decap_4
XFILLER_97_1022 VPWR VGND sg13g2_decap_8
XFILLER_20_1820 VPWR VGND sg13g2_fill_2
XFILLER_76_380 VPWR VGND sg13g2_decap_8
XFILLER_36_222 VPWR VGND sg13g2_decap_4
XFILLER_64_531 VPWR VGND sg13g2_decap_4
XFILLER_97_1055 VPWR VGND sg13g2_decap_8
XFILLER_0_1914 VPWR VGND sg13g2_decap_8
X_18657_ _18658_/B _18657_/A _18657_/B _18661_/B _18657_/D VPWR VGND sg13g2_nor4_1
X_15869_ _22475_/D _16177_/A _15868_/X _15936_/S VPWR VGND sg13g2_mux2_1
XFILLER_25_918 VPWR VGND sg13g2_decap_4
XFILLER_52_704 VPWR VGND sg13g2_fill_2
XFILLER_92_884 VPWR VGND sg13g2_decap_8
XFILLER_91_372 VPWR VGND sg13g2_decap_8
X_17608_ _17608_/Y _17608_/A _17608_/B VPWR VGND sg13g2_nand2_1
XFILLER_51_203 VPWR VGND sg13g2_decap_8
XFILLER_18_992 VPWR VGND sg13g2_fill_1
XFILLER_52_737 VPWR VGND sg13g2_decap_8
XFILLER_75_1320 VPWR VGND sg13g2_decap_8
X_18588_ _19078_/S _18780_/S _14559_/C _18587_/Y VPWR VGND sg13g2_o21ai_1
X_17539_ _17540_/C _17621_/B _17538_/Y VPWR VGND sg13g2_nor2b_1
XFILLER_33_973 VPWR VGND sg13g2_decap_4
XFILLER_32_483 VPWR VGND sg13g2_decap_8
XFILLER_14_1602 VPWR VGND sg13g2_fill_1
Xplace3900 _18504_/A _18351_/A VPWR VGND sg13g2_buf_1
X_19209_ _23166_/D _24255_/A _23166_/Q _19209_/S VPWR VGND sg13g2_mux2_1
XFILLER_105_1741 VPWR VGND sg13g2_decap_8
Xplace3911 _18539_/A _18155_/A VPWR VGND sg13g2_buf_1
Xplace3922 _18822_/A _18803_/A VPWR VGND sg13g2_buf_1
X_20481_ _23301_/D _22425_/A1 _20482_/B _20480_/Y VPWR VGND sg13g2_o21ai_1
Xplace3933 _13924_/A2 _13988_/A2 VPWR VGND sg13g2_buf_1
XFILLER_14_1657 VPWR VGND sg13g2_fill_1
XFILLER_34_1083 VPWR VGND sg13g2_decap_4
X_22220_ _24098_/D _22286_/A1 _22219_/B _22219_/Y VPWR VGND sg13g2_o21ai_1
Xplace3944 _13587_/B2 _11393_/Y VPWR VGND sg13g2_buf_2
XFILLER_14_1679 VPWR VGND sg13g2_decap_4
Xplace3955 _19039_/B _18951_/A VPWR VGND sg13g2_buf_1
XFILLER_9_690 VPWR VGND sg13g2_decap_4
Xplace3966 _18491_/A _18339_/A VPWR VGND sg13g2_buf_1
Xplace3977 _13636_/A _12740_/A VPWR VGND sg13g2_buf_2
Xplace3988 _13210_/A _12499_/A VPWR VGND sg13g2_buf_4
XFILLER_106_717 VPWR VGND sg13g2_fill_1
XFILLER_88_1769 VPWR VGND sg13g2_decap_4
Xplace3999 _12243_/A _11854_/A VPWR VGND sg13g2_buf_4
X_22151_ _22151_/Y _22151_/A _22151_/B VPWR VGND sg13g2_nand2_1
X_21102_ _21102_/Y _21102_/A _21112_/B VPWR VGND sg13g2_nand2_1
Xhold4635 _14188_/A _24215_/Q VPWR VGND sg13g2_dlygate4sd3_1
XFILLER_82_1313 VPWR VGND sg13g2_decap_4
Xhold4646 _17471_/A _22853_/Q VPWR VGND sg13g2_dlygate4sd3_1
X_22082_ _22082_/Y _22082_/A _22084_/B VPWR VGND sg13g2_nand2_1
Xhold4657 _16429_/A _22582_/Q VPWR VGND sg13g2_dlygate4sd3_1
Xhold4668 _17445_/A _22841_/Q VPWR VGND sg13g2_dlygate4sd3_1
XFILLER_87_601 VPWR VGND sg13g2_decap_4
Xhold4679 _18137_/A _22962_/Q VPWR VGND sg13g2_dlygate4sd3_1
X_21033_ _23552_/D _22282_/A1 _21042_/B _21032_/Y VPWR VGND sg13g2_o21ai_1
XFILLER_87_645 VPWR VGND sg13g2_decap_8
XFILLER_59_358 VPWR VGND sg13g2_decap_8
XFILLER_5_1847 VPWR VGND sg13g2_decap_8
XFILLER_27_200 VPWR VGND sg13g2_fill_2
XFILLER_86_199 VPWR VGND sg13g2_decap_8
X_22984_ _22984_/Q clkload29/A _22984_/D fanout2935/X VPWR VGND sg13g2_dfrbpq_2
XFILLER_21_1639 VPWR VGND sg13g2_fill_2
XFILLER_103_21 VPWR VGND sg13g2_decap_8
X_21935_ _21935_/Y _23963_/Q _21935_/B VPWR VGND sg13g2_nand2_1
XFILLER_3_1560 VPWR VGND sg13g2_decap_8
XFILLER_16_929 VPWR VGND sg13g2_fill_2
XFILLER_83_884 VPWR VGND sg13g2_decap_8
XFILLER_63_14 VPWR VGND sg13g2_decap_8
XFILLER_43_737 VPWR VGND sg13g2_fill_2
X_21866_ _23929_/D _21932_/A1 _21876_/B _21865_/Y VPWR VGND sg13g2_o21ai_1
XFILLER_58_1540 VPWR VGND sg13g2_fill_1
X_23605_ _23605_/Q clkload52/A _23605_/D fanout2756/X VPWR VGND sg13g2_dfrbpq_1
X_20817_ _23457_/D _21321_/A1 _20818_/B _20816_/Y VPWR VGND sg13g2_o21ai_1
XFILLER_93_1464 VPWR VGND sg13g2_decap_8
X_21797_ _23896_/D _22264_/A1 _21804_/B _21796_/Y VPWR VGND sg13g2_o21ai_1
XFILLER_19_1557 VPWR VGND sg13g2_decap_4
XFILLER_93_1497 VPWR VGND sg13g2_decap_8
XFILLER_24_995 VPWR VGND sg13g2_decap_8
X_11550_ _11550_/Y _13985_/B _11537_/Y _11549_/Y VPWR VGND sg13g2_a21oi_1
XFILLER_106_1527 VPWR VGND sg13g2_decap_4
X_23536_ _23536_/Q clkload38/A _23536_/D fanout2643/X VPWR VGND sg13g2_dfrbpq_1
X_20748_ _23424_/D _19997_/Y _20751_/B _20747_/Y VPWR VGND sg13g2_o21ai_1
XFILLER_11_634 VPWR VGND sg13g2_fill_2
XFILLER_17_1281 VPWR VGND sg13g2_decap_8
X_23467_ _23467_/Q clkload38/A _23467_/D fanout2638/X VPWR VGND sg13g2_dfrbpq_1
X_11481_ _12738_/B _12778_/A _12577_/B VPWR VGND sg13g2_nand2b_1
X_20679_ _23392_/D _22414_/A1 _20682_/B _20678_/Y VPWR VGND sg13g2_o21ai_1
XFILLER_11_689 VPWR VGND sg13g2_fill_2
XFILLER_52_1183 VPWR VGND sg13g2_fill_2
X_13220_ _13356_/B _13220_/A _13292_/A VPWR VGND sg13g2_xnor2_1
X_22418_ _24194_/D _22418_/A1 _22417_/B _22417_/Y VPWR VGND sg13g2_o21ai_1
X_23398_ _23398_/Q clkload33/A _23398_/D fanout2699/X VPWR VGND sg13g2_dfrbpq_1
XFILLER_6_148 VPWR VGND sg13g2_fill_2
XFILLER_109_566 VPWR VGND sg13g2_decap_8
XFILLER_13_1189 VPWR VGND sg13g2_decap_8
XFILLER_3_800 VPWR VGND sg13g2_decap_8
X_13151_ _14045_/A _13368_/A _13153_/B VPWR VGND sg13g2_and2_1
XFILLER_12_95 VPWR VGND sg13g2_decap_8
X_22349_ _24161_/D _20022_/Y _22350_/B _22348_/Y VPWR VGND sg13g2_o21ai_1
XFILLER_100_1159 VPWR VGND sg13g2_decap_8
X_12102_ _12102_/Y _12104_/B _12102_/B VPWR VGND sg13g2_nand2b_1
XFILLER_88_55 VPWR VGND sg13g2_fill_2
X_13082_ _13082_/Y _13082_/A _13082_/B VPWR VGND sg13g2_nand2_1
XFILLER_65_1522 VPWR VGND sg13g2_decap_8
X_16910_ _16910_/Y _22692_/Q _16910_/B VPWR VGND sg13g2_xnor2_1
X_24019_ _24019_/Q clkload47/A _24019_/D fanout2662/X VPWR VGND sg13g2_dfrbpq_1
X_12033_ _12033_/Y _12266_/A _12033_/B VPWR VGND sg13g2_nor2_1
XFILLER_65_1566 VPWR VGND sg13g2_fill_2
X_17890_ _17892_/A _17890_/A1 _17918_/A2 _17920_/B1 _17153_/A VPWR VGND sg13g2_a22oi_1
XFILLER_78_645 VPWR VGND sg13g2_fill_2
X_16841_ _16842_/B _22681_/Q _16841_/B VPWR VGND sg13g2_xnor2_1
XFILLER_4_1313 VPWR VGND sg13g2_fill_2
X_19560_ _19560_/X _19557_/X _19559_/X _19874_/A VPWR VGND sg13g2_mux2_1
X_16772_ _16772_/Y _16818_/A _16772_/B VPWR VGND sg13g2_nor2_1
X_13984_ _13984_/X _13980_/X _13981_/X _13982_/X _13983_/X _14129_/D _12050_/B VPWR
+ VGND sg13g2_mux4_1
XFILLER_19_745 VPWR VGND sg13g2_decap_8
XFILLER_18_222 VPWR VGND sg13g2_fill_1
XFILLER_4_1357 VPWR VGND sg13g2_decap_8
XFILLER_20_1127 VPWR VGND sg13g2_decap_8
X_18511_ _18512_/A _18539_/B _18509_/X _18479_/X VPWR VGND sg13g2_o21ai_1
X_15723_ _15726_/B _22500_/Q _15893_/A2 _15804_/B1 _14215_/A VPWR VGND sg13g2_a22oi_1
X_19491_ _19491_/Y _19582_/A _20287_/B VPWR VGND sg13g2_nor2_1
XFILLER_78_1949 VPWR VGND sg13g2_decap_4
XFILLER_74_884 VPWR VGND sg13g2_decap_8
XFILLER_34_726 VPWR VGND sg13g2_fill_1
XFILLER_74_895 VPWR VGND sg13g2_fill_2
X_18442_ _18443_/C _18115_/Y _18438_/Y _18441_/Y VPWR VGND sg13g2_o21ai_1
X_12866_ _14053_/C _12866_/A1 _12866_/A2 _13526_/D VPWR VGND sg13g2_a21oi_2
X_14605_ _14605_/Y _14786_/B _14187_/C _14194_/A VPWR VGND sg13g2_o21ai_1
XFILLER_57_1050 VPWR VGND sg13g2_decap_8
XFILLER_72_1504 VPWR VGND sg13g2_fill_1
X_11817_ _11818_/C _11517_/S _11814_/Y _11816_/Y VPWR VGND sg13g2_a21oi_1
X_18373_ _18373_/Y _18451_/A _18476_/B _18380_/B VPWR VGND sg13g2_nand3_1
X_15585_ _15585_/Y _15585_/A _15950_/B VPWR VGND sg13g2_nor2_1
XFILLER_109_1140 VPWR VGND sg13g2_fill_1
X_12797_ _12797_/Y _13035_/A2 _12770_/Y _13649_/A _12797_/B2 _12584_/Y VPWR VGND sg13g2_a221oi_1
XFILLER_57_1083 VPWR VGND sg13g2_decap_8
XFILLER_72_1537 VPWR VGND sg13g2_decap_4
XFILLER_109_1162 VPWR VGND sg13g2_fill_2
X_17324_ _17324_/Y _17324_/A _17324_/B VPWR VGND sg13g2_nand2_1
XFILLER_53_80 VPWR VGND sg13g2_decap_4
XFILLER_105_1015 VPWR VGND sg13g2_fill_2
Xcore_wrap_4568 instr_addr_o[0] VPWR VGND sg13g2_tielo
Xplace3207 _19950_/B _19857_/B VPWR VGND sg13g2_buf_1
X_17255_ _17255_/Y _17255_/A _17262_/B VPWR VGND sg13g2_nand2_1
X_14467_ _14470_/A _18884_/A _14465_/Y _14466_/X VPWR VGND sg13g2_a21o_1
Xplace3218 _22434_/B _22444_/B VPWR VGND sg13g2_buf_1
XFILLER_31_1212 VPWR VGND sg13g2_fill_2
X_11679_ _11734_/A _22974_/Q _12471_/B _11984_/C VPWR VGND sg13g2_nand3_1
XFILLER_30_998 VPWR VGND sg13g2_decap_8
Xplace3229 _21738_/B _21754_/B VPWR VGND sg13g2_buf_1
X_16206_ _22512_/D _16205_/B _16204_/Y _16205_/Y VPWR VGND sg13g2_o21ai_1
XFILLER_70_1283 VPWR VGND sg13g2_fill_2
X_13418_ _13419_/B _13416_/X _13417_/X _14129_/D VPWR VGND sg13g2_mux2_1
XFILLER_102_1947 VPWR VGND sg13g2_decap_8
XFILLER_31_1256 VPWR VGND sg13g2_fill_2
X_17186_ _17186_/Y _22740_/Q _17186_/B VPWR VGND sg13g2_xnor2_1
X_16137_ _16137_/Y _22500_/Q _16197_/B _16136_/Y VPWR VGND sg13g2_a21oi_1
X_13349_ _13349_/Y _18444_/A1 _12551_/X _13717_/B VPWR VGND sg13g2_o21ai_1
XFILLER_5_181 VPWR VGND sg13g2_fill_2
XFILLER_115_558 VPWR VGND sg13g2_decap_8
XFILLER_45_2 VPWR VGND sg13g2_fill_1
X_16068_ _16068_/Y _22488_/Q _16075_/B _16067_/Y VPWR VGND sg13g2_a21oi_1
XFILLER_102_208 VPWR VGND sg13g2_fill_2
XFILLER_68_1190 VPWR VGND sg13g2_decap_4
X_15019_ _15022_/A _15019_/A _15019_/B VPWR VGND sg13g2_or2_1
XFILLER_97_932 VPWR VGND sg13g2_fill_2
XFILLER_44_1628 VPWR VGND sg13g2_fill_1
XFILLER_64_1065 VPWR VGND sg13g2_decap_8
XFILLER_29_1196 VPWR VGND sg13g2_decap_8
XFILLER_97_976 VPWR VGND sg13g2_decap_8
X_19827_ _19831_/B _19987_/A _20058_/B VPWR VGND sg13g2_nor2_1
Xfanout2880 fanout2880/X fanout2882/X VPWR VGND sg13g2_buf_1
XFILLER_110_241 VPWR VGND sg13g2_fill_2
Xfanout2891 fanout2891/X fanout2901/X VPWR VGND sg13g2_buf_1
XFILLER_57_829 VPWR VGND sg13g2_decap_4
XFILLER_111_786 VPWR VGND sg13g2_decap_8
XFILLER_83_103 VPWR VGND sg13g2_fill_2
XFILLER_42_1363 VPWR VGND sg13g2_decap_4
X_19758_ _19758_/Y _19756_/Y _19757_/Y _20058_/A VPWR VGND sg13g2_a21oi_1
XFILLER_56_339 VPWR VGND sg13g2_decap_8
XFILLER_42_1385 VPWR VGND sg13g2_decap_8
X_18709_ _18709_/Y _18713_/A _18708_/Y _23020_/Q VPWR VGND sg13g2_a21oi_1
XFILLER_83_169 VPWR VGND sg13g2_decap_8
XFILLER_52_501 VPWR VGND sg13g2_decap_8
X_21720_ _23868_/D _21938_/A1 _21725_/B _21719_/Y VPWR VGND sg13g2_o21ai_1
XFILLER_77_1448 VPWR VGND sg13g2_decap_4
XFILLER_0_1733 VPWR VGND sg13g2_decap_4
XFILLER_91_180 VPWR VGND sg13g2_fill_1
X_21651_ _21651_/Y _23839_/Q _21657_/B VPWR VGND sg13g2_nand2_1
XFILLER_52_578 VPWR VGND sg13g2_fill_2
X_20602_ _20602_/Y _23356_/Q _20607_/B VPWR VGND sg13g2_nand2_1
XFILLER_16_1708 VPWR VGND sg13g2_decap_4
X_21582_ _23806_/D _21943_/A1 _21581_/B _21581_/Y VPWR VGND sg13g2_o21ai_1
Xrebuffer5410 _16301_/A2 rebuffer5425/X VPWR VGND sg13g2_buf_1
XFILLER_21_965 VPWR VGND sg13g2_fill_2
X_23321_ _23321_/Q _24190_/CLK _23321_/D fanout2770/X VPWR VGND sg13g2_dfrbpq_1
X_20533_ _20533_/Y _20533_/A _20533_/B VPWR VGND sg13g2_nand2_1
Xrebuffer5421 _14692_/A1 _14318_/A VPWR VGND sg13g2_buf_1
XFILLER_53_1470 VPWR VGND sg13g2_fill_1
XFILLER_14_1432 VPWR VGND sg13g2_fill_2
Xrebuffer5432 _11377_/A _22980_/Q VPWR VGND sg13g2_buf_8
Xplace3730 _19673_/A _19361_/A VPWR VGND sg13g2_buf_1
Xrebuffer5454 place3986/A _11693_/Y VPWR VGND sg13g2_buf_8
Xrebuffer5465 _11854_/A _11414_/A VPWR VGND sg13g2_buf_1
Xplace3741 _19769_/A _19325_/X VPWR VGND sg13g2_buf_1
X_23252_ _23252_/Q _24212_/CLK _23252_/D fanout2922/X VPWR VGND sg13g2_dfrbpq_1
Xplace3752 _17590_/B _17621_/B VPWR VGND sg13g2_buf_1
X_20464_ _20464_/Y _23294_/Q _20464_/B VPWR VGND sg13g2_nand2_1
Xrebuffer5476 _14073_/A _11574_/B1 VPWR VGND sg13g2_buf_1
Xrebuffer5487 _19172_/A1 _15013_/Y VPWR VGND sg13g2_buf_1
Xhold5100 _17774_/A _22902_/Q VPWR VGND sg13g2_dlygate4sd3_1
Xplace3763 _14103_/A _13736_/A VPWR VGND sg13g2_buf_1
XFILLER_106_503 VPWR VGND sg13g2_decap_8
X_22203_ _22203_/Y _22203_/A _22203_/B VPWR VGND sg13g2_nand2_1
Xplace3774 _19563_/B _14634_/B VPWR VGND sg13g2_buf_1
Xhold5111 _20701_/A _23404_/Q VPWR VGND sg13g2_dlygate4sd3_1
Xrebuffer5498 _14258_/A _11219_/Y VPWR VGND sg13g2_buf_1
Xhold5122 _21863_/A _23928_/Q VPWR VGND sg13g2_dlygate4sd3_1
XFILLER_88_1555 VPWR VGND sg13g2_decap_8
Xplace3785 _14030_/A _11983_/A VPWR VGND sg13g2_buf_1
Xplace3796 _19930_/B _19978_/B VPWR VGND sg13g2_buf_1
X_23183_ _23183_/Q _23187_/CLK _23183_/D fanout2915/X VPWR VGND sg13g2_dfrbpq_1
Xhold5133 _20868_/A _23481_/Q VPWR VGND sg13g2_dlygate4sd3_1
X_20395_ _20395_/Y _20395_/A _20395_/B VPWR VGND sg13g2_nand2_1
XFILLER_109_7 VPWR VGND sg13g2_decap_8
Xhold5144 _22042_/A _24016_/Q VPWR VGND sg13g2_dlygate4sd3_1
Xhold5155 _21933_/A _23962_/Q VPWR VGND sg13g2_dlygate4sd3_1
X_22134_ _22134_/Y _22134_/A _22136_/B VPWR VGND sg13g2_nand2_1
Xhold5166 _20522_/A _23318_/Q VPWR VGND sg13g2_dlygate4sd3_1
Xhold5177 _20919_/A _23508_/Q VPWR VGND sg13g2_dlygate4sd3_1
XFILLER_66_1842 VPWR VGND sg13g2_decap_4
XFILLER_47_1230 VPWR VGND sg13g2_decap_4
Xhold5188 _22021_/A _24004_/Q VPWR VGND sg13g2_dlygate4sd3_1
Xhold5199 _21570_/A _23801_/Q VPWR VGND sg13g2_dlygate4sd3_1
X_22065_ _22065_/Y _22065_/A _22065_/B VPWR VGND sg13g2_nand2_1
XFILLER_47_1263 VPWR VGND sg13g2_fill_1
XFILLER_102_742 VPWR VGND sg13g2_decap_8
XFILLER_114_1818 VPWR VGND sg13g2_decap_8
X_21016_ _21016_/Y _21016_/A _21019_/B VPWR VGND sg13g2_nand2_1
XFILLER_87_453 VPWR VGND sg13g2_decap_4
XFILLER_101_241 VPWR VGND sg13g2_decap_8
XFILLER_9_1780 VPWR VGND sg13g2_decap_8
XFILLER_102_797 VPWR VGND sg13g2_decap_8
XFILLER_87_486 VPWR VGND sg13g2_decap_4
XFILLER_114_42 VPWR VGND sg13g2_decap_8
XFILLER_75_648 VPWR VGND sg13g2_fill_2
XFILLER_101_296 VPWR VGND sg13g2_decap_8
XFILLER_99_1640 VPWR VGND sg13g2_decap_8
XFILLER_74_13 VPWR VGND sg13g2_fill_1
XFILLER_28_553 VPWR VGND sg13g2_decap_8
XFILLER_16_704 VPWR VGND sg13g2_decap_8
Xclkbuf_leaf_30_clk_i clkload48/A clkbuf_leaf_43_clk_i/A VPWR VGND sg13g2_buf_16
XFILLER_16_715 VPWR VGND sg13g2_fill_1
X_22967_ _22967_/Q clkload16/A _22967_/D fanout2920/X VPWR VGND sg13g2_dfrbpq_1
XFILLER_74_57 VPWR VGND sg13g2_decap_8
XFILLER_56_884 VPWR VGND sg13g2_fill_1
XFILLER_28_586 VPWR VGND sg13g2_fill_1
XFILLER_71_821 VPWR VGND sg13g2_decap_8
X_12720_ _12720_/Y _12721_/S _23907_/Q _12719_/Y VPWR VGND sg13g2_o21ai_1
X_21918_ _21918_/Y _22252_/A _22050_/B _22050_/C _21918_/D VPWR VGND sg13g2_nand4_1
XFILLER_55_394 VPWR VGND sg13g2_decap_8
X_22898_ _22898_/Q clkload9/A _22898_/D fanout2816/X VPWR VGND sg13g2_dfrbpq_1
XFILLER_70_331 VPWR VGND sg13g2_decap_8
XFILLER_38_1922 VPWR VGND sg13g2_fill_2
XFILLER_15_269 VPWR VGND sg13g2_fill_1
X_12651_ _12652_/B _23714_/Q _23746_/Q _23778_/Q _23810_/Q _12651_/S0 _12651_/S1 VPWR
+ VGND sg13g2_mux4_1
X_21849_ _23923_/D _13888_/Y _21848_/B _21848_/Y VPWR VGND sg13g2_a21oi_1
Xinput4353 _17870_/A1 boot_addr_i[11] VPWR VGND sg13g2_buf_1
Xinput4364 _17902_/A1 boot_addr_i[22] VPWR VGND sg13g2_buf_1
XFILLER_70_386 VPWR VGND sg13g2_decap_8
Xinput4375 _17862_/A1 boot_addr_i[9] VPWR VGND sg13g2_buf_1
X_11602_ _11602_/Y _14124_/A _11602_/B VPWR VGND sg13g2_nor2_1
X_15370_ _15370_/Y _15369_/Y _15972_/B VPWR VGND sg13g2_nand2b_1
XFILLER_93_1294 VPWR VGND sg13g2_fill_1
Xinput4386 _20255_/A3 data_rdata_i[17] VPWR VGND sg13g2_buf_1
XFILLER_24_792 VPWR VGND sg13g2_fill_1
X_12582_ _12582_/Y _12582_/A _12582_/B _12582_/C _12582_/D VPWR VGND sg13g2_nor4_2
Xinput4397 _20284_/A0 data_rdata_i[27] VPWR VGND sg13g2_buf_1
Xclkbuf_leaf_45_clk_i _24210_/CLK clkbuf_leaf_9_clk_i/A VPWR VGND sg13g2_buf_16
XFILLER_8_903 VPWR VGND sg13g2_decap_8
XFILLER_15_1229 VPWR VGND sg13g2_decap_8
XFILLER_8_914 VPWR VGND sg13g2_fill_1
XFILLER_90_89 VPWR VGND sg13g2_fill_2
X_14321_ _15140_/C _14321_/A _14321_/B VPWR VGND sg13g2_nor2_1
X_11533_ _11533_/X _23701_/Q _23733_/Q _23765_/Q _23797_/Q _11923_/S0 _11768_/S1 VPWR
+ VGND sg13g2_mux4_1
X_23519_ _23519_/Q clkload40/A _23519_/D fanout2736/X VPWR VGND sg13g2_dfrbpq_1
XFILLER_106_1368 VPWR VGND sg13g2_decap_8
XFILLER_8_947 VPWR VGND sg13g2_fill_1
XFILLER_11_486 VPWR VGND sg13g2_decap_8
XFILLER_32_1543 VPWR VGND sg13g2_fill_1
X_17040_ _17045_/A _14068_/B _17041_/B _17039_/Y VPWR VGND sg13g2_o21ai_1
X_11464_ _11464_/Y _11464_/A _12788_/A VPWR VGND sg13g2_nor2b_1
X_14252_ _14560_/B _24228_/Q _16215_/B VPWR VGND sg13g2_nor2_1
XFILLER_99_21 VPWR VGND sg13g2_decap_8
XFILLER_7_457 VPWR VGND sg13g2_decap_8
XFILLER_32_1565 VPWR VGND sg13g2_fill_1
X_13203_ _13206_/C _13212_/A _13203_/B VPWR VGND sg13g2_nor2_1
XFILLER_10_1830 VPWR VGND sg13g2_decap_8
X_11395_ _11395_/Y _23862_/Q _11406_/S VPWR VGND sg13g2_nand2b_1
X_14183_ _16438_/B _22942_/Q VPWR VGND sg13g2_inv_1
XFILLER_87_1076 VPWR VGND sg13g2_fill_1
XFILLER_84_1920 VPWR VGND sg13g2_fill_1
XFILLER_98_707 VPWR VGND sg13g2_decap_8
X_13134_ _13135_/B _23304_/Q _23336_/Q _23368_/Q _23400_/Q _13133_/A _13635_/S1 VPWR
+ VGND sg13g2_mux4_1
XFILLER_98_718 VPWR VGND sg13g2_fill_1
X_18991_ _18991_/Y _18999_/A _18991_/B _18991_/C VPWR VGND sg13g2_nand3b_1
XFILLER_2_140 VPWR VGND sg13g2_decap_4
XFILLER_45_1915 VPWR VGND sg13g2_decap_8
X_17942_ _17942_/Y _17940_/Y _17941_/Y _18473_/S VPWR VGND sg13g2_a21oi_1
X_13065_ _13065_/Y _13071_/B _13065_/B _13065_/C _13065_/D VPWR VGND sg13g2_nand4_1
XFILLER_80_1817 VPWR VGND sg13g2_fill_1
XFILLER_26_1314 VPWR VGND sg13g2_decap_4
XFILLER_79_954 VPWR VGND sg13g2_decap_8
XFILLER_78_442 VPWR VGND sg13g2_fill_2
XFILLER_26_1336 VPWR VGND sg13g2_decap_4
X_12016_ _12017_/D _12486_/A _12015_/X _11951_/A VPWR VGND sg13g2_o21ai_1
X_17873_ _17874_/A _17873_/A1 _17926_/A2 _17927_/B _22922_/Q _17872_/Y VPWR VGND sg13g2_a221oi_1
XFILLER_38_306 VPWR VGND sg13g2_fill_2
XFILLER_66_615 VPWR VGND sg13g2_fill_1
XFILLER_94_935 VPWR VGND sg13g2_decap_8
X_19612_ _19612_/Y _19612_/A _19612_/B _19612_/C _19612_/D VPWR VGND sg13g2_nor4_1
X_16824_ _16825_/B _22676_/Q _22675_/Q _16828_/D VPWR VGND sg13g2_nand3_1
XFILLER_43_1672 VPWR VGND sg13g2_decap_8
XFILLER_65_125 VPWR VGND sg13g2_decap_4
XFILLER_4_1143 VPWR VGND sg13g2_decap_4
XFILLER_47_851 VPWR VGND sg13g2_decap_8
X_19543_ _19543_/Y _19663_/A _19735_/B VPWR VGND sg13g2_nand2_1
XFILLER_0_21 VPWR VGND sg13g2_decap_8
XFILLER_24_1082 VPWR VGND sg13g2_decap_8
X_16755_ _16755_/Y _16755_/A _16755_/B VPWR VGND sg13g2_nor2_1
XFILLER_78_1735 VPWR VGND sg13g2_decap_8
XFILLER_4_1176 VPWR VGND sg13g2_decap_8
X_13967_ _13967_/Y _13966_/B _13960_/X _13966_/Y VPWR VGND sg13g2_o21ai_1
XFILLER_80_106 VPWR VGND sg13g2_fill_1
XFILLER_74_670 VPWR VGND sg13g2_fill_1
XFILLER_80_117 VPWR VGND sg13g2_decap_8
XFILLER_19_597 VPWR VGND sg13g2_fill_1
XFILLER_46_372 VPWR VGND sg13g2_decap_8
X_15706_ _15712_/C _16871_/C _15706_/B VPWR VGND sg13g2_nor2_1
XFILLER_78_1768 VPWR VGND sg13g2_decap_8
XFILLER_46_383 VPWR VGND sg13g2_fill_2
X_12918_ _12918_/Y _24133_/Q _12921_/S VPWR VGND sg13g2_nand2b_1
X_19474_ _19474_/X _19545_/A _19721_/B _19545_/C VPWR VGND sg13g2_and3_1
X_16686_ _16687_/B _22652_/Q _16735_/B VPWR VGND sg13g2_xnor2_1
X_13898_ _13898_/X _23443_/Q _23475_/Q _23507_/Q _23539_/Q _13900_/S0 _13900_/S1 VPWR
+ VGND sg13g2_mux4_1
X_18425_ _18426_/A _18425_/A _18425_/B VPWR VGND sg13g2_nand2_1
XFILLER_62_876 VPWR VGND sg13g2_decap_8
XFILLER_94_1069 VPWR VGND sg13g2_decap_8
X_15637_ _16113_/A _20063_/A _16353_/B VPWR VGND sg13g2_nor2_1
X_12849_ _12852_/B _12849_/A _12849_/B VPWR VGND sg13g2_xnor2_1
XFILLER_61_386 VPWR VGND sg13g2_fill_2
X_18356_ _22980_/D _14129_/B _18355_/A _18355_/Y VPWR VGND sg13g2_a21oi_1
X_15568_ _22461_/D _16094_/A _15567_/X _15695_/S VPWR VGND sg13g2_mux2_1
XFILLER_14_291 VPWR VGND sg13g2_decap_8
X_17307_ _17307_/Y _17307_/A _17315_/B VPWR VGND sg13g2_nand2_1
XFILLER_9_85 VPWR VGND sg13g2_decap_8
X_14519_ _14520_/B _14519_/A _14519_/B _14519_/C _14519_/D VPWR VGND sg13g2_nor4_1
Xplace3004 _22335_/B _22383_/B VPWR VGND sg13g2_buf_1
X_18287_ _22974_/D _20437_/B _18286_/A _18286_/Y VPWR VGND sg13g2_a21oi_1
X_15499_ _15503_/A _22595_/Q _16441_/A _17303_/A _22790_/Q VPWR VGND sg13g2_a22oi_1
Xplace3015 _22291_/B _22300_/B VPWR VGND sg13g2_buf_1
Xplace3026 _22142_/B _22129_/B VPWR VGND sg13g2_buf_1
XFILLER_15_1763 VPWR VGND sg13g2_decap_8
X_17238_ _17238_/Y _17238_/A _17252_/B VPWR VGND sg13g2_nand2_1
Xplace3037 _22084_/B _22101_/B VPWR VGND sg13g2_buf_1
Xplace3048 _22048_/B _22045_/B VPWR VGND sg13g2_buf_1
Xplace3059 _21869_/B _21899_/S VPWR VGND sg13g2_buf_1
XFILLER_89_1864 VPWR VGND sg13g2_decap_8
XFILLER_7_980 VPWR VGND sg13g2_fill_1
XFILLER_89_1875 VPWR VGND sg13g2_fill_1
X_17169_ _17169_/Y _17169_/A _17220_/B VPWR VGND sg13g2_nor2_1
XFILLER_115_322 VPWR VGND sg13g2_decap_8
XFILLER_50_0 VPWR VGND sg13g2_decap_8
X_20180_ _20182_/C _20178_/Y _19835_/Y _19837_/Y _20179_/Y VPWR VGND sg13g2_a22oi_1
XFILLER_103_506 VPWR VGND sg13g2_decap_8
XFILLER_83_1441 VPWR VGND sg13g2_decap_4
XFILLER_48_1583 VPWR VGND sg13g2_decap_8
XFILLER_69_431 VPWR VGND sg13g2_decap_8
XFILLER_96_250 VPWR VGND sg13g2_decap_8
XFILLER_85_913 VPWR VGND sg13g2_fill_1
XFILLER_28_17 VPWR VGND sg13g2_fill_2
XFILLER_57_615 VPWR VGND sg13g2_decap_8
XFILLER_69_475 VPWR VGND sg13g2_fill_2
XFILLER_6_1931 VPWR VGND sg13g2_decap_8
XFILLER_28_28 VPWR VGND sg13g2_decap_8
XFILLER_111_583 VPWR VGND sg13g2_decap_8
XFILLER_85_946 VPWR VGND sg13g2_decap_8
X_23870_ _23870_/Q _23966_/CLK _23870_/D fanout2785/X VPWR VGND sg13g2_dfrbpq_1
XFILLER_56_125 VPWR VGND sg13g2_decap_8
XFILLER_2_1806 VPWR VGND sg13g2_decap_8
XFILLER_84_467 VPWR VGND sg13g2_decap_4
X_22821_ _22821_/Q _22869_/CLK _22821_/D fanout2797/X VPWR VGND sg13g2_dfrbpq_1
XFILLER_84_478 VPWR VGND sg13g2_decap_8
XFILLER_96_1846 VPWR VGND sg13g2_fill_1
XFILLER_77_1223 VPWR VGND sg13g2_decap_8
XFILLER_37_372 VPWR VGND sg13g2_decap_8
XFILLER_65_692 VPWR VGND sg13g2_decap_4
X_22752_ _22752_/Q clkload21/A _22752_/D fanout2875/X VPWR VGND sg13g2_dfrbpq_1
XFILLER_0_1541 VPWR VGND sg13g2_decap_4
XFILLER_77_1267 VPWR VGND sg13g2_decap_4
X_21703_ _21703_/Y _21703_/A _21713_/B VPWR VGND sg13g2_nand2_1
XFILLER_80_662 VPWR VGND sg13g2_decap_4
X_22683_ _22683_/Q clkload21/A _22683_/D fanout2866/X VPWR VGND sg13g2_dfrbpq_1
XFILLER_77_1289 VPWR VGND sg13g2_decap_8
XFILLER_25_589 VPWR VGND sg13g2_decap_8
X_21634_ _23831_/D _21928_/A1 _21635_/B _21633_/Y VPWR VGND sg13g2_o21ai_1
XFILLER_107_1633 VPWR VGND sg13g2_decap_4
XFILLER_21_751 VPWR VGND sg13g2_decap_4
X_21565_ _23798_/D _21926_/A1 _21574_/B _21564_/Y VPWR VGND sg13g2_o21ai_1
XFILLER_100_77 VPWR VGND sg13g2_decap_8
XFILLER_20_261 VPWR VGND sg13g2_decap_8
Xplace4250 _13236_/S1 _13042_/A VPWR VGND sg13g2_buf_2
XFILLER_33_1841 VPWR VGND sg13g2_decap_8
Xrebuffer5240 _13057_/B _13035_/Y VPWR VGND sg13g2_buf_2
XFILLER_60_59 VPWR VGND sg13g2_decap_8
Xplace4261 _12409_/S1 _13680_/S1 VPWR VGND sg13g2_buf_8
X_23304_ _23304_/Q clkload32/A _23304_/D fanout2646/X VPWR VGND sg13g2_dfrbpq_1
X_20516_ _20516_/Y _20649_/B _22119_/A VPWR VGND sg13g2_nand2_1
Xplace4272 _13978_/S0 _13578_/S0 VPWR VGND sg13g2_buf_2
Xrebuffer5251 _13362_/B _20197_/B VPWR VGND sg13g2_buf_1
X_21496_ _21496_/Y _23765_/Q _21502_/B VPWR VGND sg13g2_nand2_1
Xplace4283 _13919_/S0 _13773_/S0 VPWR VGND sg13g2_buf_1
XFILLER_101_1210 VPWR VGND sg13g2_decap_8
XFILLER_14_1262 VPWR VGND sg13g2_fill_1
XFILLER_20_294 VPWR VGND sg13g2_decap_8
Xrebuffer5262 _13858_/B _13713_/Y VPWR VGND sg13g2_buf_2
XFILLER_10_1104 VPWR VGND sg13g2_decap_4
Xrebuffer5273 _24257_/A _19211_/A0 VPWR VGND sg13g2_buf_1
Xplace4294 _11387_/A _13039_/S VPWR VGND sg13g2_buf_2
Xplace3560 _14726_/S _14729_/S VPWR VGND sg13g2_buf_1
XFILLER_33_1896 VPWR VGND sg13g2_fill_1
Xrebuffer5284 place3728/A _11557_/Y VPWR VGND sg13g2_buf_2
Xplace3571 _20031_/A _19719_/A VPWR VGND sg13g2_buf_1
X_23235_ _23235_/Q clkload34/A _23235_/D fanout2694/X VPWR VGND sg13g2_dfrbpq_1
XFILLER_109_42 VPWR VGND sg13g2_decap_8
X_20447_ _20447_/Y _23286_/Q _20458_/B VPWR VGND sg13g2_nand2_1
Xrebuffer5295 _14642_/A _12900_/B2 VPWR VGND sg13g2_buf_1
Xplace3582 _20295_/A1 _19474_/X VPWR VGND sg13g2_buf_1
XFILLER_101_1265 VPWR VGND sg13g2_decap_8
Xplace3593 _20058_/A _19986_/A VPWR VGND sg13g2_buf_1
Xrebuffer4572 _24276_/A _15116_/B2 VPWR VGND sg13g2_buf_1
XFILLER_4_449 VPWR VGND sg13g2_decap_4
Xrebuffer4583 _15690_/A place3714/A VPWR VGND sg13g2_buf_2
XFILLER_68_1948 VPWR VGND sg13g2_decap_8
XFILLER_106_344 VPWR VGND sg13g2_decap_8
Xrebuffer4594 _24259_/A _14950_/B2 VPWR VGND sg13g2_buf_1
X_23166_ _23166_/Q clkload15/A _23166_/D fanout2859/X VPWR VGND sg13g2_dfrbpq_1
X_11180_ _14122_/C _22964_/Q _22965_/Q VPWR VGND sg13g2_and2_1
XFILLER_49_1347 VPWR VGND sg13g2_decap_8
X_20378_ _20378_/Y _23254_/Q _20388_/B VPWR VGND sg13g2_nand2_1
X_22117_ _22117_/Y _22117_/A _22117_/B VPWR VGND sg13g2_nand2_1
XFILLER_79_239 VPWR VGND sg13g2_decap_8
X_23097_ _23097_/Q clkload14/A _23097_/D fanout2843/X VPWR VGND sg13g2_dfrbpq_1
XFILLER_0_622 VPWR VGND sg13g2_fill_1
XFILLER_27_1634 VPWR VGND sg13g2_decap_4
X_22048_ _22048_/Y _24020_/Q _22048_/B VPWR VGND sg13g2_nand2_1
XFILLER_102_561 VPWR VGND sg13g2_decap_8
XFILLER_76_924 VPWR VGND sg13g2_fill_2
XFILLER_27_1689 VPWR VGND sg13g2_decap_8
XFILLER_75_401 VPWR VGND sg13g2_decap_8
XFILLER_40_1801 VPWR VGND sg13g2_fill_2
XFILLER_40_1812 VPWR VGND sg13g2_decap_8
XFILLER_87_294 VPWR VGND sg13g2_fill_2
X_14870_ _14870_/Y _22519_/Q VPWR VGND sg13g2_inv_1
XFILLER_25_1380 VPWR VGND sg13g2_decap_8
XFILLER_75_456 VPWR VGND sg13g2_fill_2
X_13821_ _13821_/X _23442_/Q _23474_/Q _23506_/Q _23538_/Q _13173_/S _13981_/S1 VPWR
+ VGND sg13g2_mux4_1
XFILLER_95_1312 VPWR VGND sg13g2_decap_8
XFILLER_28_361 VPWR VGND sg13g2_fill_1
XFILLER_40_1878 VPWR VGND sg13g2_decap_8
X_23999_ _23999_/Q _24131_/CLK _23999_/D fanout2749/X VPWR VGND sg13g2_dfrbpq_1
XFILLER_99_1492 VPWR VGND sg13g2_decap_8
XFILLER_90_426 VPWR VGND sg13g2_decap_8
XFILLER_40_1889 VPWR VGND sg13g2_fill_1
X_16540_ _16541_/B _22622_/Q _22621_/Q _22620_/Q _16559_/C VPWR VGND sg13g2_nand4_1
XFILLER_90_437 VPWR VGND sg13g2_fill_1
X_13752_ _13755_/C _13747_/B _13751_/Y _14005_/A VPWR VGND sg13g2_mux2_1
XFILLER_44_854 VPWR VGND sg13g2_decap_8
X_12703_ _12703_/X _22562_/Q _13181_/B VPWR VGND sg13g2_or2_1
XFILLER_71_662 VPWR VGND sg13g2_decap_8
X_16471_ _22598_/D _17869_/A _16470_/B _16470_/Y VPWR VGND sg13g2_o21ai_1
X_13683_ _13683_/X _24048_/Q _24080_/Q _13974_/S VPWR VGND sg13g2_mux2_1
X_18210_ _18344_/B _18236_/B _18210_/B VPWR VGND sg13g2_nand2b_1
X_15422_ _15435_/B _22845_/Q _17439_/A _16161_/A _22487_/Q VPWR VGND sg13g2_a22oi_1
XFILLER_19_1140 VPWR VGND sg13g2_decap_4
XFILLER_34_60 VPWR VGND sg13g2_fill_1
X_19190_ _19190_/Y _19268_/A _19190_/B VPWR VGND sg13g2_nand2_1
X_12634_ _12699_/B _12616_/Y _12625_/Y _12633_/Y VPWR VGND sg13g2_o21ai_1
XFILLER_34_71 VPWR VGND sg13g2_decap_4
XFILLER_70_194 VPWR VGND sg13g2_fill_2
X_18141_ _22963_/D _18140_/B _18517_/B _18140_/Y VPWR VGND sg13g2_o21ai_1
XFILLER_19_1195 VPWR VGND sg13g2_decap_8
Xoutput4509 data_wdata_o[15] _14722_/X VPWR VGND sg13g2_buf_1
X_15353_ _15969_/B _15353_/A _15478_/D VPWR VGND sg13g2_nor2_2
X_14304_ _15294_/C _14346_/B _14346_/C _14304_/C VPWR VGND sg13g2_nor3_1
X_11516_ _11516_/X _23413_/Q _23445_/Q _23477_/Q _23509_/Q _11477_/A _11714_/S VPWR
+ VGND sg13g2_mux4_1
XFILLER_8_755 VPWR VGND sg13g2_decap_8
X_18072_ _18072_/Y _18363_/A _18361_/B VPWR VGND sg13g2_nand2_1
X_15284_ _15284_/Y _15312_/A _15296_/B VPWR VGND sg13g2_nor2_1
XFILLER_12_1925 VPWR VGND sg13g2_decap_8
XFILLER_7_254 VPWR VGND sg13g2_decap_4
XFILLER_32_1362 VPWR VGND sg13g2_decap_8
X_12496_ _12497_/B _24160_/Q _23296_/Q _12498_/S VPWR VGND sg13g2_mux2_1
X_17023_ _17028_/B _22713_/Q _17023_/B VPWR VGND sg13g2_and2_1
X_14235_ _14400_/B _24215_/Q _14837_/B VPWR VGND sg13g2_nand2_1
XFILLER_50_81 VPWR VGND sg13g2_decap_8
X_11447_ _11501_/B _11447_/A _13968_/B VPWR VGND sg13g2_nor2b_1
XFILLER_109_182 VPWR VGND sg13g2_decap_8
XFILLER_7_298 VPWR VGND sg13g2_decap_8
X_14166_ _14167_/A _14166_/A _14166_/B VPWR VGND sg13g2_nand2_1
XFILLER_45_1701 VPWR VGND sg13g2_decap_4
XFILLER_113_848 VPWR VGND sg13g2_decap_8
X_13117_ _13117_/X _24040_/Q _24072_/Q _13621_/S VPWR VGND sg13g2_mux2_1
XFILLER_80_1603 VPWR VGND sg13g2_decap_8
X_18974_ _18975_/C _19003_/A _23087_/Q VPWR VGND sg13g2_nand2_1
XFILLER_3_482 VPWR VGND sg13g2_decap_8
XFILLER_80_1625 VPWR VGND sg13g2_decap_8
XFILLER_61_1013 VPWR VGND sg13g2_fill_1
XFILLER_65_1182 VPWR VGND sg13g2_fill_1
X_17925_ _22939_/D _17925_/A _17925_/B VPWR VGND sg13g2_nand2_1
X_13048_ _13048_/X _23847_/Q _23879_/Q _23943_/Q _23975_/Q _13232_/S _13042_/A VPWR
+ VGND sg13g2_mux4_1
XFILLER_59_90 VPWR VGND sg13g2_decap_8
XFILLER_61_1024 VPWR VGND sg13g2_decap_8
XFILLER_6_1216 VPWR VGND sg13g2_decap_8
XFILLER_94_710 VPWR VGND sg13g2_decap_8
XFILLER_94_721 VPWR VGND sg13g2_fill_1
XFILLER_79_795 VPWR VGND sg13g2_fill_1
XFILLER_22_1008 VPWR VGND sg13g2_decap_8
XFILLER_39_637 VPWR VGND sg13g2_decap_4
XFILLER_94_765 VPWR VGND sg13g2_fill_2
X_16807_ _16812_/C _22672_/Q _22671_/Q VPWR VGND sg13g2_nand2_1
XFILLER_38_169 VPWR VGND sg13g2_decap_8
X_17787_ _17787_/Y _17809_/A1 _17785_/Y _17786_/Y VPWR VGND sg13g2_o21ai_1
XFILLER_54_629 VPWR VGND sg13g2_fill_1
X_14999_ _14999_/Y _15068_/A _14999_/B _14999_/C VPWR VGND sg13g2_nand3_1
XFILLER_47_681 VPWR VGND sg13g2_decap_8
X_16738_ _22662_/D _17866_/A _16755_/A _16737_/Y VPWR VGND sg13g2_a21oi_1
XFILLER_81_448 VPWR VGND sg13g2_fill_1
X_19526_ _19526_/Y _19522_/Y _19523_/Y _19525_/Y VPWR VGND sg13g2_o21ai_1
XFILLER_34_320 VPWR VGND sg13g2_fill_1
XFILLER_35_876 VPWR VGND sg13g2_decap_8
XFILLER_74_1418 VPWR VGND sg13g2_decap_8
X_19457_ _19457_/Y _19728_/B _19423_/B _19456_/Y VPWR VGND sg13g2_o21ai_1
XFILLER_90_971 VPWR VGND sg13g2_decap_4
X_16669_ _16669_/Y _16673_/A _16669_/B VPWR VGND sg13g2_nor2_1
XFILLER_50_835 VPWR VGND sg13g2_decap_4
XFILLER_61_161 VPWR VGND sg13g2_decap_4
XFILLER_98_0 VPWR VGND sg13g2_decap_8
X_18408_ _18408_/Y _18359_/Y _18407_/Y _18290_/C VPWR VGND sg13g2_o21ai_1
X_19388_ _19388_/Y _20322_/A _19576_/B VPWR VGND sg13g2_nor2_1
XFILLER_91_1765 VPWR VGND sg13g2_decap_4
XFILLER_17_1836 VPWR VGND sg13g2_decap_8
XFILLER_52_1716 VPWR VGND sg13g2_fill_1
XFILLER_108_1953 VPWR VGND sg13g2_fill_2
X_18339_ _18339_/Y _18339_/A _18765_/B VPWR VGND sg13g2_nor2_1
XFILLER_52_1749 VPWR VGND sg13g2_decap_8
X_21350_ _21350_/Y _23698_/Q _21353_/B VPWR VGND sg13g2_nand2_1
XFILLER_11_1413 VPWR VGND sg13g2_decap_4
XFILLER_107_119 VPWR VGND sg13g2_decap_8
X_20301_ _23248_/D _20300_/B _21977_/A1 _20300_/Y VPWR VGND sg13g2_o21ai_1
X_21281_ _21281_/Y _23664_/Q _21281_/B VPWR VGND sg13g2_nand2_1
X_23020_ _23020_/Q clkload6/A _23020_/D fanout2804/X VPWR VGND sg13g2_dfrbpq_1
X_20232_ _20232_/Y _20354_/B _20232_/B VPWR VGND sg13g2_nor2_1
X_20163_ _20163_/Y _20164_/A _20338_/C _20162_/Y VPWR VGND sg13g2_o21ai_1
XFILLER_115_196 VPWR VGND sg13g2_decap_8
XFILLER_39_27 VPWR VGND sg13g2_decap_8
XFILLER_48_1380 VPWR VGND sg13g2_decap_8
XFILLER_115_1924 VPWR VGND sg13g2_decap_8
X_20094_ _20094_/Y _20090_/Y _20094_/B _20094_/C VPWR VGND sg13g2_nand3b_1
X_23922_ _23922_/Q clkload16/A _23922_/D fanout2623/X VPWR VGND sg13g2_dfrbpq_1
XFILLER_84_220 VPWR VGND sg13g2_decap_8
XFILLER_29_125 VPWR VGND sg13g2_decap_8
XFILLER_44_1288 VPWR VGND sg13g2_fill_1
XFILLER_79_1329 VPWR VGND sg13g2_fill_2
XFILLER_57_467 VPWR VGND sg13g2_decap_4
X_23853_ _23853_/Q clkload30/A _23853_/D fanout2657/X VPWR VGND sg13g2_dfrbpq_1
XFILLER_57_489 VPWR VGND sg13g2_decap_8
X_22804_ _22804_/Q clkload10/A _22804_/D fanout2814/X VPWR VGND sg13g2_dfrbpq_1
XFILLER_44_128 VPWR VGND sg13g2_decap_4
XFILLER_2_1669 VPWR VGND sg13g2_fill_1
XFILLER_96_1665 VPWR VGND sg13g2_fill_2
X_23784_ _23784_/Q clkload31/A _23784_/D fanout2653/X VPWR VGND sg13g2_dfrbpq_1
XFILLER_111_21 VPWR VGND sg13g2_decap_8
XFILLER_25_342 VPWR VGND sg13g2_fill_2
XFILLER_38_1004 VPWR VGND sg13g2_fill_1
XFILLER_92_1518 VPWR VGND sg13g2_decap_4
XFILLER_53_662 VPWR VGND sg13g2_fill_1
X_22735_ _22735_/Q clkload21/A _22735_/D fanout2868/X VPWR VGND sg13g2_dfrbpq_1
XFILLER_74_1941 VPWR VGND sg13g2_decap_8
XFILLER_25_386 VPWR VGND sg13g2_fill_2
XFILLER_71_14 VPWR VGND sg13g2_decap_8
XFILLER_55_1340 VPWR VGND sg13g2_fill_1
XFILLER_111_98 VPWR VGND sg13g2_decap_8
X_22666_ _22666_/Q _22733_/CLK _22666_/D fanout2880/X VPWR VGND sg13g2_dfrbpq_1
XFILLER_41_868 VPWR VGND sg13g2_fill_1
XFILLER_55_1351 VPWR VGND sg13g2_fill_1
XFILLER_16_1313 VPWR VGND sg13g2_decap_8
XFILLER_35_1936 VPWR VGND sg13g2_decap_8
XFILLER_70_1816 VPWR VGND sg13g2_fill_1
XFILLER_40_356 VPWR VGND sg13g2_decap_8
X_21617_ _23825_/D _21617_/A0 _23825_/Q _21620_/S VPWR VGND sg13g2_mux2_1
XFILLER_90_1275 VPWR VGND sg13g2_fill_1
XFILLER_16_1346 VPWR VGND sg13g2_decap_8
X_22597_ _22597_/Q _22893_/CLK _22597_/D fanout2817/X VPWR VGND sg13g2_dfrbpq_1
X_12350_ _12350_/Y _13296_/A _12350_/B _12350_/C VPWR VGND sg13g2_nor3_1
X_21548_ _23791_/D _21975_/A0 _23791_/Q _21554_/S VPWR VGND sg13g2_mux2_1
Xplace4080 _20343_/S0 _20310_/S0 VPWR VGND sg13g2_buf_1
X_11301_ _11301_/X _11281_/Y _11288_/Y _11296_/Y _11300_/Y _12674_/C _13343_/B VPWR
+ VGND sg13g2_mux4_1
Xplace4091 _19912_/S _23195_/Q VPWR VGND sg13g2_buf_1
X_12281_ _12281_/X _23422_/Q _23454_/Q _23486_/Q _23518_/Q _12246_/S _12457_/S1 VPWR
+ VGND sg13g2_mux4_1
XFILLER_4_202 VPWR VGND sg13g2_decap_8
X_21479_ _23757_/D _23757_/Q _21972_/A0 _21488_/S VPWR VGND sg13g2_mux2_1
X_24267_ _24267_/X _24267_/A VPWR VGND sg13g2_buf_1
Xplace3390 _17489_/B _17507_/S VPWR VGND sg13g2_buf_1
XFILLER_107_653 VPWR VGND sg13g2_decap_4
X_23218_ _23218_/Q clkload35/A _23218_/D fanout2932/X VPWR VGND sg13g2_dfrbpq_1
X_24198_ _24198_/Q clkload34/A _24198_/D fanout2694/X VPWR VGND sg13g2_dfrbpq_1
XFILLER_84_1046 VPWR VGND sg13g2_fill_2
X_23149_ _23149_/Q clkload14/A _23149_/D fanout2842/X VPWR VGND sg13g2_dfrbpq_1
XFILLER_62_1300 VPWR VGND sg13g2_fill_1
XFILLER_110_829 VPWR VGND sg13g2_decap_8
X_15971_ _15971_/Y _22649_/Q _16774_/D _17056_/C _22713_/Q VPWR VGND sg13g2_a22oi_1
XFILLER_103_870 VPWR VGND sg13g2_decap_8
XFILLER_88_570 VPWR VGND sg13g2_fill_1
X_17710_ _17710_/Y _17710_/A1 _17705_/X _17709_/Y VPWR VGND sg13g2_o21ai_1
XFILLER_88_592 VPWR VGND sg13g2_fill_2
X_14922_ _14922_/Y _14953_/A _16265_/A _14921_/Y VPWR VGND sg13g2_o21ai_1
X_18690_ _18696_/B _18690_/A _18690_/B VPWR VGND sg13g2_nor2_1
XFILLER_114_1467 VPWR VGND sg13g2_decap_8
X_17641_ _17641_/Y _17102_/A _17670_/A2 _17670_/B1 _17640_/Y VPWR VGND sg13g2_a22oi_1
XFILLER_91_713 VPWR VGND sg13g2_decap_8
X_14853_ _14853_/Y _14853_/A1 _14851_/Y _14852_/Y _14758_/C VPWR VGND sg13g2_a22oi_1
XFILLER_79_1830 VPWR VGND sg13g2_decap_4
XFILLER_40_1653 VPWR VGND sg13g2_decap_8
XFILLER_21_1041 VPWR VGND sg13g2_decap_4
XFILLER_21_1052 VPWR VGND sg13g2_fill_1
XFILLER_63_426 VPWR VGND sg13g2_decap_8
XFILLER_63_437 VPWR VGND sg13g2_fill_1
X_17572_ _22880_/D _17652_/B _17570_/Y _17571_/Y VPWR VGND sg13g2_a21oi_1
XFILLER_28_180 VPWR VGND sg13g2_decap_8
X_14784_ _14789_/B _14885_/A _17527_/A _17932_/B VPWR VGND sg13g2_o21ai_1
X_11996_ _12965_/B _12096_/B _12096_/C VPWR VGND sg13g2_nor2_2
X_19311_ _20367_/B _19311_/A VPWR VGND sg13g2_inv_1
X_16523_ _16524_/C _16774_/B _16774_/D VPWR VGND sg13g2_nand2_1
X_13735_ _13735_/Y _13545_/B _13733_/Y _20271_/A VPWR VGND sg13g2_a21oi_1
XFILLER_56_1126 VPWR VGND sg13g2_fill_2
XFILLER_91_1028 VPWR VGND sg13g2_fill_1
XFILLER_31_312 VPWR VGND sg13g2_fill_1
XFILLER_91_1039 VPWR VGND sg13g2_decap_4
X_19242_ _19243_/B _19265_/A _19241_/Y _19257_/B VPWR VGND sg13g2_o21ai_1
X_16454_ _16454_/Y _22591_/Q _16470_/B VPWR VGND sg13g2_nand2_1
XFILLER_32_868 VPWR VGND sg13g2_fill_1
X_13666_ _13666_/Y _13666_/A _14014_/S VPWR VGND sg13g2_xnor2_1
XFILLER_73_1440 VPWR VGND sg13g2_fill_2
X_15405_ _19778_/A _15577_/A _15388_/Y _15404_/Y VPWR VGND sg13g2_o21ai_1
XFILLER_38_1593 VPWR VGND sg13g2_decap_4
XFILLER_31_378 VPWR VGND sg13g2_decap_8
X_12617_ _12762_/B _12628_/A1 _12607_/X _12609_/Y VPWR VGND sg13g2_a21o_1
XFILLER_73_1484 VPWR VGND sg13g2_fill_2
X_16385_ _16385_/Y _22557_/Q _16388_/B VPWR VGND sg13g2_nand2_1
X_13597_ _13597_/X _13597_/A _13597_/B _13597_/C _13597_/D VPWR VGND sg13g2_or4_1
X_18124_ _22955_/D _18498_/C _22955_/Q _18471_/S VPWR VGND sg13g2_mux2_1
X_15336_ _16879_/A _16048_/S _15333_/Y _15335_/Y VPWR VGND sg13g2_o21ai_1
X_12548_ _12768_/S _12639_/S _12539_/Y _12538_/A VPWR VGND sg13g2_a21o_2
XFILLER_8_563 VPWR VGND sg13g2_fill_2
XFILLER_16_1891 VPWR VGND sg13g2_decap_8
XFILLER_103_1861 VPWR VGND sg13g2_decap_8
X_15267_ _15269_/B _15232_/Y _15261_/Y _15266_/Y VPWR VGND sg13g2_a21oi_1
XANTENNA_2 _15865_/C VPWR VGND sg13g2_antennanp
X_12479_ _12480_/D _12318_/A _12478_/X _12316_/A VPWR VGND sg13g2_o21ai_1
X_17006_ _17006_/Y _17197_/A _17021_/B VPWR VGND sg13g2_nand2_1
XFILLER_86_1845 VPWR VGND sg13g2_decap_8
X_14218_ _14219_/B _14218_/A _22822_/Q VPWR VGND sg13g2_nand2_1
XFILLER_6_75 VPWR VGND sg13g2_decap_4
XFILLER_12_1799 VPWR VGND sg13g2_decap_8
XFILLER_6_86 VPWR VGND sg13g2_fill_2
XFILLER_99_846 VPWR VGND sg13g2_decap_8
X_14149_ _14772_/A _14766_/A _14435_/B _14766_/B VPWR VGND sg13g2_o21ai_1
XFILLER_113_645 VPWR VGND sg13g2_decap_8
XFILLER_63_1119 VPWR VGND sg13g2_decap_4
XFILLER_112_133 VPWR VGND sg13g2_decap_8
X_18957_ _18958_/C _18959_/A _23053_/Q _18957_/C VPWR VGND sg13g2_or3_1
XFILLER_79_581 VPWR VGND sg13g2_decap_8
X_17908_ _17910_/A _17908_/A1 _17918_/A2 _17920_/B1 _17187_/A VPWR VGND sg13g2_a22oi_1
X_18888_ _18888_/Y _18922_/A _18888_/B VPWR VGND sg13g2_nand2_1
XFILLER_13_0 VPWR VGND sg13g2_decap_4
XFILLER_39_456 VPWR VGND sg13g2_decap_8
XFILLER_23_1851 VPWR VGND sg13g2_fill_1
XFILLER_94_562 VPWR VGND sg13g2_fill_2
XFILLER_110_1810 VPWR VGND sg13g2_decap_8
XFILLER_82_713 VPWR VGND sg13g2_fill_2
XFILLER_23_1884 VPWR VGND sg13g2_decap_8
XFILLER_82_746 VPWR VGND sg13g2_decap_8
X_20850_ _20850_/Y _20850_/A _20853_/B VPWR VGND sg13g2_nand2_1
XFILLER_93_1816 VPWR VGND sg13g2_decap_8
XFILLER_81_256 VPWR VGND sg13g2_fill_1
XFILLER_78_1362 VPWR VGND sg13g2_fill_1
XFILLER_110_1887 VPWR VGND sg13g2_decap_8
XFILLER_58_1947 VPWR VGND sg13g2_decap_8
X_19509_ _19509_/Y _24214_/Q _24213_/Q VPWR VGND sg13g2_nand2b_1
XFILLER_63_971 VPWR VGND sg13g2_decap_8
XFILLER_34_150 VPWR VGND sg13g2_decap_8
X_20781_ _20781_/Y _20781_/A _20784_/B VPWR VGND sg13g2_nand2_1
XFILLER_1_1680 VPWR VGND sg13g2_fill_1
XFILLER_35_684 VPWR VGND sg13g2_decap_8
XFILLER_90_790 VPWR VGND sg13g2_decap_4
X_22520_ _22520_/Q clkload11/A _22520_/D fanout2837/X VPWR VGND sg13g2_dfrbpq_1
XFILLER_23_857 VPWR VGND sg13g2_fill_2
XFILLER_50_654 VPWR VGND sg13g2_fill_1
XFILLER_17_1644 VPWR VGND sg13g2_decap_8
XFILLER_91_1584 VPWR VGND sg13g2_fill_2
X_22451_ _24212_/D _22451_/A1 _22450_/B _22450_/Y VPWR VGND sg13g2_o21ai_1
XFILLER_37_1092 VPWR VGND sg13g2_decap_8
XFILLER_41_17 VPWR VGND sg13g2_fill_2
XFILLER_50_698 VPWR VGND sg13g2_fill_1
XFILLER_52_1557 VPWR VGND sg13g2_decap_8
X_21402_ _21421_/S _22318_/B _21557_/B VPWR VGND sg13g2_and2_1
X_22382_ _24179_/D _24179_/Q _22449_/A1 _22382_/S VPWR VGND sg13g2_mux2_1
XFILLER_30_1811 VPWR VGND sg13g2_fill_1
X_24121_ _24121_/Q clkload56/A _24121_/D fanout2748/X VPWR VGND sg13g2_dfrbpq_1
X_21333_ _23687_/D _21333_/A1 _21353_/B _21332_/Y VPWR VGND sg13g2_o21ai_1
XFILLER_11_1232 VPWR VGND sg13g2_decap_8
XFILLER_30_1855 VPWR VGND sg13g2_decap_8
XFILLER_102_1371 VPWR VGND sg13g2_decap_4
XFILLER_85_1311 VPWR VGND sg13g2_decap_8
X_21264_ _21264_/Y _21264_/A _21264_/B VPWR VGND sg13g2_nand2_1
X_24052_ _24052_/Q _24212_/CLK _24052_/D fanout2622/X VPWR VGND sg13g2_dfrbpq_1
X_20215_ _20215_/X _20343_/A3 _23219_/Q _20343_/A2 _20343_/A1 _19912_/S _20343_/S0
+ VPWR VGND sg13g2_mux4_1
X_23003_ _23003_/Q clkload17/A _23003_/D fanout2838/X VPWR VGND sg13g2_dfrbpq_1
Xfanout2709 fanout2709/X fanout2712/X VPWR VGND sg13g2_buf_1
XFILLER_104_645 VPWR VGND sg13g2_decap_8
X_21195_ _21195_/Y _23621_/Q _21197_/B VPWR VGND sg13g2_nand2_1
XFILLER_106_21 VPWR VGND sg13g2_decap_8
XFILLER_77_507 VPWR VGND sg13g2_fill_2
X_20146_ _20146_/Y _14399_/B _15735_/C _20367_/B VPWR VGND sg13g2_a21oi_1
XFILLER_115_1721 VPWR VGND sg13g2_decap_8
XFILLER_98_890 VPWR VGND sg13g2_decap_8
XFILLER_8_1867 VPWR VGND sg13g2_decap_8
XFILLER_57_220 VPWR VGND sg13g2_decap_8
XFILLER_106_98 VPWR VGND sg13g2_decap_8
XFILLER_18_618 VPWR VGND sg13g2_decap_8
XFILLER_46_927 VPWR VGND sg13g2_decap_8
X_23905_ _23905_/Q clkload45/A _23905_/D fanout2716/X VPWR VGND sg13g2_dfrbpq_1
XFILLER_115_1798 VPWR VGND sg13g2_decap_8
XFILLER_85_584 VPWR VGND sg13g2_decap_8
XFILLER_58_798 VPWR VGND sg13g2_fill_2
XFILLER_46_949 VPWR VGND sg13g2_fill_1
XFILLER_17_128 VPWR VGND sg13g2_fill_2
X_23836_ _23836_/Q _23966_/CLK _23836_/D fanout2764/X VPWR VGND sg13g2_dfrbpq_1
X_11850_ _11857_/A _12247_/A _11850_/B VPWR VGND sg13g2_nor2_1
XFILLER_73_757 VPWR VGND sg13g2_decap_8
XFILLER_2_1488 VPWR VGND sg13g2_fill_1
XFILLER_60_407 VPWR VGND sg13g2_decap_8
XFILLER_54_982 VPWR VGND sg13g2_fill_2
X_23767_ _23767_/Q clkload52/A _23767_/D fanout2689/X VPWR VGND sg13g2_dfrbpq_1
X_11781_ _11782_/B _12002_/A _11781_/B _11781_/C VPWR VGND sg13g2_and3_1
XFILLER_92_1326 VPWR VGND sg13g2_fill_2
XFILLER_82_57 VPWR VGND sg13g2_decap_8
X_20979_ _20979_/Y _20979_/A _20983_/B VPWR VGND sg13g2_nand2_1
XFILLER_26_695 VPWR VGND sg13g2_decap_8
X_13520_ _13520_/X _13520_/A _13520_/B _15839_/A VPWR VGND sg13g2_and3_1
X_22718_ _22718_/Q clkload24/A _22718_/D fanout2888/X VPWR VGND sg13g2_dfrbpq_1
XFILLER_40_120 VPWR VGND sg13g2_fill_1
X_23698_ _23698_/Q clkload32/A _23698_/D fanout2648/X VPWR VGND sg13g2_dfrbpq_1
XFILLER_41_665 VPWR VGND sg13g2_fill_2
XFILLER_74_1771 VPWR VGND sg13g2_decap_8
X_13451_ _13451_/X _23725_/Q _23757_/Q _23789_/Q _23821_/Q _13635_/S0 _13631_/S1 VPWR
+ VGND sg13g2_mux4_1
XFILLER_16_1121 VPWR VGND sg13g2_decap_4
XFILLER_35_1744 VPWR VGND sg13g2_decap_8
X_22649_ _22649_/Q _22733_/CLK _22649_/D fanout2879/X VPWR VGND sg13g2_dfrbpq_1
XFILLER_51_1034 VPWR VGND sg13g2_decap_8
XFILLER_107_1271 VPWR VGND sg13g2_decap_8
X_12402_ _12402_/Y _12401_/B _24031_/Q _12401_/Y VPWR VGND sg13g2_o21ai_1
XFILLER_107_1282 VPWR VGND sg13g2_fill_2
X_16170_ _16170_/Y _22505_/Q _16156_/B _16169_/Y VPWR VGND sg13g2_a21oi_1
X_13382_ _24267_/A _14065_/C VPWR VGND sg13g2_inv_4
XFILLER_16_1187 VPWR VGND sg13g2_decap_8
XFILLER_51_1078 VPWR VGND sg13g2_decap_8
X_15121_ _15121_/X _24230_/Q _19150_/A VPWR VGND sg13g2_and2_1
XFILLER_51_1089 VPWR VGND sg13g2_fill_1
X_12333_ _14387_/B _12341_/A _12341_/B VPWR VGND sg13g2_nand2_1
XFILLER_108_962 VPWR VGND sg13g2_fill_1
X_12264_ _12533_/B _13123_/A _13179_/B _12264_/C VPWR VGND sg13g2_nand3_1
X_14003_ _14006_/B _14000_/Y _14001_/Y _14002_/Y VPWR VGND sg13g2_a21oi_1
X_11215_ _11326_/D _14120_/C _22966_/Q VPWR VGND sg13g2_nand2b_1
X_12195_ _12219_/C _12195_/A _12195_/B _12195_/C _12195_/D VPWR VGND sg13g2_nor4_1
X_19860_ _19880_/A _24252_/A _19977_/B VPWR VGND sg13g2_nand2_1
XFILLER_64_1439 VPWR VGND sg13g2_decap_8
XFILLER_46_1862 VPWR VGND sg13g2_fill_1
X_19791_ _19791_/Y _19791_/A _19950_/B VPWR VGND sg13g2_nand2_1
XFILLER_42_1704 VPWR VGND sg13g2_decap_8
XFILLER_42_1715 VPWR VGND sg13g2_fill_1
XFILLER_110_648 VPWR VGND sg13g2_decap_8
XFILLER_95_348 VPWR VGND sg13g2_fill_2
X_15954_ _15954_/Y _16020_/B _17920_/B2 _15953_/Y VPWR VGND sg13g2_o21ai_1
X_18742_ _18742_/Y _18742_/A _18742_/B _18750_/C VPWR VGND sg13g2_nand3_1
XFILLER_81_1797 VPWR VGND sg13g2_decap_8
XFILLER_37_905 VPWR VGND sg13g2_fill_1
XFILLER_42_1759 VPWR VGND sg13g2_fill_2
XFILLER_48_242 VPWR VGND sg13g2_decap_4
XFILLER_114_1264 VPWR VGND sg13g2_fill_1
X_14905_ _14905_/Y _14905_/A _14905_/B VPWR VGND sg13g2_nand2_1
X_18673_ _18673_/Y _14956_/Y _14958_/Y _14959_/Y VPWR VGND sg13g2_a21oi_1
XFILLER_36_404 VPWR VGND sg13g2_decap_8
XFILLER_48_264 VPWR VGND sg13g2_fill_1
XFILLER_49_787 VPWR VGND sg13g2_decap_8
X_15885_ _17192_/A _15884_/A _15883_/Y _15884_/Y VPWR VGND sg13g2_a21o_1
XFILLER_91_510 VPWR VGND sg13g2_decap_8
XFILLER_40_1450 VPWR VGND sg13g2_fill_2
XFILLER_48_275 VPWR VGND sg13g2_decap_8
XFILLER_91_521 VPWR VGND sg13g2_fill_1
XFILLER_97_1259 VPWR VGND sg13g2_fill_2
XFILLER_91_543 VPWR VGND sg13g2_fill_1
XFILLER_5_1090 VPWR VGND sg13g2_decap_4
XFILLER_36_448 VPWR VGND sg13g2_decap_8
X_17624_ _17654_/D _22555_/Q _22554_/Q _22553_/Q _17624_/D VPWR VGND sg13g2_and4_1
X_14836_ _14836_/Y _14788_/A _14788_/C _14835_/Y _14774_/A VPWR VGND sg13g2_a22oi_1
XFILLER_40_1494 VPWR VGND sg13g2_decap_8
XFILLER_63_256 VPWR VGND sg13g2_decap_8
XFILLER_23_109 VPWR VGND sg13g2_decap_8
X_17555_ _17555_/X _22549_/Q _22946_/Q VPWR VGND sg13g2_xor2_1
X_14767_ _14767_/Y _14782_/B _14780_/A _14786_/B VPWR VGND sg13g2_o21ai_1
XFILLER_51_429 VPWR VGND sg13g2_decap_8
X_11979_ _12002_/C _14039_/A _11979_/B VPWR VGND sg13g2_xnor2_1
XFILLER_17_684 VPWR VGND sg13g2_fill_1
X_16506_ _16506_/Y _22613_/Q _16506_/B VPWR VGND sg13g2_nand2_1
X_13718_ _20290_/B _13861_/C _13861_/D VPWR VGND sg13g2_nor2_1
X_14698_ _14698_/X _14695_/Y _14697_/Y _14737_/S VPWR VGND sg13g2_mux2_1
XFILLER_32_665 VPWR VGND sg13g2_decap_8
XFILLER_108_1046 VPWR VGND sg13g2_fill_2
X_16437_ _22585_/D _22585_/Q _16879_/A _16437_/S VPWR VGND sg13g2_mux2_1
XFILLER_18_1953 VPWR VGND sg13g2_fill_2
X_19225_ _23179_/D _24268_/A _23179_/Q _19232_/B VPWR VGND sg13g2_mux2_1
XFILLER_31_153 VPWR VGND sg13g2_fill_2
XFILLER_60_996 VPWR VGND sg13g2_fill_2
XFILLER_105_1912 VPWR VGND sg13g2_decap_8
XFILLER_34_1221 VPWR VGND sg13g2_decap_8
X_13649_ _13651_/C _13649_/A _14694_/A VPWR VGND sg13g2_nand2_1
X_19156_ _23129_/D _23129_/Q _14860_/X _19159_/S VPWR VGND sg13g2_mux2_1
X_16368_ _16369_/A _15133_/A _14522_/B _16029_/B _22547_/Q VPWR VGND sg13g2_a22oi_1
XFILLER_34_1287 VPWR VGND sg13g2_decap_8
XFILLER_34_1298 VPWR VGND sg13g2_fill_1
X_15319_ _15319_/Y _15319_/A _15482_/A _15319_/C VPWR VGND sg13g2_nor3_1
XFILLER_8_382 VPWR VGND sg13g2_fill_2
X_19087_ _19087_/X _18895_/B _23112_/Q _19098_/S VPWR VGND sg13g2_mux2_1
Xhold4806 _20480_/A _23301_/Q VPWR VGND sg13g2_dlygate4sd3_1
Xhold4817 _22065_/A _24025_/Q VPWR VGND sg13g2_dlygate4sd3_1
Xhold4828 _21648_/A _23838_/Q VPWR VGND sg13g2_dlygate4sd3_1
XFILLER_86_1675 VPWR VGND sg13g2_fill_1
Xhold4839 _22011_/A _23999_/Q VPWR VGND sg13g2_dlygate4sd3_1
XFILLER_114_954 VPWR VGND sg13g2_fill_1
XFILLER_114_965 VPWR VGND sg13g2_decap_8
XFILLER_113_442 VPWR VGND sg13g2_decap_8
X_20000_ _20000_/Y _20000_/A _20052_/B VPWR VGND sg13g2_nand2_1
XFILLER_64_1940 VPWR VGND sg13g2_decap_8
XFILLER_87_838 VPWR VGND sg13g2_decap_8
X_19989_ _20177_/B _20031_/A _19766_/Y _19988_/Y VPWR VGND sg13g2_o21ai_1
XFILLER_60_1804 VPWR VGND sg13g2_decap_4
XFILLER_100_125 VPWR VGND sg13g2_fill_1
XFILLER_67_540 VPWR VGND sg13g2_fill_1
XFILLER_95_860 VPWR VGND sg13g2_decap_4
XFILLER_95_871 VPWR VGND sg13g2_decap_8
XFILLER_60_1859 VPWR VGND sg13g2_decap_4
XFILLER_112_1938 VPWR VGND sg13g2_decap_8
XFILLER_28_927 VPWR VGND sg13g2_fill_2
XFILLER_41_1247 VPWR VGND sg13g2_fill_1
XFILLER_39_264 VPWR VGND sg13g2_fill_1
X_21951_ _21951_/Y _21951_/A _21951_/B VPWR VGND sg13g2_nand2_1
XFILLER_55_724 VPWR VGND sg13g2_fill_1
XFILLER_27_437 VPWR VGND sg13g2_decap_8
X_20902_ _23497_/D _21336_/A0 _23497_/Q _20902_/S VPWR VGND sg13g2_mux2_1
XFILLER_82_532 VPWR VGND sg13g2_decap_8
XFILLER_3_1764 VPWR VGND sg13g2_decap_8
XFILLER_43_908 VPWR VGND sg13g2_fill_1
XFILLER_97_1760 VPWR VGND sg13g2_decap_8
X_21882_ _23936_/D _21948_/A1 _21885_/B _21881_/Y VPWR VGND sg13g2_o21ai_1
XFILLER_43_919 VPWR VGND sg13g2_decap_8
XFILLER_70_705 VPWR VGND sg13g2_fill_2
XFILLER_42_407 VPWR VGND sg13g2_decap_8
XFILLER_97_1782 VPWR VGND sg13g2_fill_2
X_23621_ _23621_/Q clkload42/A _23621_/D fanout2718/X VPWR VGND sg13g2_dfrbpq_1
XFILLER_70_727 VPWR VGND sg13g2_decap_4
X_20833_ _20852_/S _22430_/B _20921_/B VPWR VGND sg13g2_nor2b_1
XFILLER_19_1717 VPWR VGND sg13g2_fill_1
XFILLER_51_941 VPWR VGND sg13g2_fill_1
XFILLER_19_1739 VPWR VGND sg13g2_fill_1
X_23552_ _23552_/Q _24131_/CLK _23552_/D fanout2715/X VPWR VGND sg13g2_dfrbpq_1
X_20764_ _20783_/S _22318_/B _20921_/B VPWR VGND sg13g2_and2_1
XFILLER_35_1007 VPWR VGND sg13g2_fill_2
XFILLER_39_1176 VPWR VGND sg13g2_fill_1
XFILLER_71_1911 VPWR VGND sg13g2_fill_2
XFILLER_50_451 VPWR VGND sg13g2_decap_4
X_22503_ _22503_/Q _22941_/CLK _22503_/D fanout2802/X VPWR VGND sg13g2_dfrbpq_1
X_23483_ _23483_/Q clkload59/A _23483_/D fanout2788/X VPWR VGND sg13g2_dfrbpq_1
X_20695_ _23400_/D _21964_/A0 _23400_/Q _20706_/S VPWR VGND sg13g2_mux2_1
XFILLER_22_186 VPWR VGND sg13g2_decap_8
XFILLER_108_1591 VPWR VGND sg13g2_decap_8
X_22434_ _22434_/Y _22434_/A _22434_/B VPWR VGND sg13g2_nand2_1
XFILLER_108_203 VPWR VGND sg13g2_decap_8
X_22365_ _24168_/D _24168_/Q _20172_/Y _22382_/S VPWR VGND sg13g2_mux2_1
XFILLER_104_1499 VPWR VGND sg13g2_fill_2
X_24104_ _24104_/Q clkload32/A _24104_/D fanout2648/X VPWR VGND sg13g2_dfrbpq_1
XFILLER_69_1840 VPWR VGND sg13g2_fill_1
X_21316_ _21316_/Y _21316_/A _21337_/B VPWR VGND sg13g2_nand2_1
XFILLER_30_1685 VPWR VGND sg13g2_fill_1
X_22296_ _24135_/D _22296_/A1 _22295_/B _22295_/Y VPWR VGND sg13g2_o21ai_1
XFILLER_2_503 VPWR VGND sg13g2_fill_1
XFILLER_85_1130 VPWR VGND sg13g2_decap_4
X_21247_ _21247_/Y _21247_/A _21247_/B VPWR VGND sg13g2_nand2_1
XFILLER_46_1103 VPWR VGND sg13g2_decap_8
X_24035_ _24035_/Q _24131_/CLK _24035_/D fanout2711/X VPWR VGND sg13g2_dfrbpq_1
XFILLER_85_1174 VPWR VGND sg13g2_decap_4
XFILLER_104_442 VPWR VGND sg13g2_decap_8
XFILLER_104_453 VPWR VGND sg13g2_fill_2
XFILLER_77_24 VPWR VGND sg13g2_decap_8
XFILLER_89_153 VPWR VGND sg13g2_fill_2
XFILLER_46_1147 VPWR VGND sg13g2_decap_8
X_21178_ _23613_/D _21178_/A1 _21179_/B _21177_/Y VPWR VGND sg13g2_o21ai_1
XFILLER_81_1038 VPWR VGND sg13g2_decap_8
XFILLER_78_838 VPWR VGND sg13g2_decap_4
X_20129_ _20129_/X _20255_/A3 _23214_/Q _20255_/A2 _20255_/A1 _19884_/A _20343_/S0
+ VPWR VGND sg13g2_mux4_1
XFILLER_24_1412 VPWR VGND sg13g2_fill_2
XFILLER_77_359 VPWR VGND sg13g2_decap_8
XFILLER_24_1467 VPWR VGND sg13g2_fill_1
X_12951_ _12951_/Y _12951_/A _12951_/B _15669_/A VPWR VGND sg13g2_nor3_1
XFILLER_85_370 VPWR VGND sg13g2_fill_1
XFILLER_58_595 VPWR VGND sg13g2_decap_4
XFILLER_100_692 VPWR VGND sg13g2_decap_8
XFILLER_41_1770 VPWR VGND sg13g2_fill_2
XFILLER_98_1557 VPWR VGND sg13g2_fill_2
XFILLER_93_45 VPWR VGND sg13g2_decap_4
X_11902_ _11910_/A _11393_/Y _11899_/Y _11901_/Y VPWR VGND sg13g2_a21oi_1
X_15670_ _17881_/A _20087_/B _14434_/Y _15669_/X VPWR VGND sg13g2_a21oi_1
XFILLER_73_543 VPWR VGND sg13g2_fill_2
X_12882_ _12882_/Y _23781_/Q _12884_/B VPWR VGND sg13g2_nand2b_1
XFILLER_34_919 VPWR VGND sg13g2_decap_8
XFILLER_76_1811 VPWR VGND sg13g2_decap_8
XFILLER_61_716 VPWR VGND sg13g2_fill_2
XFILLER_93_89 VPWR VGND sg13g2_decap_4
X_14621_ _14622_/S _14699_/B _14631_/B VPWR VGND sg13g2_nand2_1
X_23819_ _23819_/Q clkload49/A _23819_/D fanout2675/X VPWR VGND sg13g2_dfrbpq_1
X_11833_ _11834_/B _24153_/Q _24185_/Q _11836_/B VPWR VGND sg13g2_mux2_1
XFILLER_73_587 VPWR VGND sg13g2_fill_2
XFILLER_45_289 VPWR VGND sg13g2_decap_8
XFILLER_60_215 VPWR VGND sg13g2_decap_8
XFILLER_26_72 VPWR VGND sg13g2_decap_8
XFILLER_37_1806 VPWR VGND sg13g2_fill_1
XFILLER_61_749 VPWR VGND sg13g2_decap_8
X_17340_ _22797_/D _17476_/A1 _17366_/S _17339_/Y VPWR VGND sg13g2_o21ai_1
XFILLER_60_237 VPWR VGND sg13g2_fill_2
X_14552_ _24226_/D _14546_/Y _14551_/Y _14825_/A VPWR VGND sg13g2_a21oi_1
X_11764_ _12288_/B _12175_/B _11921_/A VPWR VGND sg13g2_nand2b_2
XFILLER_18_1227 VPWR VGND sg13g2_fill_1
XFILLER_57_1276 VPWR VGND sg13g2_fill_2
XFILLER_92_1167 VPWR VGND sg13g2_fill_1
XFILLER_13_142 VPWR VGND sg13g2_fill_1
X_13503_ _13503_/Y _13503_/A _13503_/B _13748_/C VPWR VGND sg13g2_nand3_1
X_17271_ _22765_/D _17476_/A1 _17300_/B _17270_/Y VPWR VGND sg13g2_o21ai_1
X_14483_ _14486_/B _22597_/Q _23008_/Q VPWR VGND sg13g2_xor2_1
XFILLER_13_175 VPWR VGND sg13g2_fill_2
XFILLER_13_186 VPWR VGND sg13g2_fill_1
X_19010_ _19010_/Y _19043_/A _19010_/B VPWR VGND sg13g2_nand2_1
X_16222_ _16237_/D _16241_/C _16241_/D VPWR VGND sg13g2_and2_1
XFILLER_42_60 VPWR VGND sg13g2_fill_1
X_13434_ _13449_/B _13434_/A _13528_/B VPWR VGND sg13g2_xnor2_1
XFILLER_35_1585 VPWR VGND sg13g2_decap_8
XFILLER_42_71 VPWR VGND sg13g2_fill_2
X_16153_ _22502_/D _16177_/B _16151_/Y _16152_/Y VPWR VGND sg13g2_o21ai_1
XFILLER_70_1498 VPWR VGND sg13g2_fill_1
X_13365_ _13366_/C _20179_/A _20179_/B _20166_/B VPWR VGND sg13g2_a21oi_1
XFILLER_13_1850 VPWR VGND sg13g2_decap_8
X_15104_ _15105_/B _22481_/Q _14947_/B _14936_/B VPWR VGND sg13g2_a21oi_1
X_12316_ _12324_/B _12316_/A _12316_/B VPWR VGND sg13g2_nand2_1
XFILLER_6_875 VPWR VGND sg13g2_decap_4
X_16084_ _17540_/B _16856_/A _16364_/B _16084_/C VPWR VGND sg13g2_or3_1
X_13296_ _13297_/B _13296_/A _14032_/A _20178_/B VPWR VGND sg13g2_nand3_1
XFILLER_54_7 VPWR VGND sg13g2_fill_2
XFILLER_114_217 VPWR VGND sg13g2_decap_8
XFILLER_6_897 VPWR VGND sg13g2_decap_8
XFILLER_83_1815 VPWR VGND sg13g2_fill_1
X_19912_ _19912_/X _19910_/X _19911_/X _19912_/S VPWR VGND sg13g2_mux2_1
X_15035_ _15037_/A _22505_/Q _14998_/B _15075_/B1 _22933_/Q VPWR VGND sg13g2_a22oi_1
X_12247_ _12250_/C _12247_/A _12247_/B VPWR VGND sg13g2_nor2_1
XFILLER_100_1897 VPWR VGND sg13g2_decap_8
XFILLER_3_21 VPWR VGND sg13g2_decap_8
X_12178_ _12178_/Y _23163_/Q _12640_/B _12824_/B1 _12177_/X VPWR VGND sg13g2_a22oi_1
XFILLER_95_101 VPWR VGND sg13g2_fill_1
XFILLER_3_54 VPWR VGND sg13g2_fill_2
XFILLER_1_591 VPWR VGND sg13g2_fill_2
X_19774_ _19775_/B _19773_/A _19772_/Y _19773_/Y VPWR VGND sg13g2_a21oi_1
XFILLER_7_1141 VPWR VGND sg13g2_decap_8
XFILLER_84_819 VPWR VGND sg13g2_decap_8
X_16986_ _22706_/D _16972_/B _16983_/Y _16985_/Y VPWR VGND sg13g2_o21ai_1
XFILLER_3_98 VPWR VGND sg13g2_fill_2
XFILLER_27_1091 VPWR VGND sg13g2_fill_1
XFILLER_77_882 VPWR VGND sg13g2_decap_8
X_18725_ _18725_/Y _18729_/A _18729_/B _15042_/B VPWR VGND sg13g2_o21ai_1
XFILLER_49_573 VPWR VGND sg13g2_decap_8
X_15937_ _15941_/A _22906_/Q _15937_/B VPWR VGND sg13g2_nand2_1
XFILLER_36_201 VPWR VGND sg13g2_fill_1
XFILLER_64_510 VPWR VGND sg13g2_decap_8
X_15868_ _15868_/X _17187_/A _22475_/Q _15935_/S VPWR VGND sg13g2_mux2_1
X_18656_ _23009_/D _18651_/B _18655_/Y _14919_/A VPWR VGND sg13g2_a21oi_1
XFILLER_92_863 VPWR VGND sg13g2_decap_8
X_14819_ _14819_/Y _11782_/A _11782_/B _14956_/C VPWR VGND sg13g2_o21ai_1
XFILLER_18_982 VPWR VGND sg13g2_fill_1
X_17607_ _17608_/B _17689_/B1 _17604_/Y _17606_/Y _17538_/B VPWR VGND sg13g2_a22oi_1
XFILLER_79_1490 VPWR VGND sg13g2_fill_1
X_18587_ _18587_/Y _18884_/B _18803_/A _18587_/C VPWR VGND sg13g2_nand3_1
X_15799_ _16154_/B _15799_/A _16352_/B _15799_/C VPWR VGND sg13g2_nand3_1
XFILLER_20_1898 VPWR VGND sg13g2_decap_8
XFILLER_55_1906 VPWR VGND sg13g2_decap_8
XFILLER_75_1332 VPWR VGND sg13g2_decap_8
X_17538_ _17538_/Y _24238_/Q _17538_/B VPWR VGND sg13g2_nor2_1
XFILLER_75_1376 VPWR VGND sg13g2_decap_4
XFILLER_33_996 VPWR VGND sg13g2_decap_8
X_17469_ _17469_/Y _17469_/A _17507_/S VPWR VGND sg13g2_nand2_1
XFILLER_92_1690 VPWR VGND sg13g2_fill_1
XFILLER_60_793 VPWR VGND sg13g2_decap_8
XFILLER_80_0 VPWR VGND sg13g2_decap_8
XFILLER_18_1772 VPWR VGND sg13g2_fill_1
XFILLER_18_1783 VPWR VGND sg13g2_decap_8
Xplace3901 _18451_/A _18351_/A VPWR VGND sg13g2_buf_1
X_19208_ _23165_/D _24254_/A _23165_/Q _19209_/S VPWR VGND sg13g2_mux2_1
X_20480_ _20480_/Y _20480_/A _20482_/B VPWR VGND sg13g2_nand2_1
Xplace3912 _18421_/A _18274_/B VPWR VGND sg13g2_buf_1
Xplace3923 _18866_/A _18803_/A VPWR VGND sg13g2_buf_1
Xplace3934 _13988_/A2 _19197_/A VPWR VGND sg13g2_buf_1
Xplace3945 _12414_/A _11556_/A VPWR VGND sg13g2_buf_1
Xplace3956 _18951_/A _18884_/B VPWR VGND sg13g2_buf_1
X_19139_ _23115_/D _23115_/Q _18929_/A _19141_/S VPWR VGND sg13g2_mux2_1
XFILLER_105_1797 VPWR VGND sg13g2_fill_1
Xplace3967 _18339_/A _14471_/A VPWR VGND sg13g2_buf_1
Xplace3978 _13607_/A place3978/A VPWR VGND sg13g2_buf_1
X_22150_ _24065_/D _22284_/A1 _22151_/B _22149_/Y VPWR VGND sg13g2_o21ai_1
Xplace3989 _13191_/B1 _13256_/A VPWR VGND sg13g2_buf_1
Xhold4636 hold4636/X _24218_/Q VPWR VGND sg13g2_dlygate4sd3_1
X_22081_ _24032_/D _22282_/A1 _22084_/B _22080_/Y VPWR VGND sg13g2_o21ai_1
Xhold4647 _17477_/A _22856_/Q VPWR VGND sg13g2_dlygate4sd3_1
Xhold4658 _17343_/A _22799_/Q VPWR VGND sg13g2_dlygate4sd3_1
X_21032_ _21032_/Y _21032_/A _21042_/B VPWR VGND sg13g2_nand2_1
Xhold4669 _17257_/A _22759_/Q VPWR VGND sg13g2_dlygate4sd3_1
XFILLER_87_613 VPWR VGND sg13g2_fill_1
XFILLER_114_795 VPWR VGND sg13g2_decap_8
XFILLER_86_101 VPWR VGND sg13g2_fill_1
XFILLER_82_1369 VPWR VGND sg13g2_decap_8
XFILLER_47_1489 VPWR VGND sg13g2_fill_2
XFILLER_113_283 VPWR VGND sg13g2_fill_2
XFILLER_5_1826 VPWR VGND sg13g2_decap_8
XFILLER_25_1754 VPWR VGND sg13g2_decap_8
XFILLER_74_307 VPWR VGND sg13g2_decap_8
XFILLER_41_1033 VPWR VGND sg13g2_decap_8
XFILLER_80_1093 VPWR VGND sg13g2_fill_1
XFILLER_60_1667 VPWR VGND sg13g2_decap_4
XFILLER_112_1735 VPWR VGND sg13g2_decap_8
XFILLER_25_1787 VPWR VGND sg13g2_decap_8
X_22983_ _22983_/Q clkload16/A _22983_/D fanout2921/X VPWR VGND sg13g2_dfrbpq_2
XFILLER_67_370 VPWR VGND sg13g2_decap_8
XFILLER_68_893 VPWR VGND sg13g2_decap_8
XFILLER_83_830 VPWR VGND sg13g2_decap_4
XFILLER_83_841 VPWR VGND sg13g2_decap_8
XFILLER_60_1689 VPWR VGND sg13g2_decap_8
X_21934_ _23962_/D _21934_/A1 _21935_/B _21933_/Y VPWR VGND sg13g2_o21ai_1
XFILLER_16_908 VPWR VGND sg13g2_decap_4
XFILLER_27_245 VPWR VGND sg13g2_fill_2
XFILLER_41_1099 VPWR VGND sg13g2_decap_8
XFILLER_27_267 VPWR VGND sg13g2_fill_1
XFILLER_43_716 VPWR VGND sg13g2_decap_8
XFILLER_103_77 VPWR VGND sg13g2_decap_8
X_21865_ _21865_/Y _23929_/Q _21876_/B VPWR VGND sg13g2_nand2_1
XFILLER_15_429 VPWR VGND sg13g2_decap_8
XFILLER_42_215 VPWR VGND sg13g2_fill_1
XFILLER_24_930 VPWR VGND sg13g2_decap_8
XFILLER_58_1552 VPWR VGND sg13g2_decap_4
XFILLER_70_546 VPWR VGND sg13g2_fill_1
XFILLER_24_941 VPWR VGND sg13g2_fill_2
X_23604_ _23604_/Q clkload56/A _23604_/D fanout2672/X VPWR VGND sg13g2_dfrbpq_1
X_20816_ _20816_/Y _23457_/Q _20818_/B VPWR VGND sg13g2_nand2_1
XFILLER_58_1574 VPWR VGND sg13g2_decap_8
XFILLER_23_440 VPWR VGND sg13g2_decap_8
X_21796_ _21796_/Y _23896_/Q _21804_/B VPWR VGND sg13g2_nand2_1
XFILLER_24_985 VPWR VGND sg13g2_decap_4
X_23535_ _23535_/Q clkload30/A _23535_/D fanout2658/X VPWR VGND sg13g2_dfrbpq_1
X_20747_ _20747_/Y _23424_/Q _20751_/B VPWR VGND sg13g2_nand2_1
XFILLER_10_112 VPWR VGND sg13g2_fill_1
XFILLER_10_123 VPWR VGND sg13g2_decap_8
X_11480_ _11480_/Y _11508_/S0 _23606_/Q _11479_/Y VPWR VGND sg13g2_o21ai_1
X_23466_ _23466_/Q _24196_/CLK _23466_/D fanout2704/X VPWR VGND sg13g2_dfrbpq_1
XFILLER_71_1774 VPWR VGND sg13g2_fill_1
X_20678_ _20678_/Y _23392_/Q _20682_/B VPWR VGND sg13g2_nand2_1
XFILLER_52_1173 VPWR VGND sg13g2_fill_2
XFILLER_6_116 VPWR VGND sg13g2_decap_4
X_22417_ _22417_/Y _22417_/A _22417_/B VPWR VGND sg13g2_nand2_1
XFILLER_109_545 VPWR VGND sg13g2_decap_8
XFILLER_104_1274 VPWR VGND sg13g2_fill_2
X_23397_ _23397_/Q clkload33/A _23397_/D fanout2701/X VPWR VGND sg13g2_dfrbpq_1
XFILLER_100_1138 VPWR VGND sg13g2_decap_8
XFILLER_87_1236 VPWR VGND sg13g2_fill_1
X_13150_ _13153_/B _13520_/A _20166_/B VPWR VGND sg13g2_xnor2_1
X_22348_ _22348_/Y _22348_/A _22350_/B VPWR VGND sg13g2_nand2_1
XFILLER_30_1482 VPWR VGND sg13g2_fill_2
X_12101_ _12102_/B _12034_/Y _19373_/A VPWR VGND sg13g2_nand2b_1
X_13081_ _13081_/Y _13081_/A _13081_/B VPWR VGND sg13g2_nand2_1
X_22279_ _22279_/Y _22279_/A _22285_/B VPWR VGND sg13g2_nand2_1
X_12032_ _12032_/Y _12032_/A _12032_/B _12032_/C _12032_/D VPWR VGND sg13g2_nor4_2
XFILLER_88_89 VPWR VGND sg13g2_decap_4
X_24018_ _24018_/Q _24210_/CLK _24018_/D fanout2623/X VPWR VGND sg13g2_dfrbpq_1
XFILLER_77_101 VPWR VGND sg13g2_decap_8
XFILLER_105_795 VPWR VGND sg13g2_decap_4
XFILLER_77_112 VPWR VGND sg13g2_fill_1
XFILLER_104_294 VPWR VGND sg13g2_fill_1
X_16840_ _16841_/B _22680_/Q _22679_/Q _16844_/D VPWR VGND sg13g2_nand3_1
X_16771_ _16772_/B _22670_/Q _16771_/B VPWR VGND sg13g2_xnor2_1
XFILLER_93_638 VPWR VGND sg13g2_decap_4
XFILLER_19_724 VPWR VGND sg13g2_decap_8
XFILLER_24_1264 VPWR VGND sg13g2_decap_8
XFILLER_46_510 VPWR VGND sg13g2_decap_8
XFILLER_59_893 VPWR VGND sg13g2_decap_8
X_13983_ _13983_/X _23732_/Q _23764_/Q _23796_/Q _23828_/Q _13983_/S0 _13983_/S1 VPWR
+ VGND sg13g2_mux4_1
XFILLER_20_1106 VPWR VGND sg13g2_decap_4
X_15722_ _15726_/A _22896_/Q _15825_/B VPWR VGND sg13g2_nand2_1
XFILLER_78_1928 VPWR VGND sg13g2_decap_8
X_12934_ _12939_/B _12934_/A _20087_/B _12936_/C _14053_/C VPWR VGND sg13g2_nand4_1
XFILLER_46_554 VPWR VGND sg13g2_decap_8
X_18441_ _18441_/Y _18564_/A1 _18435_/X _18440_/Y VPWR VGND sg13g2_a21oi_1
X_15653_ _15653_/X _17130_/A _22465_/Q _15694_/S VPWR VGND sg13g2_mux2_1
XFILLER_2_1082 VPWR VGND sg13g2_fill_2
X_14604_ _14604_/Y _14604_/A VPWR VGND sg13g2_inv_1
XFILLER_61_546 VPWR VGND sg13g2_decap_4
X_11816_ _11816_/Y _12119_/A _11815_/X _13191_/B1 VPWR VGND sg13g2_o21ai_1
X_18372_ _18380_/B _17962_/B _18784_/B _18463_/S VPWR VGND sg13g2_mux2_1
X_15584_ _19984_/A _15584_/A _15584_/B _15584_/C _15584_/D VPWR VGND sg13g2_nand4_1
X_12796_ _12796_/Y _12778_/X _12783_/Y _12795_/Y _12792_/Y VPWR VGND sg13g2_a22oi_1
XFILLER_76_1696 VPWR VGND sg13g2_decap_8
XFILLER_14_462 VPWR VGND sg13g2_decap_4
XFILLER_42_771 VPWR VGND sg13g2_decap_8
X_14535_ _18780_/S _18616_/D _18742_/A _14535_/C VPWR VGND sg13g2_nand3_1
X_11747_ _11747_/Y _11752_/B _23576_/Q _11746_/Y VPWR VGND sg13g2_o21ai_1
XFILLER_37_1669 VPWR VGND sg13g2_decap_4
XFILLER_18_1057 VPWR VGND sg13g2_decap_8
XFILLER_53_92 VPWR VGND sg13g2_decap_4
Xcore_wrap_4569 instr_addr_o[1] VPWR VGND sg13g2_tielo
XFILLER_30_944 VPWR VGND sg13g2_decap_4
XFILLER_30_966 VPWR VGND sg13g2_fill_2
Xplace3208 _19857_/B _20190_/S VPWR VGND sg13g2_buf_1
XFILLER_15_1934 VPWR VGND sg13g2_decap_8
X_14466_ _14466_/X _24225_/Q _23046_/Q _23047_/Q VPWR VGND sg13g2_and3_1
Xplace3219 _22444_/B _22450_/B VPWR VGND sg13g2_buf_1
X_16205_ _16205_/Y _16205_/A _16205_/B VPWR VGND sg13g2_nand2_1
XFILLER_102_1926 VPWR VGND sg13g2_decap_8
XFILLER_31_1235 VPWR VGND sg13g2_decap_8
X_13417_ _13417_/X _23436_/Q _23468_/Q _23500_/Q _23532_/Q _13586_/A1 _13686_/A VPWR
+ VGND sg13g2_mux4_1
X_17185_ _17186_/B _17185_/A _17195_/A _17218_/B VPWR VGND sg13g2_nor3_1
X_14397_ _14397_/Y _14378_/Y _14324_/Y _14396_/Y VPWR VGND sg13g2_o21ai_1
XFILLER_31_1268 VPWR VGND sg13g2_decap_8
X_16136_ _16136_/Y _16136_/A _16197_/B VPWR VGND sg13g2_nor2_1
XFILLER_115_537 VPWR VGND sg13g2_decap_8
XFILLER_5_160 VPWR VGND sg13g2_decap_8
XFILLER_48_1721 VPWR VGND sg13g2_fill_2
X_16067_ _16067_/Y _16067_/A _16071_/B VPWR VGND sg13g2_nor2_1
XFILLER_87_1792 VPWR VGND sg13g2_decap_4
XFILLER_83_1634 VPWR VGND sg13g2_fill_2
XFILLER_64_1011 VPWR VGND sg13g2_decap_8
X_15018_ _15019_/B _17900_/A1 _15107_/A2 _15070_/B VPWR VGND sg13g2_o21ai_1
XFILLER_64_1022 VPWR VGND sg13g2_fill_2
XFILLER_29_1175 VPWR VGND sg13g2_decap_8
X_19826_ _20058_/B _19638_/X _19651_/Y _19869_/A VPWR VGND sg13g2_mux2_1
XFILLER_110_231 VPWR VGND sg13g2_decap_4
Xfanout2870 fanout2870/X fanout2873/X VPWR VGND sg13g2_buf_1
XFILLER_68_145 VPWR VGND sg13g2_fill_1
XFILLER_111_765 VPWR VGND sg13g2_decap_8
Xfanout2881 fanout2881/X fanout2882/X VPWR VGND sg13g2_buf_1
XFILLER_84_605 VPWR VGND sg13g2_decap_4
Xfanout2892 fanout2892/X fanout2894/X VPWR VGND sg13g2_buf_1
XFILLER_84_616 VPWR VGND sg13g2_fill_2
XFILLER_42_1342 VPWR VGND sg13g2_decap_8
X_19757_ _19757_/Y _19757_/A _19757_/B _19757_/C VPWR VGND sg13g2_nand3_1
XFILLER_22_1938 VPWR VGND sg13g2_decap_8
X_16969_ _16970_/B _22703_/Q _22702_/Q _16975_/A VPWR VGND sg13g2_nand3_1
XFILLER_37_532 VPWR VGND sg13g2_fill_2
X_18708_ _18708_/Y _18708_/A _18708_/B VPWR VGND sg13g2_nand2_1
X_19688_ _19688_/Y _20329_/B2 _19678_/Y _19687_/Y VPWR VGND sg13g2_a21oi_1
XFILLER_0_1701 VPWR VGND sg13g2_decap_4
XFILLER_37_554 VPWR VGND sg13g2_fill_1
XFILLER_92_660 VPWR VGND sg13g2_fill_2
XFILLER_20_1640 VPWR VGND sg13g2_decap_8
XFILLER_64_351 VPWR VGND sg13g2_fill_1
XFILLER_20_1651 VPWR VGND sg13g2_fill_2
XFILLER_37_576 VPWR VGND sg13g2_decap_8
XFILLER_77_1438 VPWR VGND sg13g2_fill_2
XFILLER_25_727 VPWR VGND sg13g2_decap_4
XFILLER_92_682 VPWR VGND sg13g2_decap_8
XFILLER_92_693 VPWR VGND sg13g2_fill_2
XFILLER_52_546 VPWR VGND sg13g2_fill_1
XFILLER_80_866 VPWR VGND sg13g2_fill_1
XFILLER_0_1789 VPWR VGND sg13g2_decap_4
XFILLER_55_1725 VPWR VGND sg13g2_fill_2
XFILLER_75_1151 VPWR VGND sg13g2_fill_2
XFILLER_55_1736 VPWR VGND sg13g2_decap_4
XFILLER_90_1638 VPWR VGND sg13g2_fill_1
X_20601_ _23355_/D _22403_/A1 _20600_/B _20600_/Y VPWR VGND sg13g2_o21ai_1
X_21581_ _21581_/Y _23806_/Q _21581_/B VPWR VGND sg13g2_nand2_1
XFILLER_36_1168 VPWR VGND sg13g2_decap_8
X_23320_ _23320_/Q clkload56/A _23320_/D fanout2747/X VPWR VGND sg13g2_dfrbpq_1
Xrebuffer5411 _16302_/A1 rebuffer5425/X VPWR VGND sg13g2_buf_1
X_20532_ _23322_/D _22401_/A1 _20533_/B _20531_/Y VPWR VGND sg13g2_o21ai_1
Xrebuffer5422 _19325_/B _11592_/A VPWR VGND sg13g2_buf_1
Xrebuffer5433 _12001_/C _12084_/D VPWR VGND sg13g2_buf_1
Xplace3720 _16781_/A _12350_/B VPWR VGND sg13g2_buf_1
XFILLER_21_999 VPWR VGND sg13g2_decap_8
XFILLER_105_1572 VPWR VGND sg13g2_fill_2
XFILLER_101_1403 VPWR VGND sg13g2_fill_1
X_23251_ _23251_/Q clkload50/A _23251_/D fanout2662/X VPWR VGND sg13g2_dfrbpq_1
XFILLER_88_1512 VPWR VGND sg13g2_fill_2
Xplace3731 _20319_/B _20304_/B VPWR VGND sg13g2_buf_1
Xrebuffer5455 _14032_/A _13290_/X VPWR VGND sg13g2_buf_8
X_20463_ _23293_/D _21178_/A1 _20464_/B _20462_/Y VPWR VGND sg13g2_o21ai_1
Xplace3742 _19423_/B _19460_/B VPWR VGND sg13g2_buf_1
Xrebuffer5466 place4008/A _11346_/Y VPWR VGND sg13g2_buf_8
XFILLER_10_1308 VPWR VGND sg13g2_decap_8
Xplace3753 _17621_/B _14756_/Y VPWR VGND sg13g2_buf_1
Xrebuffer5477 _11574_/B1 _11559_/Y VPWR VGND sg13g2_buf_1
XFILLER_4_609 VPWR VGND sg13g2_fill_2
Xrebuffer5488 _13753_/B _13856_/D VPWR VGND sg13g2_buf_1
Xplace3764 _12837_/A _12951_/A VPWR VGND sg13g2_buf_1
X_22202_ _24090_/D _22268_/A1 _22203_/B _22201_/Y VPWR VGND sg13g2_o21ai_1
Xplace3775 _15165_/B _14634_/B VPWR VGND sg13g2_buf_1
Xhold5101 _22205_/A _24092_/Q VPWR VGND sg13g2_dlygate4sd3_1
Xhold5112 _20614_/A _23361_/Q VPWR VGND sg13g2_dlygate4sd3_1
Xrebuffer5499 _11239_/A2 _11219_/Y VPWR VGND sg13g2_buf_1
Xplace3786 _14028_/B _11983_/A VPWR VGND sg13g2_buf_1
X_20394_ _23261_/D _22407_/A1 _20395_/B _20393_/Y VPWR VGND sg13g2_o21ai_1
X_23182_ _23182_/Q clkload17/A _23182_/D fanout2848/X VPWR VGND sg13g2_dfrbpq_1
Xhold5123 _21835_/A _23915_/Q VPWR VGND sg13g2_dlygate4sd3_1
Xhold5134 _22215_/A _24096_/Q VPWR VGND sg13g2_dlygate4sd3_1
Xplace3797 _19978_/B _20117_/C VPWR VGND sg13g2_buf_1
Xhold5145 _17487_/A _22860_/Q VPWR VGND sg13g2_dlygate4sd3_1
XFILLER_49_1529 VPWR VGND sg13g2_fill_1
X_22133_ _24057_/D _22266_/A1 _22136_/B _22132_/Y VPWR VGND sg13g2_o21ai_1
Xhold5156 _21339_/A _23691_/Q VPWR VGND sg13g2_dlygate4sd3_1
XFILLER_106_559 VPWR VGND sg13g2_decap_8
Xhold5167 _22293_/A _24134_/Q VPWR VGND sg13g2_dlygate4sd3_1
Xhold5178 _20496_/A _23308_/Q VPWR VGND sg13g2_dlygate4sd3_1
XFILLER_82_1111 VPWR VGND sg13g2_fill_2
Xhold5189 _22149_/A _24065_/Q VPWR VGND sg13g2_dlygate4sd3_1
XFILLER_27_1805 VPWR VGND sg13g2_fill_2
XFILLER_102_710 VPWR VGND sg13g2_decap_8
XFILLER_114_592 VPWR VGND sg13g2_decap_8
XFILLER_82_1166 VPWR VGND sg13g2_fill_2
XFILLER_59_134 VPWR VGND sg13g2_decap_8
XFILLER_88_977 VPWR VGND sg13g2_fill_1
XFILLER_87_465 VPWR VGND sg13g2_decap_8
XFILLER_114_21 VPWR VGND sg13g2_decap_8
XFILLER_60_1442 VPWR VGND sg13g2_fill_1
XFILLER_5_1634 VPWR VGND sg13g2_decap_4
XFILLER_47_329 VPWR VGND sg13g2_decap_8
XFILLER_99_1630 VPWR VGND sg13g2_fill_1
XFILLER_25_1595 VPWR VGND sg13g2_decap_8
XFILLER_28_532 VPWR VGND sg13g2_decap_8
XFILLER_74_36 VPWR VGND sg13g2_decap_8
XFILLER_114_98 VPWR VGND sg13g2_decap_8
XFILLER_99_1674 VPWR VGND sg13g2_fill_1
X_22966_ _22966_/Q clkload16/A _22966_/D fanout2920/X VPWR VGND sg13g2_dfrbpq_1
XFILLER_71_800 VPWR VGND sg13g2_decap_4
XFILLER_56_896 VPWR VGND sg13g2_fill_2
XFILLER_16_738 VPWR VGND sg13g2_decap_8
X_21917_ _23956_/D _22317_/A1 _21916_/B _21916_/Y VPWR VGND sg13g2_o21ai_1
XFILLER_15_226 VPWR VGND sg13g2_decap_8
X_22897_ _22897_/Q clkload9/A _22897_/D fanout2812/X VPWR VGND sg13g2_dfrbpq_1
XFILLER_38_1901 VPWR VGND sg13g2_fill_2
XFILLER_82_181 VPWR VGND sg13g2_decap_8
XFILLER_15_237 VPWR VGND sg13g2_fill_1
XFILLER_71_855 VPWR VGND sg13g2_fill_2
XFILLER_19_1300 VPWR VGND sg13g2_fill_1
X_12650_ _12650_/X _23842_/Q _23874_/Q _23938_/Q _23970_/Q _12909_/B _13006_/S1 VPWR
+ VGND sg13g2_mux4_1
X_21848_ _21848_/Y _21848_/A _21848_/B VPWR VGND sg13g2_nor2_1
XFILLER_70_365 VPWR VGND sg13g2_fill_2
XFILLER_19_1333 VPWR VGND sg13g2_decap_8
Xinput4354 _17873_/A1 boot_addr_i[12] VPWR VGND sg13g2_buf_1
XFILLER_93_1273 VPWR VGND sg13g2_fill_1
Xinput4365 _17905_/A1 boot_addr_i[23] VPWR VGND sg13g2_buf_1
XFILLER_19_1355 VPWR VGND sg13g2_decap_8
Xinput4376 _19266_/A data_err_i VPWR VGND sg13g2_buf_1
X_12581_ _12582_/B _12574_/X _13271_/A _12580_/X VPWR VGND sg13g2_o21ai_1
XFILLER_19_1366 VPWR VGND sg13g2_fill_2
XFILLER_12_944 VPWR VGND sg13g2_decap_8
Xinput4387 _20278_/A3 data_rdata_i[18] VPWR VGND sg13g2_buf_1
X_21779_ _21779_/Y _21779_/A _21779_/B VPWR VGND sg13g2_nand2_1
XFILLER_90_68 VPWR VGND sg13g2_decap_8
XFILLER_15_1208 VPWR VGND sg13g2_decap_8
Xinput4398 _20310_/A0 data_rdata_i[28] VPWR VGND sg13g2_buf_1
X_11532_ _11532_/X _23573_/Q _23605_/Q _23637_/Q _23669_/Q _11923_/S0 _12171_/S1 VPWR
+ VGND sg13g2_mux4_1
X_23518_ _23518_/Q clkload55/A _23518_/D fanout2777/X VPWR VGND sg13g2_dfrbpq_1
XFILLER_7_403 VPWR VGND sg13g2_decap_4
XFILLER_12_988 VPWR VGND sg13g2_fill_2
XFILLER_36_1691 VPWR VGND sg13g2_decap_8
X_23449_ _23449_/Q clkload53/A _23449_/D fanout2782/X VPWR VGND sg13g2_dfrbpq_1
X_11463_ _11464_/A _11461_/X _11462_/X _12889_/A VPWR VGND sg13g2_mux2_1
XFILLER_109_342 VPWR VGND sg13g2_fill_2
X_13202_ _13203_/B _23785_/Q _23945_/Q _13796_/B VPWR VGND sg13g2_mux2_1
XFILLER_87_1044 VPWR VGND sg13g2_decap_8
XFILLER_99_77 VPWR VGND sg13g2_decap_8
XFILLER_99_88 VPWR VGND sg13g2_fill_2
X_13133_ _13136_/C _13133_/A _13641_/A _13133_/C VPWR VGND sg13g2_nor3_1
X_18990_ _18991_/C _23056_/Q _19045_/B _19042_/S VPWR VGND sg13g2_or3_1
XFILLER_10_1886 VPWR VGND sg13g2_decap_8
XFILLER_84_1954 VPWR VGND sg13g2_fill_1
X_17941_ _17941_/Y _18016_/S _17941_/B VPWR VGND sg13g2_nand2b_1
X_13064_ _13065_/D _13434_/A _13072_/A _15714_/A VPWR VGND sg13g2_or3_1
XFILLER_78_421 VPWR VGND sg13g2_decap_8
X_12015_ _12015_/X _23259_/Q _23387_/Q _12015_/S VPWR VGND sg13g2_mux2_1
XFILLER_6_1409 VPWR VGND sg13g2_fill_1
XFILLER_2_196 VPWR VGND sg13g2_decap_8
X_17872_ _17872_/Y _17872_/A _17917_/B VPWR VGND sg13g2_nor2_1
XFILLER_79_999 VPWR VGND sg13g2_decap_8
X_19611_ _19612_/D _19611_/A _20334_/B VPWR VGND sg13g2_nor2_1
XFILLER_65_104 VPWR VGND sg13g2_decap_8
X_16823_ _22676_/D _16175_/A _16774_/Y _16822_/Y VPWR VGND sg13g2_o21ai_1
XFILLER_19_510 VPWR VGND sg13g2_decap_8
XFILLER_17_7 VPWR VGND sg13g2_fill_1
XFILLER_48_81 VPWR VGND sg13g2_fill_1
XFILLER_47_830 VPWR VGND sg13g2_decap_8
XFILLER_78_1703 VPWR VGND sg13g2_fill_2
X_19542_ _19542_/Y _19986_/A _19824_/B _19541_/Y VPWR VGND sg13g2_o21ai_1
X_16754_ _16755_/B _22666_/Q _16754_/B VPWR VGND sg13g2_xnor2_1
XFILLER_19_554 VPWR VGND sg13g2_decap_8
X_13966_ _13966_/Y _13965_/X _13966_/B VPWR VGND sg13g2_nand2b_1
X_12917_ _12917_/Y _12921_/S _23909_/Q _12916_/Y VPWR VGND sg13g2_o21ai_1
X_15705_ _15706_/B _22701_/Q _15946_/A2 _15946_/B1 _22637_/Q VPWR VGND sg13g2_a22oi_1
XFILLER_74_682 VPWR VGND sg13g2_decap_4
X_19473_ _19545_/C _20355_/A _19320_/C _14099_/Y VPWR VGND sg13g2_o21ai_1
X_13897_ _13897_/X _23603_/Q _23635_/Q _23667_/Q _23699_/Q _13900_/S0 _13900_/S1 VPWR
+ VGND sg13g2_mux4_1
XFILLER_0_77 VPWR VGND sg13g2_decap_8
XFILLER_59_1146 VPWR VGND sg13g2_fill_1
XFILLER_0_88 VPWR VGND sg13g2_fill_1
XFILLER_73_181 VPWR VGND sg13g2_fill_2
XFILLER_62_855 VPWR VGND sg13g2_fill_2
XFILLER_73_192 VPWR VGND sg13g2_decap_8
X_18424_ _18424_/Y _18425_/A _18423_/Y _18385_/A VPWR VGND sg13g2_a21oi_1
X_15636_ _16117_/A _23012_/Q _22562_/Q _15982_/S VPWR VGND sg13g2_mux2_1
X_18355_ _18355_/Y _18355_/A _18355_/B VPWR VGND sg13g2_nor2_1
X_15567_ _15567_/X _17107_/A _22461_/Q _15589_/S VPWR VGND sg13g2_mux2_1
X_12779_ _12779_/X _23716_/Q _23780_/Q _23844_/Q _23940_/Q _12877_/B _12498_/S VPWR
+ VGND sg13g2_mux4_1
XFILLER_9_64 VPWR VGND sg13g2_decap_8
X_14518_ _14519_/D _14518_/A _14518_/B _14518_/C _14518_/D VPWR VGND sg13g2_nand4_1
XFILLER_15_1720 VPWR VGND sg13g2_decap_8
X_15498_ _15498_/Y _22724_/Q _15307_/B _16681_/B _22660_/Q VPWR VGND sg13g2_a22oi_1
Xplace3005 _22359_/B _22374_/B VPWR VGND sg13g2_buf_1
X_18286_ _18286_/Y _18286_/A _18286_/B VPWR VGND sg13g2_nor2_1
Xplace3016 _22300_/B _22316_/B VPWR VGND sg13g2_buf_1
Xplace3027 _22136_/B _22129_/B VPWR VGND sg13g2_buf_1
XFILLER_31_1021 VPWR VGND sg13g2_fill_1
XFILLER_106_1881 VPWR VGND sg13g2_decap_8
XFILLER_102_1712 VPWR VGND sg13g2_decap_8
X_14449_ _14450_/D _24219_/Q _14449_/B VPWR VGND sg13g2_and2_1
Xplace3038 _22101_/B _22075_/B VPWR VGND sg13g2_buf_1
Xplace3049 _22025_/B _22045_/B VPWR VGND sg13g2_buf_1
X_17168_ _17168_/Y _22737_/Q _17226_/B VPWR VGND sg13g2_xnor2_1
XFILLER_115_301 VPWR VGND sg13g2_decap_8
XFILLER_31_1076 VPWR VGND sg13g2_decap_8
XFILLER_50_1699 VPWR VGND sg13g2_fill_1
XFILLER_85_1729 VPWR VGND sg13g2_decap_8
X_16119_ _16119_/Y _17881_/A _16119_/B VPWR VGND sg13g2_nor2_1
X_17099_ _22724_/D _17227_/B _17097_/Y _17098_/Y VPWR VGND sg13g2_a21o_1
XFILLER_89_708 VPWR VGND sg13g2_decap_8
XFILLER_43_0 VPWR VGND sg13g2_decap_8
XFILLER_83_1431 VPWR VGND sg13g2_fill_1
XFILLER_97_741 VPWR VGND sg13g2_decap_8
XFILLER_44_1426 VPWR VGND sg13g2_decap_4
XFILLER_83_1486 VPWR VGND sg13g2_decap_8
XFILLER_9_1044 VPWR VGND sg13g2_decap_8
XFILLER_6_1910 VPWR VGND sg13g2_decap_8
XFILLER_9_1077 VPWR VGND sg13g2_decap_8
XFILLER_111_562 VPWR VGND sg13g2_decap_8
X_19809_ _19809_/Y _23210_/Q _19881_/A2 _19881_/B1 _23202_/Q VPWR VGND sg13g2_a22oi_1
XFILLER_26_1871 VPWR VGND sg13g2_fill_2
XFILLER_29_318 VPWR VGND sg13g2_fill_1
XFILLER_61_1751 VPWR VGND sg13g2_decap_8
XFILLER_6_1954 VPWR VGND sg13g2_fill_1
XFILLER_57_649 VPWR VGND sg13g2_fill_1
XFILLER_84_446 VPWR VGND sg13g2_decap_8
XFILLER_42_1172 VPWR VGND sg13g2_decap_4
X_22820_ _22820_/Q clkload18/A _22820_/D fanout2828/X VPWR VGND sg13g2_dfrbpq_1
XFILLER_22_1768 VPWR VGND sg13g2_decap_8
XFILLER_37_340 VPWR VGND sg13g2_fill_1
XFILLER_113_1885 VPWR VGND sg13g2_decap_8
XFILLER_77_1213 VPWR VGND sg13g2_decap_4
XFILLER_71_107 VPWR VGND sg13g2_fill_1
X_22751_ _22751_/Q clkload24/A _22751_/D fanout2898/X VPWR VGND sg13g2_dfrbpq_1
XFILLER_77_1246 VPWR VGND sg13g2_decap_8
XFILLER_53_877 VPWR VGND sg13g2_decap_8
X_22682_ _22682_/Q clkload21/A _22682_/D fanout2866/X VPWR VGND sg13g2_dfrbpq_1
XFILLER_0_1575 VPWR VGND sg13g2_fill_1
XFILLER_40_527 VPWR VGND sg13g2_decap_8
X_21633_ _21633_/Y _21633_/A _21635_/B VPWR VGND sg13g2_nand2_1
XFILLER_55_1577 VPWR VGND sg13g2_fill_1
XFILLER_100_56 VPWR VGND sg13g2_decap_8
XFILLER_60_16 VPWR VGND sg13g2_decap_8
X_21564_ _21564_/Y _21564_/A _21574_/B VPWR VGND sg13g2_nand2_1
XFILLER_21_774 VPWR VGND sg13g2_decap_8
XFILLER_72_1880 VPWR VGND sg13g2_decap_8
XFILLER_107_1689 VPWR VGND sg13g2_decap_8
XFILLER_72_1891 VPWR VGND sg13g2_fill_2
Xplace4240 _11423_/B _12285_/A VPWR VGND sg13g2_buf_2
X_23303_ _23303_/Q clkload35/A _23303_/D fanout2632/X VPWR VGND sg13g2_dfrbpq_1
XFILLER_14_1230 VPWR VGND sg13g2_decap_8
XFILLER_21_796 VPWR VGND sg13g2_decap_8
Xplace4251 _13004_/S1 _13042_/A VPWR VGND sg13g2_buf_1
Xrebuffer5230 _12585_/B2 _12582_/Y VPWR VGND sg13g2_buf_8
Xplace4262 _11920_/C1 _11390_/A VPWR VGND sg13g2_buf_1
Xrebuffer5241 _11554_/B1 _11329_/A VPWR VGND sg13g2_buf_1
Xplace4273 _13578_/S0 _13236_/S0 VPWR VGND sg13g2_buf_1
Xrebuffer5252 _13363_/A2 _20197_/B VPWR VGND sg13g2_buf_1
Xplace4284 _13773_/S0 _13910_/S VPWR VGND sg13g2_buf_4
Xrebuffer5263 _12033_/B _12032_/Y VPWR VGND sg13g2_buf_8
Xplace3550 _15684_/B _15296_/Y VPWR VGND sg13g2_buf_1
XFILLER_109_21 VPWR VGND sg13g2_decap_8
Xplace4295 _11919_/S _12062_/A VPWR VGND sg13g2_buf_4
Xrebuffer5274 _19211_/A0 _12614_/Y VPWR VGND sg13g2_buf_8
Xplace3561 _14729_/S _19611_/A VPWR VGND sg13g2_buf_1
X_23234_ _23234_/Q clkload41/A _23234_/D fanout2703/X VPWR VGND sg13g2_dfrbpq_1
Xrebuffer5285 _15009_/B2 _13225_/Y VPWR VGND sg13g2_buf_8
Xplace3572 _20033_/A1 _20092_/A2 VPWR VGND sg13g2_buf_1
X_20446_ _23285_/D _22390_/A1 _20451_/B _20445_/Y VPWR VGND sg13g2_o21ai_1
Xrebuffer5296 _12900_/B2 _12897_/Y VPWR VGND sg13g2_buf_8
Xplace3583 _20080_/A _20030_/S VPWR VGND sg13g2_buf_1
XFILLER_88_1353 VPWR VGND sg13g2_fill_2
XFILLER_14_1296 VPWR VGND sg13g2_decap_8
XFILLER_4_428 VPWR VGND sg13g2_decap_8
XFILLER_68_1927 VPWR VGND sg13g2_decap_8
Xplace3594 _19986_/A _19762_/A VPWR VGND sg13g2_buf_1
Xrebuffer4573 _15116_/B2 _13996_/Y VPWR VGND sg13g2_buf_8
XFILLER_101_1277 VPWR VGND sg13g2_decap_4
Xrebuffer4584 _13070_/B _13012_/B VPWR VGND sg13g2_buf_2
X_23165_ _23165_/Q clkload15/A _23165_/D fanout2857/X VPWR VGND sg13g2_dfrbpq_1
Xrebuffer4595 _14950_/B2 _12769_/Y VPWR VGND sg13g2_buf_8
X_20377_ _23253_/D _22390_/A1 _20380_/B _20376_/Y VPWR VGND sg13g2_o21ai_1
XFILLER_109_98 VPWR VGND sg13g2_decap_8
XFILLER_101_1299 VPWR VGND sg13g2_decap_8
XFILLER_84_1239 VPWR VGND sg13g2_decap_8
X_22116_ _24051_/D _24051_/Q _22449_/A1 _22116_/S VPWR VGND sg13g2_mux2_1
X_23096_ _23096_/Q clkload14/A _23096_/D fanout2842/X VPWR VGND sg13g2_dfrbpq_1
XFILLER_0_645 VPWR VGND sg13g2_decap_4
XFILLER_102_540 VPWR VGND sg13g2_decap_8
X_22047_ _24019_/D _22315_/A0 _24019_/Q _22047_/S VPWR VGND sg13g2_mux2_1
XFILLER_47_1083 VPWR VGND sg13g2_fill_2
XFILLER_76_903 VPWR VGND sg13g2_decap_4
XFILLER_87_251 VPWR VGND sg13g2_decap_8
XFILLER_85_13 VPWR VGND sg13g2_fill_1
XFILLER_27_1668 VPWR VGND sg13g2_decap_8
XFILLER_88_785 VPWR VGND sg13g2_fill_1
XFILLER_88_796 VPWR VGND sg13g2_decap_8
XFILLER_76_947 VPWR VGND sg13g2_decap_8
XFILLER_91_906 VPWR VGND sg13g2_decap_8
X_13820_ _13820_/X _23602_/Q _23634_/Q _23666_/Q _23698_/Q _13173_/S _11390_/A VPWR
+ VGND sg13g2_mux4_1
XFILLER_112_1340 VPWR VGND sg13g2_fill_2
XFILLER_25_1392 VPWR VGND sg13g2_decap_8
XFILLER_47_159 VPWR VGND sg13g2_decap_8
XFILLER_90_405 VPWR VGND sg13g2_decap_8
XFILLER_28_351 VPWR VGND sg13g2_fill_2
X_23998_ _23998_/Q clkload44/A _23998_/D fanout2750/X VPWR VGND sg13g2_dfrbpq_1
XFILLER_112_1384 VPWR VGND sg13g2_decap_8
X_13751_ _13751_/Y _14004_/B _13753_/A _13947_/A VPWR VGND sg13g2_nand3_1
XFILLER_16_524 VPWR VGND sg13g2_decap_8
X_22949_ _22949_/Q _23187_/CLK _22949_/D fanout2917/X VPWR VGND sg13g2_dfrbpq_1
XFILLER_83_490 VPWR VGND sg13g2_decap_8
X_16470_ _16470_/Y _22598_/Q _16470_/B VPWR VGND sg13g2_nand2_1
XFILLER_43_354 VPWR VGND sg13g2_decap_4
X_13682_ _13692_/C _13675_/Y _13678_/Y _13681_/X _11363_/B VPWR VGND sg13g2_a22oi_1
X_15421_ _15435_/A _22883_/Q _15182_/X _17835_/A _22915_/Q VPWR VGND sg13g2_a22oi_1
X_12633_ _12633_/Y _12623_/X _12627_/Y _12630_/Y _12638_/C _12632_/Y VPWR VGND sg13g2_a221oi_1
XFILLER_38_1764 VPWR VGND sg13g2_fill_2
XFILLER_54_1032 VPWR VGND sg13g2_decap_8
XFILLER_34_1639 VPWR VGND sg13g2_decap_8
X_18140_ _18140_/Y _18140_/A _18140_/B VPWR VGND sg13g2_nand2_1
XFILLER_19_1185 VPWR VGND sg13g2_decap_4
XFILLER_54_1098 VPWR VGND sg13g2_fill_1
X_11515_ _11515_/X _23573_/Q _23605_/Q _23637_/Q _23669_/Q _12028_/A _12006_/S1 VPWR
+ VGND sg13g2_mux4_1
XFILLER_12_1904 VPWR VGND sg13g2_decap_8
X_18071_ _18071_/Y _18071_/A _18174_/B VPWR VGND sg13g2_nand2_1
XFILLER_51_1953 VPWR VGND sg13g2_fill_2
X_15283_ _15296_/B _16789_/A _15307_/A _15283_/C VPWR VGND sg13g2_nand3_1
XFILLER_71_1390 VPWR VGND sg13g2_decap_4
X_12495_ _12505_/D _12730_/S _12492_/Y _12494_/Y VPWR VGND sg13g2_a21oi_1
X_17022_ _22713_/D _16946_/S _17020_/Y _17021_/Y VPWR VGND sg13g2_o21ai_1
XFILLER_7_277 VPWR VGND sg13g2_decap_8
X_11446_ _11446_/X _22947_/Q _22972_/Q _12471_/B VPWR VGND sg13g2_mux2_1
XFILLER_109_161 VPWR VGND sg13g2_decap_8
XFILLER_32_1396 VPWR VGND sg13g2_decap_8
X_14165_ _14166_/B _22583_/Q _14758_/B VPWR VGND sg13g2_nand2_1
XFILLER_4_951 VPWR VGND sg13g2_fill_1
X_11377_ _11915_/S _11377_/A VPWR VGND sg13g2_inv_2
XFILLER_4_962 VPWR VGND sg13g2_decap_8
XFILLER_113_827 VPWR VGND sg13g2_decap_8
X_13116_ _13116_/Y _13770_/A _13113_/X _13115_/X VPWR VGND sg13g2_a21oi_1
XFILLER_10_1694 VPWR VGND sg13g2_fill_2
XFILLER_112_326 VPWR VGND sg13g2_decap_8
X_18973_ _18975_/B _19039_/B _18973_/B VPWR VGND sg13g2_nand2_1
X_14096_ _19545_/A _14096_/A _14433_/B VPWR VGND sg13g2_and2_1
XFILLER_79_730 VPWR VGND sg13g2_decap_8
XFILLER_26_1112 VPWR VGND sg13g2_decap_8
X_17924_ _17925_/B _17924_/A1 _17926_/A2 _17929_/B1 _17215_/A VPWR VGND sg13g2_a22oi_1
X_13047_ _13055_/C _14129_/A _13043_/Y _13046_/X _12048_/A VPWR VGND sg13g2_a22oi_1
XFILLER_67_903 VPWR VGND sg13g2_fill_1
XFILLER_65_1194 VPWR VGND sg13g2_fill_2
XFILLER_80_1659 VPWR VGND sg13g2_fill_2
XFILLER_79_785 VPWR VGND sg13g2_decap_4
X_17855_ _17927_/B _17855_/A _17855_/B VPWR VGND sg13g2_nor2_1
XFILLER_67_969 VPWR VGND sg13g2_decap_8
XFILLER_93_232 VPWR VGND sg13g2_decap_4
X_16806_ _16812_/A _22673_/Q VPWR VGND sg13g2_inv_1
XFILLER_94_788 VPWR VGND sg13g2_fill_1
X_17786_ _17786_/Y _23182_/Q _17801_/A2 _17822_/B1 _22990_/Q VPWR VGND sg13g2_a22oi_1
X_14998_ _14999_/C _22501_/Q _14998_/B VPWR VGND sg13g2_nand2_1
XFILLER_93_276 VPWR VGND sg13g2_fill_2
XFILLER_35_822 VPWR VGND sg13g2_fill_2
X_19525_ _19525_/Y _19525_/A _19525_/B VPWR VGND sg13g2_nand2_1
X_16737_ _16737_/Y _16755_/A _16737_/B VPWR VGND sg13g2_nor2_1
X_13949_ _13950_/D _13753_/B _13949_/B _13949_/C VPWR VGND sg13g2_nand3b_1
XFILLER_35_866 VPWR VGND sg13g2_fill_2
X_19456_ _19456_/Y _19456_/A _19463_/S VPWR VGND sg13g2_nand2_1
X_16668_ _16669_/B _22649_/Q _16668_/B VPWR VGND sg13g2_xnor2_1
XFILLER_1_1895 VPWR VGND sg13g2_decap_8
X_18407_ _18407_/Y _18344_/B _18403_/Y _18406_/Y VPWR VGND sg13g2_o21ai_1
XFILLER_22_538 VPWR VGND sg13g2_decap_8
XFILLER_108_1932 VPWR VGND sg13g2_decap_8
X_19387_ _19534_/B _19587_/A _19483_/A _19386_/X VPWR VGND sg13g2_a21oi_1
X_16599_ _22634_/D _17878_/A _16610_/A _16598_/Y VPWR VGND sg13g2_a21oi_1
X_18338_ _18765_/B _19116_/A1 _23062_/Q _18462_/S VPWR VGND sg13g2_mux2_1
X_18269_ _18269_/Y _18269_/A _18377_/A VPWR VGND sg13g2_nor2_1
X_20300_ _20300_/Y _20300_/A _20300_/B VPWR VGND sg13g2_nand2_1
X_21280_ _23663_/D _21346_/A0 _23663_/Q _21286_/S VPWR VGND sg13g2_mux2_1
X_20231_ _20232_/B _20228_/Y _20287_/B _20230_/Y _20228_/A VPWR VGND sg13g2_a22oi_1
X_20162_ _20162_/Y _20162_/A _20164_/A VPWR VGND sg13g2_nand2_1
XFILLER_115_175 VPWR VGND sg13g2_decap_8
XFILLER_103_348 VPWR VGND sg13g2_decap_8
XFILLER_115_1903 VPWR VGND sg13g2_decap_8
X_20093_ _20094_/C _20112_/B _20177_/A VPWR VGND sg13g2_nand2b_1
Xclkbuf_leaf_44_clk_i clkload29/A clkbuf_leaf_9_clk_i/A VPWR VGND sg13g2_buf_16
X_23921_ _23921_/Q clkload47/A _23921_/D fanout2681/X VPWR VGND sg13g2_dfrbpq_1
XFILLER_58_958 VPWR VGND sg13g2_decap_8
XFILLER_111_381 VPWR VGND sg13g2_fill_1
XFILLER_22_1521 VPWR VGND sg13g2_decap_8
XFILLER_85_766 VPWR VGND sg13g2_fill_2
X_23852_ _23852_/Q clkload49/A _23852_/D fanout2674/X VPWR VGND sg13g2_dfrbpq_1
XFILLER_73_917 VPWR VGND sg13g2_decap_8
XFILLER_6_1784 VPWR VGND sg13g2_decap_8
XFILLER_55_27 VPWR VGND sg13g2_decap_4
XFILLER_44_107 VPWR VGND sg13g2_decap_8
X_22803_ _22803_/Q _22893_/CLK _22803_/D fanout2817/X VPWR VGND sg13g2_dfrbpq_1
XFILLER_37_170 VPWR VGND sg13g2_decap_8
X_23783_ _23783_/Q _24170_/CLK _23783_/D fanout2707/X VPWR VGND sg13g2_dfrbpq_1
Xclkbuf_leaf_59_clk_i _23215_/CLK clkbuf_4_8__f_clk_i/X VPWR VGND sg13g2_buf_16
XFILLER_37_192 VPWR VGND sg13g2_decap_8
XFILLER_53_641 VPWR VGND sg13g2_decap_8
X_22734_ _22734_/Q clkload21/A _22734_/D fanout2868/X VPWR VGND sg13g2_dfrbpq_1
XFILLER_80_471 VPWR VGND sg13g2_decap_8
XFILLER_26_899 VPWR VGND sg13g2_decap_8
XFILLER_38_1049 VPWR VGND sg13g2_decap_8
XFILLER_111_77 VPWR VGND sg13g2_decap_8
X_22665_ _22665_/Q _22733_/CLK _22665_/D fanout2891/X VPWR VGND sg13g2_dfrbpq_1
XFILLER_94_1390 VPWR VGND sg13g2_fill_1
X_21616_ _23824_/D _21616_/A1 _21621_/B _21615_/Y VPWR VGND sg13g2_o21ai_1
X_22596_ _22596_/Q clkload28/A _22596_/D fanout2870/X VPWR VGND sg13g2_dfrbpq_1
XFILLER_21_582 VPWR VGND sg13g2_decap_8
X_21547_ _23790_/D _21974_/A1 _21549_/B _21546_/Y VPWR VGND sg13g2_o21ai_1
Xplace4070 _19043_/A _17992_/S VPWR VGND sg13g2_buf_1
X_11300_ _11300_/Y _12028_/A _11297_/X _11299_/Y VPWR VGND sg13g2_o21ai_1
Xplace4081 _20310_/S0 _20154_/S1 VPWR VGND sg13g2_buf_1
Xplace4092 _19501_/A _19514_/A VPWR VGND sg13g2_buf_1
X_12280_ _12280_/X _23582_/Q _23614_/Q _23646_/Q _23678_/Q _12246_/S _12457_/S1 VPWR
+ VGND sg13g2_mux4_1
X_24266_ _24266_/X _24266_/A VPWR VGND sg13g2_buf_1
XFILLER_68_1702 VPWR VGND sg13g2_decap_8
X_21478_ _23756_/D _21971_/A1 _21483_/B _21477_/Y VPWR VGND sg13g2_o21ai_1
XFILLER_107_632 VPWR VGND sg13g2_decap_8
XFILLER_5_748 VPWR VGND sg13g2_decap_8
Xplace3380 _16654_/B _16575_/C VPWR VGND sg13g2_buf_1
X_23217_ _23217_/Q clkload35/A _23217_/D fanout2933/X VPWR VGND sg13g2_dfrbpq_1
Xplace3391 _17507_/S _17475_/B VPWR VGND sg13g2_buf_1
X_11231_ _14098_/C _11311_/B _22970_/Q _11595_/A VPWR VGND sg13g2_nand3b_1
X_20429_ _20429_/Y _23280_/Q _20429_/B VPWR VGND sg13g2_nand2_1
XFILLER_88_1183 VPWR VGND sg13g2_decap_8
X_24197_ _24197_/Q clkload34/A _24197_/D fanout2700/X VPWR VGND sg13g2_dfrbpq_1
XFILLER_29_1708 VPWR VGND sg13g2_fill_2
XFILLER_101_1085 VPWR VGND sg13g2_decap_8
XFILLER_29_1719 VPWR VGND sg13g2_decap_8
XFILLER_49_1156 VPWR VGND sg13g2_decap_8
XFILLER_68_1779 VPWR VGND sg13g2_decap_8
XFILLER_106_175 VPWR VGND sg13g2_decap_8
X_23148_ _23148_/Q clkload14/A _23148_/D fanout2842/X VPWR VGND sg13g2_dfrbpq_1
XFILLER_84_1058 VPWR VGND sg13g2_decap_8
XFILLER_1_932 VPWR VGND sg13g2_fill_2
XFILLER_27_1410 VPWR VGND sg13g2_fill_2
XFILLER_27_1421 VPWR VGND sg13g2_fill_2
XFILLER_110_808 VPWR VGND sg13g2_decap_8
XFILLER_7_1504 VPWR VGND sg13g2_fill_1
XFILLER_49_903 VPWR VGND sg13g2_fill_1
XFILLER_96_56 VPWR VGND sg13g2_decap_8
XFILLER_95_519 VPWR VGND sg13g2_fill_1
X_23079_ _23079_/Q _23114_/CLK _23079_/D fanout2909/X VPWR VGND sg13g2_dfrbpq_1
X_15970_ _15975_/B _22480_/Q _15970_/A2 _15992_/B1 _22811_/Q VPWR VGND sg13g2_a22oi_1
XFILLER_49_925 VPWR VGND sg13g2_decap_4
XFILLER_23_1307 VPWR VGND sg13g2_decap_8
X_14921_ _14921_/Y _14953_/A _23135_/Q VPWR VGND sg13g2_nand2_1
XFILLER_76_744 VPWR VGND sg13g2_decap_8
XFILLER_48_457 VPWR VGND sg13g2_fill_1
XFILLER_40_1632 VPWR VGND sg13g2_decap_8
X_17640_ _17640_/Y _17710_/A1 _17635_/X _17639_/Y VPWR VGND sg13g2_o21ai_1
X_14852_ _14852_/Y _14852_/A _17540_/A VPWR VGND sg13g2_nor2_1
XFILLER_63_405 VPWR VGND sg13g2_fill_1
XFILLER_75_265 VPWR VGND sg13g2_decap_8
XFILLER_5_1294 VPWR VGND sg13g2_fill_2
XFILLER_57_991 VPWR VGND sg13g2_fill_1
X_13803_ _13867_/B _14342_/A _14704_/A VPWR VGND sg13g2_and2_1
XFILLER_17_833 VPWR VGND sg13g2_fill_1
X_17571_ _17571_/Y _17571_/A _17652_/B VPWR VGND sg13g2_nor2_1
XFILLER_90_235 VPWR VGND sg13g2_decap_8
X_11995_ _12096_/C _13854_/A _14346_/B _14346_/C _15410_/A VPWR VGND sg13g2_nor4_1
XFILLER_63_449 VPWR VGND sg13g2_decap_8
XFILLER_79_1875 VPWR VGND sg13g2_decap_8
XFILLER_21_1086 VPWR VGND sg13g2_decap_8
XFILLER_44_641 VPWR VGND sg13g2_fill_1
X_13734_ _20271_/A _13734_/A VPWR VGND sg13g2_inv_1
XFILLER_75_1739 VPWR VGND sg13g2_decap_8
X_19241_ _19241_/Y _19241_/A VPWR VGND sg13g2_inv_1
XFILLER_44_696 VPWR VGND sg13g2_decap_8
XFILLER_31_324 VPWR VGND sg13g2_decap_8
X_13665_ _13666_/A _13657_/X _13660_/Y _13662_/Y _13664_/Y VPWR VGND sg13g2_a22oi_1
X_16453_ _22590_/D _15375_/Y _16472_/B _16452_/Y VPWR VGND sg13g2_o21ai_1
X_15404_ _15404_/Y _15404_/A _15404_/B _15404_/C VPWR VGND sg13g2_nor3_1
X_12616_ _12616_/Y _20013_/A _20013_/B _13520_/A VPWR VGND sg13g2_a21oi_1
X_19172_ _23144_/D _23144_/Q _19172_/A1 _19176_/B VPWR VGND sg13g2_mux2_1
X_16384_ _22556_/D _23006_/Q _22556_/Q _18657_/B VPWR VGND sg13g2_mux2_1
XFILLER_84_7 VPWR VGND sg13g2_decap_4
X_13596_ _13597_/D _13624_/A _13596_/B VPWR VGND sg13g2_nor2_1
XFILLER_12_571 VPWR VGND sg13g2_fill_2
X_15335_ _15335_/Y _16048_/S _15335_/B VPWR VGND sg13g2_nand2_1
XFILLER_8_542 VPWR VGND sg13g2_decap_8
XFILLER_61_81 VPWR VGND sg13g2_fill_2
XFILLER_16_1870 VPWR VGND sg13g2_decap_8
XFILLER_51_1761 VPWR VGND sg13g2_decap_8
XFILLER_61_92 VPWR VGND sg13g2_fill_1
XFILLER_103_1840 VPWR VGND sg13g2_decap_8
X_15266_ _15266_/Y _16787_/A _16787_/B _15266_/C VPWR VGND sg13g2_nand3_1
X_18054_ _18332_/A _18052_/X _18053_/X _18491_/A VPWR VGND sg13g2_mux2_1
XFILLER_6_21 VPWR VGND sg13g2_decap_8
XFILLER_86_1802 VPWR VGND sg13g2_fill_1
XFILLER_6_32 VPWR VGND sg13g2_fill_2
X_12478_ _12478_/X _23616_/Q _23680_/Q _12478_/S VPWR VGND sg13g2_mux2_1
XANTENNA_3 _15865_/C VPWR VGND sg13g2_antennanp
X_14217_ _14219_/A _14217_/A _22821_/Q VPWR VGND sg13g2_nand2_1
X_17005_ _17005_/Y _22710_/Q _17005_/B VPWR VGND sg13g2_xnor2_1
X_11429_ _11430_/B _23222_/Q _23254_/Q _11762_/B VPWR VGND sg13g2_mux2_1
X_15197_ _15215_/A _15197_/A _15197_/B _15197_/C _15197_/D VPWR VGND sg13g2_nand4_1
XFILLER_99_825 VPWR VGND sg13g2_decap_8
XFILLER_86_1868 VPWR VGND sg13g2_fill_2
XFILLER_67_1256 VPWR VGND sg13g2_decap_8
XFILLER_113_624 VPWR VGND sg13g2_decap_8
XFILLER_10_1480 VPWR VGND sg13g2_decap_8
XFILLER_112_112 VPWR VGND sg13g2_decap_8
XFILLER_67_1278 VPWR VGND sg13g2_decap_8
XFILLER_98_357 VPWR VGND sg13g2_decap_8
XFILLER_80_1401 VPWR VGND sg13g2_decap_8
XFILLER_3_280 VPWR VGND sg13g2_decap_8
XFILLER_80_1423 VPWR VGND sg13g2_fill_1
X_18956_ _18958_/B _18953_/Y _18956_/B VPWR VGND sg13g2_nand2b_1
X_14079_ _14081_/A _14119_/B _11581_/Y _11589_/X VPWR VGND sg13g2_a21oi_1
XFILLER_86_519 VPWR VGND sg13g2_decap_8
XFILLER_112_189 VPWR VGND sg13g2_decap_8
X_17907_ _22933_/D _17907_/A _17907_/B VPWR VGND sg13g2_nand2_1
X_18887_ _18888_/B _18886_/Y _23047_/Q _18889_/B VPWR VGND sg13g2_mux2_1
XFILLER_67_744 VPWR VGND sg13g2_fill_2
XFILLER_94_530 VPWR VGND sg13g2_decap_8
XFILLER_94_541 VPWR VGND sg13g2_fill_1
XFILLER_6_1069 VPWR VGND sg13g2_decap_4
XFILLER_67_766 VPWR VGND sg13g2_fill_1
XFILLER_82_703 VPWR VGND sg13g2_fill_1
X_17838_ _17853_/B _17838_/A _17838_/B _17932_/B VPWR VGND sg13g2_nand3_1
XFILLER_55_917 VPWR VGND sg13g2_fill_1
XFILLER_66_265 VPWR VGND sg13g2_decap_8
XFILLER_3_1946 VPWR VGND sg13g2_decap_8
XFILLER_66_276 VPWR VGND sg13g2_fill_1
XFILLER_48_991 VPWR VGND sg13g2_decap_4
XFILLER_97_1953 VPWR VGND sg13g2_fill_2
X_17769_ _17770_/B _22571_/Q _17777_/C VPWR VGND sg13g2_nand2_1
XFILLER_110_1866 VPWR VGND sg13g2_decap_8
XFILLER_82_769 VPWR VGND sg13g2_decap_8
X_19508_ _19508_/Y _19497_/X _19504_/Y _19507_/Y VPWR VGND sg13g2_a21oi_1
XFILLER_81_268 VPWR VGND sg13g2_fill_2
XFILLER_74_1205 VPWR VGND sg13g2_decap_8
X_20780_ _23441_/D _23441_/Q _21978_/A0 _20783_/S VPWR VGND sg13g2_mux2_1
XFILLER_1_1692 VPWR VGND sg13g2_decap_8
XFILLER_35_696 VPWR VGND sg13g2_decap_8
XFILLER_17_1623 VPWR VGND sg13g2_decap_4
X_22450_ _22450_/Y _22450_/A _22450_/B VPWR VGND sg13g2_nand2_1
XFILLER_37_1071 VPWR VGND sg13g2_decap_8
XFILLER_108_1773 VPWR VGND sg13g2_decap_8
XFILLER_104_1604 VPWR VGND sg13g2_decap_8
XFILLER_108_1784 VPWR VGND sg13g2_fill_2
XFILLER_31_891 VPWR VGND sg13g2_decap_8
X_21401_ _23719_/D _21962_/A1 _21416_/B _21400_/Y VPWR VGND sg13g2_o21ai_1
XFILLER_17_1689 VPWR VGND sg13g2_decap_8
X_22381_ _24178_/D _22448_/A1 _22383_/B _22380_/Y VPWR VGND sg13g2_o21ai_1
X_24120_ _24120_/Q clkload46/A _24120_/D fanout2687/X VPWR VGND sg13g2_dfrbpq_1
X_21332_ _21332_/Y _23687_/Q _21332_/B VPWR VGND sg13g2_nand2_1
XFILLER_30_1845 VPWR VGND sg13g2_fill_1
XFILLER_102_1350 VPWR VGND sg13g2_decap_8
X_24051_ _24051_/Q clkload51/A _24051_/D fanout2665/X VPWR VGND sg13g2_dfrbpq_1
X_21263_ _23653_/D _21329_/A1 _21264_/B _21262_/Y VPWR VGND sg13g2_o21ai_1
XFILLER_11_1288 VPWR VGND sg13g2_decap_4
X_23002_ _23002_/Q clkload15/A _23002_/D fanout2838/X VPWR VGND sg13g2_dfrbpq_1
X_20214_ _20214_/Y _20214_/A _20214_/B _20214_/C VPWR VGND sg13g2_nand3_1
XFILLER_104_624 VPWR VGND sg13g2_decap_8
X_21194_ _23620_/D _21327_/A1 _21197_/B _21193_/Y VPWR VGND sg13g2_o21ai_1
XFILLER_115_1700 VPWR VGND sg13g2_decap_8
XFILLER_89_368 VPWR VGND sg13g2_decap_8
X_20145_ _23238_/D _20144_/B _22427_/A1 _20144_/Y VPWR VGND sg13g2_o21ai_1
XFILLER_28_1752 VPWR VGND sg13g2_fill_1
XFILLER_63_1632 VPWR VGND sg13g2_fill_2
XFILLER_89_379 VPWR VGND sg13g2_fill_1
XFILLER_8_1846 VPWR VGND sg13g2_decap_8
XFILLER_106_77 VPWR VGND sg13g2_decap_8
XFILLER_63_1676 VPWR VGND sg13g2_fill_1
XFILLER_63_1687 VPWR VGND sg13g2_decap_8
XFILLER_44_1086 VPWR VGND sg13g2_fill_1
XFILLER_115_1777 VPWR VGND sg13g2_decap_8
XFILLER_57_243 VPWR VGND sg13g2_fill_1
XFILLER_100_863 VPWR VGND sg13g2_decap_8
X_23904_ _23904_/Q _24131_/CLK _23904_/D fanout2749/X VPWR VGND sg13g2_dfrbpq_1
XFILLER_73_703 VPWR VGND sg13g2_decap_8
XFILLER_17_107 VPWR VGND sg13g2_decap_8
XFILLER_39_980 VPWR VGND sg13g2_decap_8
XFILLER_17_118 VPWR VGND sg13g2_fill_1
X_23835_ _23835_/Q clkload58/A _23835_/D fanout2763/X VPWR VGND sg13g2_dfrbpq_1
XFILLER_2_1445 VPWR VGND sg13g2_decap_4
XFILLER_57_1403 VPWR VGND sg13g2_fill_1
XFILLER_54_961 VPWR VGND sg13g2_decap_8
XFILLER_14_803 VPWR VGND sg13g2_decap_8
XFILLER_72_268 VPWR VGND sg13g2_decap_8
X_23766_ _23766_/Q clkload58/A _23766_/D fanout2758/X VPWR VGND sg13g2_dfrbpq_1
X_11780_ _11782_/A _12002_/A _11882_/B _11781_/C VPWR VGND sg13g2_a21oi_1
XFILLER_92_1305 VPWR VGND sg13g2_decap_8
X_20978_ _23533_/D _21343_/A0 _23533_/Q _20989_/S VPWR VGND sg13g2_mux2_1
XFILLER_72_279 VPWR VGND sg13g2_fill_2
XFILLER_96_1496 VPWR VGND sg13g2_fill_2
XFILLER_14_825 VPWR VGND sg13g2_decap_8
XFILLER_57_1447 VPWR VGND sg13g2_decap_8
XFILLER_41_622 VPWR VGND sg13g2_fill_2
X_22717_ _22717_/Q clkload24/A _22717_/D fanout2888/X VPWR VGND sg13g2_dfrbpq_1
X_23697_ _23697_/Q _24113_/CLK _23697_/D fanout2684/X VPWR VGND sg13g2_dfrbpq_1
XFILLER_70_1614 VPWR VGND sg13g2_fill_1
X_22648_ _22648_/Q _22733_/CLK _22648_/D fanout2881/X VPWR VGND sg13g2_dfrbpq_1
XFILLER_9_317 VPWR VGND sg13g2_fill_2
XFILLER_51_1002 VPWR VGND sg13g2_fill_2
XFILLER_13_379 VPWR VGND sg13g2_decap_8
XFILLER_51_1024 VPWR VGND sg13g2_decap_4
X_12401_ _12401_/Y _24063_/Q _12401_/B VPWR VGND sg13g2_nand2b_1
XFILLER_40_187 VPWR VGND sg13g2_decap_4
X_13381_ _13381_/X _13510_/A _13381_/B VPWR VGND sg13g2_xor2_1
X_22579_ _22579_/Q clkload11/A _22579_/D fanout2837/X VPWR VGND sg13g2_dfrbpq_1
XFILLER_12_1019 VPWR VGND sg13g2_decap_8
X_15120_ _15120_/X _23155_/Q _16333_/A _15120_/S VPWR VGND sg13g2_mux2_1
XFILLER_5_501 VPWR VGND sg13g2_fill_1
XFILLER_5_512 VPWR VGND sg13g2_fill_2
XFILLER_110_0 VPWR VGND sg13g2_decap_8
XFILLER_5_545 VPWR VGND sg13g2_decap_4
X_15051_ _16323_/C _22536_/Q _15117_/A _18721_/A VPWR VGND sg13g2_a21o_2
X_24249_ _24249_/X _24249_/A VPWR VGND sg13g2_buf_1
X_14002_ _14002_/Y _14002_/A VPWR VGND sg13g2_inv_1
XFILLER_68_1565 VPWR VGND sg13g2_decap_8
X_12194_ _12195_/D _12318_/A _12193_/X _12488_/B1 VPWR VGND sg13g2_o21ai_1
XFILLER_64_1418 VPWR VGND sg13g2_decap_8
X_18810_ _18810_/Y _18053_/S _23036_/Q _18823_/B1 _19122_/A1 VPWR VGND sg13g2_a22oi_1
XFILLER_95_305 VPWR VGND sg13g2_fill_1
XFILLER_110_627 VPWR VGND sg13g2_decap_8
XFILLER_95_338 VPWR VGND sg13g2_fill_1
X_18741_ _18750_/C _18741_/A _18741_/B VPWR VGND sg13g2_nor2_1
XFILLER_27_1262 VPWR VGND sg13g2_fill_2
X_15953_ _15953_/Y _22479_/Q _16020_/B VPWR VGND sg13g2_nand2b_1
XFILLER_23_1104 VPWR VGND sg13g2_fill_1
XFILLER_49_766 VPWR VGND sg13g2_decap_4
XFILLER_37_917 VPWR VGND sg13g2_fill_2
X_14904_ _14905_/B _22461_/Q _14947_/B _14936_/B VPWR VGND sg13g2_a21oi_1
XFILLER_76_552 VPWR VGND sg13g2_decap_4
XFILLER_97_1205 VPWR VGND sg13g2_decap_8
X_18672_ _18678_/B _18742_/A _18672_/B _18684_/B VPWR VGND sg13g2_nand3_1
XFILLER_37_928 VPWR VGND sg13g2_decap_8
X_15884_ _15884_/Y _15884_/A _15963_/B VPWR VGND sg13g2_nor2_1
XFILLER_40_1440 VPWR VGND sg13g2_fill_1
XFILLER_110_1129 VPWR VGND sg13g2_decap_8
XFILLER_97_1238 VPWR VGND sg13g2_decap_8
XFILLER_76_596 VPWR VGND sg13g2_decap_4
X_17623_ _17623_/Y _21087_/A _17573_/A _17622_/Y VPWR VGND sg13g2_o21ai_1
X_14835_ _14835_/Y _14872_/A _14833_/Y _14834_/Y VPWR VGND sg13g2_a21oi_1
XFILLER_45_950 VPWR VGND sg13g2_fill_1
XFILLER_79_1683 VPWR VGND sg13g2_decap_8
XFILLER_16_140 VPWR VGND sg13g2_decap_8
X_17554_ _17554_/X _22965_/Q _22949_/Q _17622_/A VPWR VGND sg13g2_mux2_1
X_11978_ _12112_/A _12088_/A _12104_/B VPWR VGND sg13g2_xor2_1
XFILLER_79_1694 VPWR VGND sg13g2_fill_2
X_14766_ _14780_/A _14766_/A _14766_/B VPWR VGND sg13g2_nand2_1
XFILLER_60_920 VPWR VGND sg13g2_decap_8
XFILLER_32_622 VPWR VGND sg13g2_decap_8
X_13717_ _13861_/D _13970_/A _13717_/B _13717_/C VPWR VGND sg13g2_and3_1
X_17485_ _22859_/D _16142_/A _17503_/B _17484_/Y VPWR VGND sg13g2_o21ai_1
X_14697_ _14697_/Y _14697_/A1 _14710_/B _14696_/Y VPWR VGND sg13g2_a21oi_1
XFILLER_32_644 VPWR VGND sg13g2_decap_8
XFILLER_92_1861 VPWR VGND sg13g2_fill_2
XFILLER_18_1932 VPWR VGND sg13g2_decap_8
X_19224_ _23178_/D _14065_/C _19221_/S _19223_/Y VPWR VGND sg13g2_o21ai_1
XFILLER_60_975 VPWR VGND sg13g2_decap_8
X_16436_ _22584_/D _22584_/Q _16357_/C _16437_/S VPWR VGND sg13g2_mux2_1
XFILLER_73_1260 VPWR VGND sg13g2_decap_4
X_13648_ _13648_/Y _13648_/A _13648_/B _13648_/C _13648_/D VPWR VGND sg13g2_nor4_2
XFILLER_53_1856 VPWR VGND sg13g2_decap_4
X_19155_ _23128_/D _23128_/Q _14844_/X _19159_/S VPWR VGND sg13g2_mux2_1
X_13579_ _13579_/X _13579_/A _13579_/B VPWR VGND sg13g2_or2_1
X_16367_ _22546_/D _16367_/A _16366_/Y VPWR VGND sg13g2_nor2b_1
XFILLER_88_1908 VPWR VGND sg13g2_fill_2
X_18106_ _22948_/D _18119_/S _18485_/A _18105_/Y VPWR VGND sg13g2_o21ai_1
XFILLER_9_895 VPWR VGND sg13g2_decap_8
XFILLER_69_1307 VPWR VGND sg13g2_fill_2
X_19086_ _23079_/D _23079_/Q _19085_/X _19086_/S VPWR VGND sg13g2_mux2_1
X_16298_ _16314_/C _16322_/A _16322_/B _16298_/C _16322_/D VPWR VGND sg13g2_nand4_1
X_15249_ _15250_/D _15246_/B _15247_/Y _15248_/X _16776_/C VPWR VGND sg13g2_a22oi_1
Xhold4807 _21713_/A _23866_/Q VPWR VGND sg13g2_dlygate4sd3_1
XFILLER_99_600 VPWR VGND sg13g2_decap_8
Xhold4818 _21266_/A _23655_/Q VPWR VGND sg13g2_dlygate4sd3_1
Xhold4829 _22424_/A _24197_/Q VPWR VGND sg13g2_dlygate4sd3_1
XFILLER_28_1004 VPWR VGND sg13g2_decap_4
XFILLER_113_421 VPWR VGND sg13g2_decap_8
XFILLER_28_1026 VPWR VGND sg13g2_fill_2
XFILLER_28_1037 VPWR VGND sg13g2_decap_4
XFILLER_87_817 VPWR VGND sg13g2_decap_8
XFILLER_28_1048 VPWR VGND sg13g2_decap_4
XFILLER_114_999 VPWR VGND sg13g2_fill_1
X_19988_ _19988_/Y _20031_/A _19988_/B _19988_/C VPWR VGND sg13g2_nand3_1
XFILLER_80_1231 VPWR VGND sg13g2_fill_1
XFILLER_113_498 VPWR VGND sg13g2_decap_8
XFILLER_98_187 VPWR VGND sg13g2_decap_8
XFILLER_45_1362 VPWR VGND sg13g2_decap_4
XFILLER_101_649 VPWR VGND sg13g2_decap_8
XFILLER_86_338 VPWR VGND sg13g2_decap_8
X_18939_ _23051_/D _18933_/Y _18936_/Y _18937_/Y _18938_/Y VPWR VGND sg13g2_a22oi_1
XFILLER_112_1917 VPWR VGND sg13g2_decap_8
XFILLER_67_552 VPWR VGND sg13g2_decap_4
X_21950_ _23969_/D _21950_/A1 _21951_/B _21949_/Y VPWR VGND sg13g2_o21ai_1
XFILLER_27_405 VPWR VGND sg13g2_fill_2
XFILLER_7_1890 VPWR VGND sg13g2_decap_8
XFILLER_23_1660 VPWR VGND sg13g2_decap_8
XFILLER_36_18 VPWR VGND sg13g2_decap_8
X_20901_ _23496_/D _21335_/A0 _23496_/Q _20918_/S VPWR VGND sg13g2_mux2_1
XFILLER_3_1743 VPWR VGND sg13g2_decap_8
XFILLER_27_427 VPWR VGND sg13g2_fill_2
X_21881_ _21881_/Y _21881_/A _21885_/B VPWR VGND sg13g2_nand2_1
X_23620_ _23620_/Q _24196_/CLK _23620_/D fanout2702/X VPWR VGND sg13g2_dfrbpq_1
XFILLER_58_1734 VPWR VGND sg13g2_decap_8
XFILLER_93_1625 VPWR VGND sg13g2_decap_8
XFILLER_82_599 VPWR VGND sg13g2_decap_8
XFILLER_110_1696 VPWR VGND sg13g2_decap_8
XFILLER_58_1756 VPWR VGND sg13g2_decap_8
XFILLER_39_1155 VPWR VGND sg13g2_decap_8
X_23551_ _23551_/Q clkload44/A _23551_/D fanout2749/X VPWR VGND sg13g2_dfrbpq_1
XFILLER_23_644 VPWR VGND sg13g2_fill_1
X_20763_ _23431_/D _21333_/A1 _20768_/B _20762_/Y VPWR VGND sg13g2_o21ai_1
XFILLER_22_121 VPWR VGND sg13g2_decap_4
XFILLER_23_655 VPWR VGND sg13g2_decap_8
X_22502_ _22502_/Q _22869_/CLK _22502_/D fanout2800/X VPWR VGND sg13g2_dfrbpq_1
X_23482_ _23482_/Q clkload53/A _23482_/D fanout2772/X VPWR VGND sg13g2_dfrbpq_1
XFILLER_11_828 VPWR VGND sg13g2_decap_8
XFILLER_91_1371 VPWR VGND sg13g2_decap_4
XFILLER_11_839 VPWR VGND sg13g2_decap_4
X_22433_ _24201_/D _24201_/Q _22433_/A1 _22449_/S VPWR VGND sg13g2_mux2_1
XFILLER_10_338 VPWR VGND sg13g2_fill_2
XFILLER_32_1918 VPWR VGND sg13g2_fill_2
XFILLER_13_1306 VPWR VGND sg13g2_decap_4
XFILLER_10_349 VPWR VGND sg13g2_decap_8
XFILLER_32_1929 VPWR VGND sg13g2_decap_8
XFILLER_13_1339 VPWR VGND sg13g2_fill_1
XFILLER_52_1388 VPWR VGND sg13g2_fill_2
XFILLER_109_749 VPWR VGND sg13g2_decap_4
XFILLER_108_226 VPWR VGND sg13g2_fill_1
XFILLER_11_1030 VPWR VGND sg13g2_fill_1
X_24103_ _24103_/Q _24170_/CLK _24103_/D fanout2708/X VPWR VGND sg13g2_dfrbpq_1
XFILLER_30_1664 VPWR VGND sg13g2_decap_8
X_22295_ _22295_/Y _24135_/Q _22295_/B VPWR VGND sg13g2_nand2_1
X_24034_ _24034_/Q _24131_/CLK _24034_/D fanout2716/X VPWR VGND sg13g2_dfrbpq_1
X_21246_ _23645_/D _21312_/A1 _21247_/B _21245_/Y VPWR VGND sg13g2_o21ai_1
XFILLER_2_526 VPWR VGND sg13g2_fill_2
XFILLER_105_944 VPWR VGND sg13g2_fill_2
XFILLER_2_537 VPWR VGND sg13g2_fill_2
XFILLER_89_132 VPWR VGND sg13g2_decap_8
XFILLER_46_1126 VPWR VGND sg13g2_decap_8
X_21177_ _21177_/Y _21177_/A _21179_/B VPWR VGND sg13g2_nand2_1
XFILLER_85_1197 VPWR VGND sg13g2_fill_2
XFILLER_63_1440 VPWR VGND sg13g2_decap_8
XFILLER_104_498 VPWR VGND sg13g2_decap_8
X_20128_ _23237_/D _20144_/B _22425_/A1 _20127_/Y VPWR VGND sg13g2_o21ai_1
XFILLER_77_338 VPWR VGND sg13g2_decap_8
XFILLER_4_1507 VPWR VGND sg13g2_decap_8
XFILLER_115_1574 VPWR VGND sg13g2_decap_8
XFILLER_86_872 VPWR VGND sg13g2_fill_1
XFILLER_19_917 VPWR VGND sg13g2_decap_8
XFILLER_58_563 VPWR VGND sg13g2_fill_2
X_12950_ _12950_/X _12951_/A _12950_/B _20087_/B VPWR VGND sg13g2_and3_1
X_20059_ _20060_/B _20058_/A _19823_/Y _20058_/Y VPWR VGND sg13g2_a21oi_1
XFILLER_19_928 VPWR VGND sg13g2_fill_1
XFILLER_98_1525 VPWR VGND sg13g2_decap_8
XFILLER_100_671 VPWR VGND sg13g2_fill_2
XFILLER_18_416 VPWR VGND sg13g2_decap_8
X_11901_ _11901_/Y _12243_/A _11901_/B VPWR VGND sg13g2_nor2_1
XFILLER_85_382 VPWR VGND sg13g2_decap_8
XFILLER_18_449 VPWR VGND sg13g2_decap_8
XFILLER_2_1231 VPWR VGND sg13g2_fill_2
X_12881_ _12881_/Y _13266_/A1 _12878_/Y _12880_/Y _14189_/A VPWR VGND sg13g2_a22oi_1
XFILLER_93_68 VPWR VGND sg13g2_decap_8
XFILLER_2_1253 VPWR VGND sg13g2_decap_4
XFILLER_27_961 VPWR VGND sg13g2_decap_4
X_11832_ _11832_/Y _11836_/B _23353_/Q _11831_/Y VPWR VGND sg13g2_o21ai_1
XFILLER_33_419 VPWR VGND sg13g2_decap_8
X_23818_ _23818_/Q clkload45/A _23818_/D fanout2733/X VPWR VGND sg13g2_dfrbpq_1
XFILLER_73_599 VPWR VGND sg13g2_decap_8
XFILLER_96_1293 VPWR VGND sg13g2_decap_4
X_14551_ _14551_/Y _18803_/A _18857_/S _14550_/Y VPWR VGND sg13g2_a21oi_1
X_11763_ _11763_/Y _11762_/B _23352_/Q _11762_/Y VPWR VGND sg13g2_o21ai_1
XFILLER_42_942 VPWR VGND sg13g2_decap_4
X_23749_ _23749_/Q clkload39/A _23749_/D fanout2738/X VPWR VGND sg13g2_dfrbpq_1
XFILLER_109_1356 VPWR VGND sg13g2_fill_2
XFILLER_13_154 VPWR VGND sg13g2_fill_1
X_14482_ _14486_/A _22596_/Q _23007_/Q VPWR VGND sg13g2_xor2_1
X_17270_ _17270_/Y _17270_/A _17270_/B VPWR VGND sg13g2_nand2_1
XFILLER_9_114 VPWR VGND sg13g2_decap_8
XFILLER_35_1542 VPWR VGND sg13g2_decap_8
X_16221_ _16241_/D _16219_/X _18613_/A _16220_/Y VPWR VGND sg13g2_o21ai_1
X_13433_ _13528_/B _13433_/A _13433_/B VPWR VGND sg13g2_xor2_1
XFILLER_9_147 VPWR VGND sg13g2_decap_8
XFILLER_35_1575 VPWR VGND sg13g2_decap_4
XFILLER_31_1428 VPWR VGND sg13g2_fill_1
X_16152_ _16152_/Y _16152_/A _16177_/B VPWR VGND sg13g2_nand2_1
XFILLER_10_861 VPWR VGND sg13g2_fill_1
X_13364_ _15785_/A _20193_/B VPWR VGND sg13g2_inv_1
X_12315_ _12316_/B _12313_/X _12314_/X _12557_/S VPWR VGND sg13g2_mux2_1
XFILLER_6_854 VPWR VGND sg13g2_decap_8
X_15103_ _15105_/A _22512_/Q _15113_/B _15103_/B1 _22940_/Q VPWR VGND sg13g2_a22oi_1
X_16083_ _16083_/Y _16080_/Y _16207_/B _16082_/Y VPWR VGND sg13g2_o21ai_1
XFILLER_115_719 VPWR VGND sg13g2_decap_8
X_13295_ _20178_/B _19423_/A _20179_/B VPWR VGND sg13g2_nand2_1
XFILLER_68_1340 VPWR VGND sg13g2_fill_2
X_19911_ _19911_/X _20098_/A0 _20349_/A2 _20222_/B VPWR VGND sg13g2_mux2_1
X_15034_ _15034_/Y _23147_/Q VPWR VGND sg13g2_inv_1
XFILLER_68_1351 VPWR VGND sg13g2_decap_8
XFILLER_108_793 VPWR VGND sg13g2_fill_1
XFILLER_100_1876 VPWR VGND sg13g2_decap_8
X_12246_ _12247_/B _23581_/Q _23613_/Q _12246_/S VPWR VGND sg13g2_mux2_1
XFILLER_5_397 VPWR VGND sg13g2_fill_2
X_19842_ _19842_/Y _20295_/A1 _19832_/Y _19841_/Y VPWR VGND sg13g2_a21oi_1
XFILLER_111_914 VPWR VGND sg13g2_fill_2
X_12177_ _12177_/X _22555_/Q _13181_/B VPWR VGND sg13g2_or2_1
XFILLER_110_402 VPWR VGND sg13g2_decap_8
XFILLER_29_1379 VPWR VGND sg13g2_fill_2
XFILLER_110_413 VPWR VGND sg13g2_fill_1
XFILLER_81_1551 VPWR VGND sg13g2_decap_8
XFILLER_7_1120 VPWR VGND sg13g2_decap_8
XFILLER_96_658 VPWR VGND sg13g2_fill_1
X_19773_ _19773_/Y _19773_/A _19777_/B _19803_/B VPWR VGND sg13g2_nor3_1
XFILLER_68_349 VPWR VGND sg13g2_decap_8
XFILLER_110_446 VPWR VGND sg13g2_decap_4
XFILLER_46_1693 VPWR VGND sg13g2_decap_8
X_16985_ _16985_/Y _17175_/A _17021_/B VPWR VGND sg13g2_nand2_1
XFILLER_95_168 VPWR VGND sg13g2_fill_2
X_18724_ _18729_/B _23023_/Q _18733_/D VPWR VGND sg13g2_nand2_1
XFILLER_49_552 VPWR VGND sg13g2_fill_1
XFILLER_77_861 VPWR VGND sg13g2_decap_8
X_15936_ _22478_/D _16189_/A _15935_/X _15936_/S VPWR VGND sg13g2_mux2_1
XFILLER_7_1197 VPWR VGND sg13g2_decap_8
X_18655_ _18655_/Y _23009_/Q _18655_/B VPWR VGND sg13g2_xnor2_1
XFILLER_37_769 VPWR VGND sg13g2_decap_4
X_17606_ _17606_/Y _22554_/Q _17606_/B VPWR VGND sg13g2_xnor2_1
XFILLER_91_363 VPWR VGND sg13g2_decap_4
X_14818_ _14818_/Y _22454_/Q _14794_/X _14816_/Y _14774_/X _14817_/X VPWR VGND sg13g2_a221oi_1
X_18586_ _18586_/X _18595_/A1 _22998_/Q _19054_/S VPWR VGND sg13g2_mux2_1
XFILLER_0_1949 VPWR VGND sg13g2_decap_4
X_15798_ _15799_/C _15798_/A _15798_/B _15798_/C _15798_/D VPWR VGND sg13g2_nand4_1
XFILLER_33_931 VPWR VGND sg13g2_fill_2
X_17537_ _17537_/Y _23156_/Q _17734_/A2 _17699_/B1 _17536_/X VPWR VGND sg13g2_a22oi_1
X_14749_ _14749_/Y _15742_/B2 _22824_/Q _14226_/A _14748_/Y VPWR VGND sg13g2_a22oi_1
XFILLER_33_953 VPWR VGND sg13g2_fill_1
XFILLER_75_1355 VPWR VGND sg13g2_decap_8
X_17468_ _22851_/D _17869_/A _17467_/B _17467_/Y VPWR VGND sg13g2_o21ai_1
XFILLER_53_1631 VPWR VGND sg13g2_decap_8
X_19207_ _23164_/D _24253_/A _23164_/Q _19231_/S VPWR VGND sg13g2_mux2_1
XFILLER_109_1890 VPWR VGND sg13g2_decap_8
XFILLER_20_647 VPWR VGND sg13g2_fill_2
X_16419_ _16419_/Y _22577_/Q _18623_/A VPWR VGND sg13g2_nand2_1
Xplace3902 _18541_/A1 _18539_/B VPWR VGND sg13g2_buf_1
Xplace3913 _18274_/B _18155_/A VPWR VGND sg13g2_buf_1
X_17399_ _17437_/B _17399_/A _17399_/B VPWR VGND sg13g2_nand2_1
Xplace3924 _13608_/A1 _12039_/Y VPWR VGND sg13g2_buf_2
XFILLER_34_1063 VPWR VGND sg13g2_decap_8
XFILLER_53_1697 VPWR VGND sg13g2_decap_4
XFILLER_73_0 VPWR VGND sg13g2_decap_8
X_19138_ _23114_/D _23114_/Q _18918_/B _19141_/S VPWR VGND sg13g2_mux2_1
Xplace3935 _12640_/B _19197_/A VPWR VGND sg13g2_buf_1
XFILLER_88_1716 VPWR VGND sg13g2_decap_8
Xplace3946 _11502_/A place3946/A VPWR VGND sg13g2_buf_1
Xplace3957 _18884_/B _18592_/A VPWR VGND sg13g2_buf_1
Xplace3968 _18953_/A _18886_/A VPWR VGND sg13g2_buf_1
Xplace3979 _14134_/D _12686_/B VPWR VGND sg13g2_buf_1
XFILLER_12_1361 VPWR VGND sg13g2_decap_8
XFILLER_105_207 VPWR VGND sg13g2_fill_1
XFILLER_69_1159 VPWR VGND sg13g2_fill_2
X_21100_ _23576_/D _21301_/A1 _21099_/B _21099_/Y VPWR VGND sg13g2_o21ai_1
X_22080_ _22080_/Y _22080_/A _22084_/B VPWR VGND sg13g2_nand2_1
XFILLER_99_430 VPWR VGND sg13g2_fill_2
Xhold4637 _17462_/A _22849_/Q VPWR VGND sg13g2_dlygate4sd3_1
Xhold4648 _17333_/A _22794_/Q VPWR VGND sg13g2_dlygate4sd3_1
XFILLER_86_1484 VPWR VGND sg13g2_decap_8
Xhold4659 _17455_/A _22846_/Q VPWR VGND sg13g2_dlygate4sd3_1
XFILLER_86_1495 VPWR VGND sg13g2_fill_1
XFILLER_47_1446 VPWR VGND sg13g2_decap_8
XFILLER_102_914 VPWR VGND sg13g2_fill_2
XFILLER_82_1337 VPWR VGND sg13g2_decap_8
XFILLER_114_774 VPWR VGND sg13g2_decap_8
XFILLER_9_1941 VPWR VGND sg13g2_decap_8
XFILLER_99_496 VPWR VGND sg13g2_decap_8
XFILLER_59_338 VPWR VGND sg13g2_decap_4
XFILLER_102_969 VPWR VGND sg13g2_decap_8
XFILLER_5_1805 VPWR VGND sg13g2_decap_8
XFILLER_112_1703 VPWR VGND sg13g2_decap_4
XFILLER_41_1012 VPWR VGND sg13g2_decap_8
XFILLER_86_157 VPWR VGND sg13g2_decap_8
XFILLER_60_1646 VPWR VGND sg13g2_decap_8
XFILLER_28_714 VPWR VGND sg13g2_fill_1
X_22982_ _22982_/Q clkload29/A _22982_/D fanout2921/X VPWR VGND sg13g2_dfrbpq_1
XFILLER_28_725 VPWR VGND sg13g2_fill_2
XFILLER_95_680 VPWR VGND sg13g2_fill_1
XFILLER_27_202 VPWR VGND sg13g2_fill_1
X_21933_ _21933_/Y _21933_/A _21935_/B VPWR VGND sg13g2_nand2_1
XFILLER_41_1078 VPWR VGND sg13g2_decap_8
XFILLER_83_853 VPWR VGND sg13g2_decap_8
XFILLER_103_56 VPWR VGND sg13g2_decap_8
XFILLER_43_706 VPWR VGND sg13g2_decap_4
XFILLER_55_566 VPWR VGND sg13g2_decap_4
XFILLER_15_408 VPWR VGND sg13g2_decap_8
X_21864_ _23928_/D _21930_/A1 _21899_/S _21863_/Y VPWR VGND sg13g2_o21ai_1
XFILLER_110_1471 VPWR VGND sg13g2_decap_4
XFILLER_55_599 VPWR VGND sg13g2_decap_8
X_23603_ _23603_/Q clkload51/A _23603_/D fanout2664/X VPWR VGND sg13g2_dfrbpq_1
XFILLER_63_49 VPWR VGND sg13g2_decap_8
XFILLER_93_1444 VPWR VGND sg13g2_fill_1
X_20815_ _23456_/D _19997_/Y _20818_/B _20814_/Y VPWR VGND sg13g2_o21ai_1
XFILLER_19_1515 VPWR VGND sg13g2_decap_4
XFILLER_24_953 VPWR VGND sg13g2_decap_8
XFILLER_70_558 VPWR VGND sg13g2_decap_8
X_21795_ _23895_/D _22262_/A1 _21804_/B _21794_/Y VPWR VGND sg13g2_o21ai_1
XFILLER_70_569 VPWR VGND sg13g2_fill_2
X_23534_ _23534_/Q _24170_/CLK _23534_/D fanout2640/X VPWR VGND sg13g2_dfrbpq_1
X_20746_ _23423_/D _21317_/A1 _20751_/B _20745_/Y VPWR VGND sg13g2_o21ai_1
XFILLER_23_474 VPWR VGND sg13g2_decap_8
XFILLER_11_636 VPWR VGND sg13g2_fill_1
XFILLER_17_1250 VPWR VGND sg13g2_fill_2
X_23465_ _23465_/Q clkload47/A _23465_/D fanout2679/X VPWR VGND sg13g2_dfrbpq_1
XFILLER_17_1261 VPWR VGND sg13g2_decap_4
XFILLER_13_1103 VPWR VGND sg13g2_decap_8
X_20677_ _23391_/D _22412_/A1 _20682_/B _20676_/Y VPWR VGND sg13g2_o21ai_1
XFILLER_32_1737 VPWR VGND sg13g2_decap_8
XFILLER_109_524 VPWR VGND sg13g2_decap_8
X_22416_ _24193_/D _22416_/A1 _22417_/B _22415_/Y VPWR VGND sg13g2_o21ai_1
XFILLER_52_1185 VPWR VGND sg13g2_fill_1
XFILLER_104_1264 VPWR VGND sg13g2_decap_4
XFILLER_12_42 VPWR VGND sg13g2_decap_8
XFILLER_10_179 VPWR VGND sg13g2_decap_8
X_23396_ _23396_/Q _24196_/CLK _23396_/D fanout2700/X VPWR VGND sg13g2_dfrbpq_1
XFILLER_100_1117 VPWR VGND sg13g2_decap_8
X_22347_ _24160_/D _19997_/Y _22350_/B _22346_/Y VPWR VGND sg13g2_o21ai_1
XFILLER_87_1248 VPWR VGND sg13g2_decap_8
Xoutput4490 data_addr_o[31] _24276_/X VPWR VGND sg13g2_buf_1
XFILLER_105_752 VPWR VGND sg13g2_fill_2
XFILLER_69_1693 VPWR VGND sg13g2_decap_8
X_12031_ _12032_/A _12028_/Y _12030_/Y _12558_/A VPWR VGND sg13g2_a21oi_1
X_24017_ _24017_/Q clkload47/A _24017_/D fanout2679/X VPWR VGND sg13g2_dfrbpq_1
XFILLER_2_345 VPWR VGND sg13g2_decap_8
X_21229_ _23637_/D _21295_/A1 _21234_/B _21228_/Y VPWR VGND sg13g2_o21ai_1
XFILLER_105_774 VPWR VGND sg13g2_decap_8
XFILLER_78_614 VPWR VGND sg13g2_decap_8
XFILLER_65_1568 VPWR VGND sg13g2_fill_1
XFILLER_78_647 VPWR VGND sg13g2_fill_1
XFILLER_43_1833 VPWR VGND sg13g2_decap_8
XFILLER_24_1221 VPWR VGND sg13g2_decap_4
XFILLER_63_1270 VPWR VGND sg13g2_decap_8
XFILLER_59_872 VPWR VGND sg13g2_decap_8
XFILLER_77_168 VPWR VGND sg13g2_decap_8
XFILLER_115_1360 VPWR VGND sg13g2_decap_8
X_16770_ _16771_/B _22669_/Q _22668_/Q _22667_/Q _16770_/D VPWR VGND sg13g2_nand4_1
XFILLER_4_1315 VPWR VGND sg13g2_fill_1
XFILLER_111_1202 VPWR VGND sg13g2_fill_1
X_13982_ _13982_/X _23860_/Q _23892_/Q _23956_/Q _23988_/Q _13983_/S0 _13983_/S1 VPWR
+ VGND sg13g2_mux4_1
XFILLER_111_1213 VPWR VGND sg13g2_decap_8
XFILLER_92_116 VPWR VGND sg13g2_fill_1
XFILLER_4_1337 VPWR VGND sg13g2_decap_4
XFILLER_43_1888 VPWR VGND sg13g2_fill_2
XFILLER_115_1393 VPWR VGND sg13g2_decap_4
XFILLER_111_1224 VPWR VGND sg13g2_fill_2
XFILLER_101_991 VPWR VGND sg13g2_decap_4
XFILLER_98_1333 VPWR VGND sg13g2_fill_2
XFILLER_86_691 VPWR VGND sg13g2_fill_2
X_15721_ _16138_/A _18690_/A _15889_/S _15720_/Y VPWR VGND sg13g2_o21ai_1
XFILLER_98_1344 VPWR VGND sg13g2_fill_1
XFILLER_58_393 VPWR VGND sg13g2_fill_2
X_12933_ _12939_/A _12951_/B _20085_/A _13748_/A _13748_/B VPWR VGND sg13g2_nand4_1
XFILLER_100_490 VPWR VGND sg13g2_decap_8
XFILLER_74_853 VPWR VGND sg13g2_decap_8
X_18440_ _18440_/Y _18539_/A _18544_/A _18440_/C VPWR VGND sg13g2_nor3_1
XFILLER_18_279 VPWR VGND sg13g2_decap_8
XFILLER_2_1061 VPWR VGND sg13g2_fill_2
X_12864_ _12864_/Y _13086_/A _13526_/B _12866_/A2 VPWR VGND sg13g2_o21ai_1
XFILLER_27_780 VPWR VGND sg13g2_fill_2
XFILLER_37_1604 VPWR VGND sg13g2_decap_4
X_14603_ _14604_/A _14596_/A _14601_/B _14885_/A VPWR VGND sg13g2_o21ai_1
X_11815_ _11815_/X _24025_/Q _24057_/Q _24089_/Q _24121_/Q _12123_/A _11815_/S1 VPWR
+ VGND sg13g2_mux4_1
X_18371_ _18784_/B _19118_/A1 _23064_/Q _18462_/S VPWR VGND sg13g2_mux2_1
XFILLER_15_953 VPWR VGND sg13g2_decap_4
X_12795_ _12795_/Y _12780_/Y _12793_/X _12794_/X _12782_/X VPWR VGND sg13g2_a22oi_1
X_15583_ _15584_/D _22921_/Q _17835_/A VPWR VGND sg13g2_nand2_1
XFILLER_42_750 VPWR VGND sg13g2_decap_4
X_17322_ _22789_/D _17854_/A1 _17324_/B _17321_/Y VPWR VGND sg13g2_o21ai_1
X_11746_ _11746_/Y _23608_/Q _11752_/B VPWR VGND sg13g2_nand2b_1
XFILLER_41_260 VPWR VGND sg13g2_decap_8
XFILLER_42_794 VPWR VGND sg13g2_decap_8
XFILLER_15_1913 VPWR VGND sg13g2_decap_8
XFILLER_41_282 VPWR VGND sg13g2_fill_2
X_17253_ _22757_/D _17854_/A1 _17252_/B _17252_/Y VPWR VGND sg13g2_o21ai_1
X_11677_ _11882_/B _11672_/Y _11674_/Y _11676_/Y VPWR VGND sg13g2_a21o_2
X_14465_ _14465_/Y _18899_/A _18871_/A VPWR VGND sg13g2_nor2b_1
Xplace3209 _20190_/S _20365_/B VPWR VGND sg13g2_buf_1
XFILLER_102_1905 VPWR VGND sg13g2_decap_8
X_16204_ _16204_/Y _22512_/Q _16203_/B _16203_/Y VPWR VGND sg13g2_a21oi_1
X_13416_ _13416_/X _23596_/Q _23628_/Q _23660_/Q _23692_/Q _13039_/S _12050_/C VPWR
+ VGND sg13g2_mux4_1
X_14396_ _14396_/Y _15262_/B _15179_/A _14385_/Y _16786_/A _14395_/Y VPWR VGND sg13g2_a221oi_1
XFILLER_50_1859 VPWR VGND sg13g2_decap_8
X_17184_ _17185_/A _22739_/Q VPWR VGND sg13g2_inv_1
XFILLER_70_1296 VPWR VGND sg13g2_decap_8
XFILLER_31_1258 VPWR VGND sg13g2_fill_1
X_13347_ _13717_/B _13383_/B _13383_/C VPWR VGND sg13g2_or2_1
XFILLER_115_516 VPWR VGND sg13g2_decap_8
XFILLER_87_1771 VPWR VGND sg13g2_decap_4
X_13278_ _13278_/Y _13278_/A _13278_/B _13278_/C _13278_/D VPWR VGND sg13g2_nand4_1
X_16066_ _22487_/D _16073_/B _16064_/Y _16065_/Y VPWR VGND sg13g2_o21ai_1
XFILLER_5_183 VPWR VGND sg13g2_fill_1
XFILLER_5_194 VPWR VGND sg13g2_fill_2
XFILLER_29_1132 VPWR VGND sg13g2_decap_8
X_12229_ _12232_/C _12245_/A _12229_/B VPWR VGND sg13g2_nor2_1
X_15017_ _15019_/A _15017_/A1 _18679_/A2 _15016_/Y VPWR VGND sg13g2_a21oi_1
XFILLER_83_1646 VPWR VGND sg13g2_fill_2
XFILLER_69_614 VPWR VGND sg13g2_fill_2
XFILLER_9_1237 VPWR VGND sg13g2_decap_8
XFILLER_68_113 VPWR VGND sg13g2_decap_8
XFILLER_110_210 VPWR VGND sg13g2_decap_8
X_19825_ _19825_/Y _19824_/A _19823_/Y _19824_/Y VPWR VGND sg13g2_a21oi_1
XFILLER_111_744 VPWR VGND sg13g2_decap_8
Xfanout2860 fanout2860/X fanout2861/X VPWR VGND sg13g2_buf_1
Xfanout2871 fanout2871/X fanout2873/X VPWR VGND sg13g2_buf_1
Xclkbuf_4_15__f_clk_i clkload4/A clkbuf_3_7_0_clk_i/X VPWR VGND sg13g2_buf_8
Xfanout2882 fanout2882/X fanout2883/X VPWR VGND sg13g2_buf_1
XFILLER_110_243 VPWR VGND sg13g2_fill_1
XFILLER_81_1370 VPWR VGND sg13g2_decap_4
XFILLER_61_1944 VPWR VGND sg13g2_decap_8
XFILLER_96_477 VPWR VGND sg13g2_decap_4
XFILLER_68_168 VPWR VGND sg13g2_decap_8
Xfanout2893 fanout2893/X fanout2894/X VPWR VGND sg13g2_buf_1
X_19756_ _19756_/Y _19932_/A _19756_/B VPWR VGND sg13g2_nand2_1
XFILLER_22_1917 VPWR VGND sg13g2_decap_8
XFILLER_56_319 VPWR VGND sg13g2_decap_8
XFILLER_83_105 VPWR VGND sg13g2_fill_1
X_16968_ _22703_/D _16967_/X _17158_/A _16972_/B VPWR VGND sg13g2_mux2_1
XFILLER_49_371 VPWR VGND sg13g2_decap_8
XFILLER_65_831 VPWR VGND sg13g2_decap_8
X_18707_ _18707_/Y _16405_/A _18708_/B _18692_/B VPWR VGND sg13g2_o21ai_1
X_15919_ _15921_/C _22777_/Q _15312_/Y _15825_/B _22905_/Q VPWR VGND sg13g2_a22oi_1
XFILLER_83_149 VPWR VGND sg13g2_decap_4
X_19687_ _19687_/Y _19685_/Y _19686_/Y _20100_/C1 VPWR VGND sg13g2_a21oi_1
XFILLER_64_330 VPWR VGND sg13g2_decap_8
X_16899_ _16899_/Y _22690_/Q _16899_/B VPWR VGND sg13g2_xnor2_1
XFILLER_25_706 VPWR VGND sg13g2_decap_8
XFILLER_4_1893 VPWR VGND sg13g2_decap_8
X_18638_ _18661_/B _23006_/Q _18638_/B VPWR VGND sg13g2_nand2_1
XFILLER_111_1780 VPWR VGND sg13g2_decap_8
XFILLER_18_780 VPWR VGND sg13g2_decap_8
XFILLER_20_1685 VPWR VGND sg13g2_decap_4
XFILLER_0_1757 VPWR VGND sg13g2_decap_4
XFILLER_24_238 VPWR VGND sg13g2_decap_8
X_18569_ _18571_/C _18766_/A _18569_/B _18569_/C VPWR VGND sg13g2_nor3_1
XFILLER_94_1786 VPWR VGND sg13g2_decap_8
X_20600_ _20600_/Y _23355_/Q _20600_/B VPWR VGND sg13g2_nand2_1
XFILLER_21_912 VPWR VGND sg13g2_fill_2
X_21580_ _23805_/D _21941_/A1 _21581_/B _21579_/Y VPWR VGND sg13g2_o21ai_1
XFILLER_33_783 VPWR VGND sg13g2_decap_8
XFILLER_55_1759 VPWR VGND sg13g2_fill_2
XFILLER_33_794 VPWR VGND sg13g2_fill_2
XFILLER_71_1027 VPWR VGND sg13g2_fill_2
XFILLER_21_945 VPWR VGND sg13g2_fill_2
XFILLER_32_282 VPWR VGND sg13g2_fill_1
X_20531_ _20531_/Y _23322_/Q _20533_/B VPWR VGND sg13g2_nand2_1
XFILLER_18_1570 VPWR VGND sg13g2_fill_1
XFILLER_21_967 VPWR VGND sg13g2_fill_1
Xrebuffer5412 _18708_/A _15030_/Y VPWR VGND sg13g2_buf_1
XFILLER_14_1423 VPWR VGND sg13g2_decap_4
Xrebuffer5423 _11592_/A _11575_/Y VPWR VGND sg13g2_buf_2
Xrebuffer5434 _13921_/B _11352_/A VPWR VGND sg13g2_buf_1
Xplace3710 _20179_/A _13292_/A VPWR VGND sg13g2_buf_2
Xplace3721 _15227_/A _12034_/Y VPWR VGND sg13g2_buf_2
X_23250_ _23250_/Q _24212_/CLK _23250_/D fanout2922/X VPWR VGND sg13g2_dfrbpq_1
Xrebuffer5456 _13521_/A1 place3556/A VPWR VGND sg13g2_buf_1
Xplace3732 _19803_/B _20085_/B VPWR VGND sg13g2_buf_1
X_20462_ _20462_/Y _20462_/A _20464_/B VPWR VGND sg13g2_nand2_1
Xplace3743 _19367_/B _19460_/B VPWR VGND sg13g2_buf_1
Xrebuffer5467 _13233_/A2 _11346_/Y VPWR VGND sg13g2_buf_1
X_22201_ _22201_/Y _24090_/Q _22203_/B VPWR VGND sg13g2_nand2_1
Xplace3754 _16789_/A _15255_/B VPWR VGND sg13g2_buf_1
Xrebuffer5478 _14065_/B _13075_/B VPWR VGND sg13g2_buf_1
XFILLER_88_1535 VPWR VGND sg13g2_decap_8
Xrebuffer5489 _13951_/B _13856_/D VPWR VGND sg13g2_buf_1
Xplace3765 _12951_/A _13736_/A VPWR VGND sg13g2_buf_1
Xhold5102 _22274_/A _24125_/Q VPWR VGND sg13g2_dlygate4sd3_1
Xhold5113 _20758_/A _23429_/Q VPWR VGND sg13g2_dlygate4sd3_1
X_23181_ _23181_/Q clkload13/A _23181_/D fanout2847/X VPWR VGND sg13g2_dfrbpq_1
Xplace3776 _13434_/A _13723_/A VPWR VGND sg13g2_buf_1
Xplace3787 _19584_/S _19589_/A VPWR VGND sg13g2_buf_1
XFILLER_101_1448 VPWR VGND sg13g2_decap_4
X_20393_ _20393_/Y _20393_/A _20395_/B VPWR VGND sg13g2_nand2_1
XFILLER_31_1781 VPWR VGND sg13g2_fill_1
Xhold5124 _21592_/A _23811_/Q VPWR VGND sg13g2_dlygate4sd3_1
Xplace3798 _20117_/C _20287_/B VPWR VGND sg13g2_buf_1
Xhold5135 _20910_/A _23502_/Q VPWR VGND sg13g2_dlygate4sd3_1
XFILLER_106_538 VPWR VGND sg13g2_decap_8
X_22132_ _22132_/Y _24057_/Q _22136_/B VPWR VGND sg13g2_nand2_1
Xhold5146 _17421_/A _22830_/Q VPWR VGND sg13g2_dlygate4sd3_1
Xhold5157 _21889_/A _23940_/Q VPWR VGND sg13g2_dlygate4sd3_1
Xhold5168 _21324_/A _23683_/Q VPWR VGND sg13g2_dlygate4sd3_1
Xhold5179 _22357_/A _24165_/Q VPWR VGND sg13g2_dlygate4sd3_1
XFILLER_66_1855 VPWR VGND sg13g2_fill_2
X_22063_ _24024_/D _22264_/A1 _22065_/B _22062_/Y VPWR VGND sg13g2_o21ai_1
XFILLER_99_260 VPWR VGND sg13g2_decap_8
XFILLER_114_571 VPWR VGND sg13g2_decap_8
XFILLER_47_1254 VPWR VGND sg13g2_fill_2
XFILLER_58_27 VPWR VGND sg13g2_decap_4
XFILLER_102_722 VPWR VGND sg13g2_decap_8
XFILLER_27_1839 VPWR VGND sg13g2_decap_4
XFILLER_102_733 VPWR VGND sg13g2_fill_1
XFILLER_99_282 VPWR VGND sg13g2_decap_8
X_21014_ _23546_/D _22268_/A1 _21013_/B _21013_/Y VPWR VGND sg13g2_o21ai_1
XFILLER_59_113 VPWR VGND sg13g2_decap_8
XFILLER_5_1602 VPWR VGND sg13g2_fill_2
XFILLER_25_1552 VPWR VGND sg13g2_decap_8
XFILLER_47_308 VPWR VGND sg13g2_fill_1
XFILLER_25_1563 VPWR VGND sg13g2_fill_1
XFILLER_59_179 VPWR VGND sg13g2_fill_1
XFILLER_101_276 VPWR VGND sg13g2_decap_4
XFILLER_21_1416 VPWR VGND sg13g2_decap_8
XFILLER_28_522 VPWR VGND sg13g2_decap_4
XFILLER_68_691 VPWR VGND sg13g2_fill_1
XFILLER_112_1544 VPWR VGND sg13g2_decap_8
XFILLER_114_77 VPWR VGND sg13g2_decap_8
XFILLER_112_1555 VPWR VGND sg13g2_decap_4
X_22965_ _22965_/Q _23187_/CLK _22965_/D fanout2918/X VPWR VGND sg13g2_dfrbpq_1
XFILLER_56_853 VPWR VGND sg13g2_fill_1
XFILLER_90_609 VPWR VGND sg13g2_decap_8
XFILLER_83_672 VPWR VGND sg13g2_fill_2
XFILLER_43_514 VPWR VGND sg13g2_decap_8
X_21916_ _21916_/Y _23956_/Q _21916_/B VPWR VGND sg13g2_nand2_1
XFILLER_82_160 VPWR VGND sg13g2_decap_8
X_22896_ _22896_/Q clkload9/A _22896_/D fanout2812/X VPWR VGND sg13g2_dfrbpq_1
XFILLER_43_547 VPWR VGND sg13g2_decap_8
XFILLER_15_249 VPWR VGND sg13g2_decap_8
X_21847_ _23922_/D _22314_/A1 _21832_/S _21846_/Y VPWR VGND sg13g2_o21ai_1
XFILLER_71_878 VPWR VGND sg13g2_decap_8
X_11600_ _19489_/B _11594_/X _11597_/Y _11599_/Y VPWR VGND sg13g2_o21ai_1
Xinput4355 _14936_/A boot_addr_i[13] VPWR VGND sg13g2_buf_1
Xinput4366 _17908_/A1 boot_addr_i[24] VPWR VGND sg13g2_buf_1
X_12580_ _12580_/X _12873_/A _12580_/B VPWR VGND sg13g2_or2_1
XFILLER_73_1848 VPWR VGND sg13g2_fill_1
XFILLER_106_1304 VPWR VGND sg13g2_decap_4
XFILLER_90_47 VPWR VGND sg13g2_fill_2
Xinput4377 _19257_/B data_gnt_i VPWR VGND sg13g2_buf_1
XFILLER_24_783 VPWR VGND sg13g2_decap_8
Xinput4388 _20284_/A3 data_rdata_i[19] VPWR VGND sg13g2_buf_1
XFILLER_23_271 VPWR VGND sg13g2_fill_1
XFILLER_54_1247 VPWR VGND sg13g2_decap_4
X_11531_ _11531_/X _23829_/Q _23861_/Q _23925_/Q _23957_/Q _11923_/S0 _11768_/S1 VPWR
+ VGND sg13g2_mux4_1
XFILLER_11_433 VPWR VGND sg13g2_fill_2
Xinput4399 _20316_/A0 data_rdata_i[29] VPWR VGND sg13g2_buf_1
XFILLER_54_1269 VPWR VGND sg13g2_fill_1
X_20729_ _20729_/Y _20729_/A _20738_/B VPWR VGND sg13g2_nand2_1
X_23517_ _23517_/Q clkload55/A _23517_/D fanout2777/X VPWR VGND sg13g2_dfrbpq_1
X_14250_ _16215_/B _16233_/B _14246_/Y _14247_/Y _14249_/Y _24231_/Q VPWR VGND sg13g2_a221oi_1
XFILLER_32_1534 VPWR VGND sg13g2_decap_8
X_23448_ _23448_/Q clkload53/A _23448_/D fanout2781/X VPWR VGND sg13g2_dfrbpq_1
X_11462_ _11462_/X _24150_/Q _24182_/Q _23222_/Q _23254_/Q _11477_/A _11449_/B VPWR
+ VGND sg13g2_mux4_1
XFILLER_23_85 VPWR VGND sg13g2_decap_8
XFILLER_109_321 VPWR VGND sg13g2_decap_8
XFILLER_32_1556 VPWR VGND sg13g2_decap_8
X_13201_ _13206_/B _13210_/A _13201_/B VPWR VGND sg13g2_nor2_1
X_14181_ _17540_/A _14788_/A _14782_/C VPWR VGND sg13g2_nand2_1
XFILLER_99_56 VPWR VGND sg13g2_decap_8
X_23379_ _23379_/Q clkload50/A _23379_/D fanout2663/X VPWR VGND sg13g2_dfrbpq_1
X_11393_ _11393_/Y _11393_/A _11393_/B VPWR VGND sg13g2_nor2_2
X_13132_ _13133_/C _23432_/Q _23496_/Q _23592_/Q _23656_/Q _13631_/S1 _14146_/B VPWR
+ VGND sg13g2_mux4_1
XFILLER_84_1911 VPWR VGND sg13g2_decap_8
XFILLER_10_1865 VPWR VGND sg13g2_decap_8
XFILLER_3_0 VPWR VGND sg13g2_decap_8
XFILLER_65_1321 VPWR VGND sg13g2_decap_8
XFILLER_79_912 VPWR VGND sg13g2_decap_8
X_17940_ _17940_/Y _18016_/S _23042_/Q VPWR VGND sg13g2_nand2_1
X_13063_ _13065_/C _13434_/A _13072_/A _15714_/A VPWR VGND sg13g2_nand3_1
XFILLER_80_1808 VPWR VGND sg13g2_fill_1
X_12014_ _12017_/C _12145_/A _12014_/B VPWR VGND sg13g2_nor2_1
XFILLER_105_593 VPWR VGND sg13g2_decap_8
X_17871_ _22921_/D _17871_/A VPWR VGND sg13g2_inv_1
Xhold4990 _22402_/A _24187_/Q VPWR VGND sg13g2_dlygate4sd3_1
XFILLER_39_809 VPWR VGND sg13g2_decap_8
XFILLER_113_1308 VPWR VGND sg13g2_fill_2
X_19610_ _20334_/B _20091_/B VPWR VGND sg13g2_inv_1
XFILLER_38_308 VPWR VGND sg13g2_fill_1
X_16822_ _16822_/Y _16830_/A _16822_/B VPWR VGND sg13g2_nand2_1
XFILLER_4_1123 VPWR VGND sg13g2_fill_2
X_19541_ _19541_/Y _19541_/A VPWR VGND sg13g2_inv_1
XFILLER_93_447 VPWR VGND sg13g2_decap_4
XFILLER_19_533 VPWR VGND sg13g2_fill_1
X_16753_ _16754_/B _22665_/Q _22664_/Q _16753_/C VPWR VGND sg13g2_nand3_1
XFILLER_93_458 VPWR VGND sg13g2_decap_8
XFILLER_78_1715 VPWR VGND sg13g2_decap_4
XFILLER_19_544 VPWR VGND sg13g2_decap_4
X_13965_ _13965_/X _13961_/X _13962_/X _13963_/X _13964_/X _18444_/A1 _13141_/B VPWR
+ VGND sg13g2_mux4_1
XFILLER_24_1095 VPWR VGND sg13g2_fill_2
XFILLER_47_875 VPWR VGND sg13g2_fill_2
X_15704_ _15712_/B _15704_/A _15704_/B _15704_/C VPWR VGND sg13g2_nand3_1
XFILLER_62_812 VPWR VGND sg13g2_fill_2
XFILLER_19_588 VPWR VGND sg13g2_decap_8
XFILLER_0_56 VPWR VGND sg13g2_decap_8
X_12916_ _12916_/Y _24005_/Q _12921_/S VPWR VGND sg13g2_nand2b_1
X_19472_ _19721_/B _19489_/A _19489_/C VPWR VGND sg13g2_nand2_1
XFILLER_59_1125 VPWR VGND sg13g2_decap_8
X_16684_ _16735_/B _16684_/A1 _16681_/Y _16683_/Y VPWR VGND sg13g2_o21ai_1
XFILLER_98_1196 VPWR VGND sg13g2_decap_4
X_13896_ _13896_/Y _13896_/A _13896_/B VPWR VGND sg13g2_nand2_1
XFILLER_111_1098 VPWR VGND sg13g2_decap_8
X_18423_ _18423_/Y _18498_/B _18423_/B VPWR VGND sg13g2_nor2_1
XFILLER_34_547 VPWR VGND sg13g2_decap_8
X_15635_ _22464_/D _15718_/S _15632_/Y _15634_/Y VPWR VGND sg13g2_a21oi_1
XFILLER_64_81 VPWR VGND sg13g2_fill_1
X_12847_ _13526_/D _12847_/A _12847_/B _12847_/C VPWR VGND sg13g2_or3_1
XFILLER_34_569 VPWR VGND sg13g2_decap_4
X_18354_ _18355_/B _18269_/A _18346_/Y _18353_/Y VPWR VGND sg13g2_o21ai_1
XFILLER_91_1948 VPWR VGND sg13g2_decap_8
X_12778_ _12778_/X _12778_/A _12778_/B _12778_/C VPWR VGND sg13g2_and3_1
XFILLER_72_1347 VPWR VGND sg13g2_fill_2
XFILLER_33_1309 VPWR VGND sg13g2_fill_1
X_14517_ _14518_/D _22594_/Q _23005_/Q VPWR VGND sg13g2_xnor2_1
X_11729_ _11729_/Y _12119_/A _11728_/X _13191_/B1 VPWR VGND sg13g2_o21ai_1
X_18285_ _18286_/B _18399_/A _18282_/Y _18284_/Y VPWR VGND sg13g2_a21oi_1
XFILLER_30_764 VPWR VGND sg13g2_decap_8
X_15497_ _22458_/D _16073_/A _15496_/X _15497_/S VPWR VGND sg13g2_mux2_1
Xplace3006 _22350_/B _22374_/B VPWR VGND sg13g2_buf_1
XFILLER_50_1612 VPWR VGND sg13g2_decap_4
XFILLER_106_1860 VPWR VGND sg13g2_decap_8
Xplace3017 _22295_/B _22316_/B VPWR VGND sg13g2_buf_1
XFILLER_50_1634 VPWR VGND sg13g2_decap_4
XFILLER_50_1645 VPWR VGND sg13g2_decap_4
X_14448_ _14449_/B _14852_/A _14782_/C _14448_/C _14758_/C VPWR VGND sg13g2_nand4_1
Xplace3028 _22129_/B _22172_/B VPWR VGND sg13g2_buf_1
Xplace3039 _22075_/B _22095_/B VPWR VGND sg13g2_buf_1
XFILLER_50_1678 VPWR VGND sg13g2_decap_8
XFILLER_102_1757 VPWR VGND sg13g2_fill_2
X_17167_ _17226_/B _17171_/A _17218_/A _17173_/B _17171_/B VPWR VGND sg13g2_nor4_2
X_14379_ _15264_/B _17390_/A _15307_/A VPWR VGND sg13g2_nor2_1
XFILLER_7_993 VPWR VGND sg13g2_fill_2
X_16118_ _22496_/D _16132_/B _16116_/Y _16117_/Y VPWR VGND sg13g2_o21ai_1
X_17098_ _17098_/Y _17098_/A _17222_/C VPWR VGND sg13g2_nor2_1
XFILLER_115_357 VPWR VGND sg13g2_decap_8
XFILLER_48_1563 VPWR VGND sg13g2_decap_8
XFILLER_97_720 VPWR VGND sg13g2_decap_8
XFILLER_36_0 VPWR VGND sg13g2_decap_8
XFILLER_48_1596 VPWR VGND sg13g2_decap_8
XFILLER_111_541 VPWR VGND sg13g2_decap_8
XFILLER_85_904 VPWR VGND sg13g2_decap_4
XFILLER_83_1498 VPWR VGND sg13g2_decap_4
XFILLER_26_1850 VPWR VGND sg13g2_fill_1
XFILLER_69_477 VPWR VGND sg13g2_fill_1
Xfanout2690 fanout2690/X fanout2691/X VPWR VGND sg13g2_buf_1
X_19808_ _19808_/Y _20307_/A _19798_/X _19807_/Y VPWR VGND sg13g2_o21ai_1
XFILLER_84_403 VPWR VGND sg13g2_fill_1
XFILLER_69_488 VPWR VGND sg13g2_decap_8
XFILLER_96_285 VPWR VGND sg13g2_fill_1
XFILLER_113_1864 VPWR VGND sg13g2_decap_8
X_19739_ _19740_/C _20335_/A _20307_/B VPWR VGND sg13g2_nor2_1
XFILLER_22_1758 VPWR VGND sg13g2_decap_4
XFILLER_42_1184 VPWR VGND sg13g2_decap_8
X_22750_ _22750_/Q clkload24/A _22750_/D fanout2898/X VPWR VGND sg13g2_dfrbpq_1
XFILLER_65_672 VPWR VGND sg13g2_decap_8
XFILLER_53_823 VPWR VGND sg13g2_decap_8
XFILLER_4_1690 VPWR VGND sg13g2_decap_8
XFILLER_25_525 VPWR VGND sg13g2_decap_8
XFILLER_25_536 VPWR VGND sg13g2_fill_1
XFILLER_44_18 VPWR VGND sg13g2_decap_8
X_21701_ _23862_/D _21926_/A1 _21716_/B _21700_/Y VPWR VGND sg13g2_o21ai_1
XFILLER_20_1482 VPWR VGND sg13g2_decap_8
XFILLER_53_856 VPWR VGND sg13g2_decap_8
XFILLER_64_193 VPWR VGND sg13g2_fill_1
X_22681_ _22681_/Q clkload21/A _22681_/D fanout2866/X VPWR VGND sg13g2_dfrbpq_1
XFILLER_80_653 VPWR VGND sg13g2_fill_1
XFILLER_52_344 VPWR VGND sg13g2_decap_8
XFILLER_52_355 VPWR VGND sg13g2_fill_1
X_21632_ _23830_/D _21926_/A1 _21642_/B _21631_/Y VPWR VGND sg13g2_o21ai_1
XFILLER_12_219 VPWR VGND sg13g2_decap_8
XFILLER_52_388 VPWR VGND sg13g2_decap_8
XFILLER_55_1545 VPWR VGND sg13g2_fill_1
XFILLER_100_35 VPWR VGND sg13g2_decap_8
X_21563_ _23797_/D _21924_/A1 _21574_/B _21562_/Y VPWR VGND sg13g2_o21ai_1
Xplace4230 _17718_/B2 _13978_/S1 VPWR VGND sg13g2_buf_1
X_23302_ _23302_/Q clkload33/A _23302_/D fanout2694/X VPWR VGND sg13g2_dfrbpq_1
Xrebuffer5220 _15017_/A1 _13306_/Y VPWR VGND sg13g2_buf_2
Xplace4241 _12285_/A _22981_/Q VPWR VGND sg13g2_buf_2
Xrebuffer5231 _12220_/A_N place3840/A VPWR VGND sg13g2_buf_8
Xplace4252 _13042_/A _12050_/C VPWR VGND sg13g2_buf_4
X_20514_ _22119_/A _22972_/Q _20514_/B VPWR VGND sg13g2_nor2_1
Xplace4263 _11768_/S1 _11390_/A VPWR VGND sg13g2_buf_1
Xrebuffer5242 _11442_/A _11329_/A VPWR VGND sg13g2_buf_1
Xplace4274 _13001_/S0 _13236_/S0 VPWR VGND sg13g2_buf_2
Xrebuffer5253 _20197_/B _13282_/Y VPWR VGND sg13g2_buf_2
Xplace4285 _13166_/B _13910_/S VPWR VGND sg13g2_buf_2
Xrebuffer5264 _14697_/A1 _11302_/B VPWR VGND sg13g2_buf_1
Xplace3540 _15947_/B1 _16016_/A VPWR VGND sg13g2_buf_1
Xplace4296 _12062_/A _12166_/B VPWR VGND sg13g2_buf_2
Xplace3551 _15937_/B _15825_/B VPWR VGND sg13g2_buf_1
X_23233_ _23233_/Q _24196_/CLK _23233_/D fanout2723/X VPWR VGND sg13g2_dfrbpq_1
XFILLER_33_1887 VPWR VGND sg13g2_fill_2
Xrebuffer5275 _13072_/A _12969_/Y VPWR VGND sg13g2_buf_8
X_20445_ _20445_/Y _23285_/Q _20451_/B VPWR VGND sg13g2_nand2_1
Xplace3562 _14737_/S _14732_/S VPWR VGND sg13g2_buf_1
XFILLER_114_7 VPWR VGND sg13g2_decap_8
XFILLER_4_418 VPWR VGND sg13g2_fill_2
Xrebuffer5286 _13736_/B _13724_/A2 VPWR VGND sg13g2_buf_1
XFILLER_107_836 VPWR VGND sg13g2_decap_8
Xplace3573 _20092_/A2 _19719_/A VPWR VGND sg13g2_buf_1
XFILLER_10_1128 VPWR VGND sg13g2_fill_2
Xrebuffer5297 _14065_/C _13381_/X VPWR VGND sg13g2_buf_8
Xplace3584 _19824_/A _19987_/A VPWR VGND sg13g2_buf_1
XFILLER_10_1139 VPWR VGND sg13g2_decap_8
Xplace3595 _17929_/A2 _17918_/A2 VPWR VGND sg13g2_buf_1
XFILLER_49_1316 VPWR VGND sg13g2_fill_2
Xrebuffer4574 _24262_/A _13014_/Y VPWR VGND sg13g2_buf_1
Xrebuffer4585 _13012_/B _13010_/Y VPWR VGND sg13g2_buf_2
X_23164_ _23164_/Q clkload27/A _23164_/D fanout2860/X VPWR VGND sg13g2_dfrbpq_1
XFILLER_109_77 VPWR VGND sg13g2_decap_8
XFILLER_107_869 VPWR VGND sg13g2_decap_8
X_20376_ _20376_/Y _20376_/A _20380_/B VPWR VGND sg13g2_nand2_1
Xrebuffer4596 _11993_/B _11859_/Y VPWR VGND sg13g2_buf_8
XFILLER_69_37 VPWR VGND sg13g2_decap_8
X_22115_ _24050_/D _22314_/A1 _22117_/B _22114_/Y VPWR VGND sg13g2_o21ai_1
XFILLER_69_59 VPWR VGND sg13g2_decap_8
X_23095_ _23095_/Q clkload14/A _23095_/D fanout2842/X VPWR VGND sg13g2_dfrbpq_1
XFILLER_115_880 VPWR VGND sg13g2_decap_8
X_22046_ _24018_/D _22314_/A1 _22045_/B _22045_/Y VPWR VGND sg13g2_o21ai_1
XFILLER_88_753 VPWR VGND sg13g2_fill_2
XFILLER_62_1538 VPWR VGND sg13g2_decap_4
XFILLER_114_1617 VPWR VGND sg13g2_fill_2
XFILLER_87_241 VPWR VGND sg13g2_decap_4
XFILLER_85_25 VPWR VGND sg13g2_decap_8
XFILLER_87_285 VPWR VGND sg13g2_decap_4
XFILLER_9_1590 VPWR VGND sg13g2_fill_2
XFILLER_102_596 VPWR VGND sg13g2_decap_8
XFILLER_87_296 VPWR VGND sg13g2_fill_1
XFILLER_29_831 VPWR VGND sg13g2_decap_8
XFILLER_60_1251 VPWR VGND sg13g2_decap_8
XFILLER_112_1330 VPWR VGND sg13g2_fill_1
XFILLER_47_138 VPWR VGND sg13g2_fill_2
XFILLER_75_458 VPWR VGND sg13g2_fill_1
XFILLER_28_330 VPWR VGND sg13g2_decap_8
XFILLER_63_609 VPWR VGND sg13g2_fill_1
X_23997_ _23997_/Q clkload44/A _23997_/D fanout2745/X VPWR VGND sg13g2_dfrbpq_1
XFILLER_16_503 VPWR VGND sg13g2_fill_2
XFILLER_29_886 VPWR VGND sg13g2_decap_8
X_22948_ _22948_/Q _23187_/CLK _22948_/D fanout2916/X VPWR VGND sg13g2_dfrbpq_1
XFILLER_28_396 VPWR VGND sg13g2_decap_8
X_12701_ _24258_/A _14935_/A _14935_/B VPWR VGND sg13g2_and2_1
XFILLER_43_344 VPWR VGND sg13g2_decap_4
X_13681_ _13681_/X _13679_/X _13680_/X _13681_/S VPWR VGND sg13g2_mux2_1
X_22879_ _22879_/Q _22917_/CLK _22879_/D fanout2895/X VPWR VGND sg13g2_dfrbpq_1
XFILLER_77_1770 VPWR VGND sg13g2_decap_8
XFILLER_44_889 VPWR VGND sg13g2_decap_8
XFILLER_70_141 VPWR VGND sg13g2_decap_8
XFILLER_77_1781 VPWR VGND sg13g2_fill_2
XFILLER_77_1792 VPWR VGND sg13g2_decap_8
XFILLER_19_1120 VPWR VGND sg13g2_fill_2
X_15420_ _16065_/A _23003_/Q _22553_/Q _15591_/S VPWR VGND sg13g2_mux2_1
XFILLER_73_1623 VPWR VGND sg13g2_decap_8
X_12632_ _12632_/Y _12759_/A _12829_/B _14358_/B _12632_/D VPWR VGND sg13g2_nor4_1
XFILLER_73_1634 VPWR VGND sg13g2_fill_2
XFILLER_70_196 VPWR VGND sg13g2_fill_1
XFILLER_93_1093 VPWR VGND sg13g2_fill_2
X_15351_ _15478_/D _14316_/C _19360_/B VPWR VGND sg13g2_nand2b_1
X_12563_ _12740_/A _12782_/A _12778_/A _13702_/A VPWR VGND sg13g2_nand3b_1
XFILLER_38_1798 VPWR VGND sg13g2_decap_8
XFILLER_8_702 VPWR VGND sg13g2_decap_8
XFILLER_54_1066 VPWR VGND sg13g2_decap_8
XFILLER_15_1028 VPWR VGND sg13g2_decap_8
XFILLER_54_1077 VPWR VGND sg13g2_fill_1
XFILLER_106_1156 VPWR VGND sg13g2_fill_2
X_14302_ _16779_/A _16789_/A _19401_/B VPWR VGND sg13g2_nand2_1
XFILLER_12_786 VPWR VGND sg13g2_decap_8
X_18070_ _18070_/Y _18554_/A1 _18501_/S _18069_/Y VPWR VGND sg13g2_o21ai_1
X_12494_ _12494_/Y _12730_/S _12493_/X _13191_/B1 VPWR VGND sg13g2_o21ai_1
X_17021_ _17021_/Y _17215_/A _17021_/B VPWR VGND sg13g2_nand2_1
XFILLER_109_140 VPWR VGND sg13g2_decap_8
X_14233_ _14837_/B _24216_/Q _24221_/Q VPWR VGND sg13g2_nor2_1
XFILLER_4_930 VPWR VGND sg13g2_decap_8
X_14164_ _14758_/B _22749_/Q _22748_/Q VPWR VGND sg13g2_nor2_1
XFILLER_113_806 VPWR VGND sg13g2_decap_8
XFILLER_98_506 VPWR VGND sg13g2_fill_1
X_13115_ _13115_/X _13115_/A _13115_/B VPWR VGND sg13g2_and2_1
XFILLER_10_1684 VPWR VGND sg13g2_fill_1
XFILLER_3_451 VPWR VGND sg13g2_fill_1
XFILLER_112_305 VPWR VGND sg13g2_decap_8
X_18972_ _23054_/D _18966_/Y _18969_/Y _18970_/Y _18971_/Y VPWR VGND sg13g2_a22oi_1
X_14095_ _14433_/B _14095_/A _14094_/Y VPWR VGND sg13g2_nor2b_1
X_17923_ _17925_/A _22939_/Q _17923_/B VPWR VGND sg13g2_nand2_1
X_13046_ _13046_/X _13044_/X _13045_/X _13244_/S VPWR VGND sg13g2_mux2_1
XFILLER_61_1004 VPWR VGND sg13g2_decap_8
XFILLER_79_764 VPWR VGND sg13g2_decap_8
XFILLER_39_617 VPWR VGND sg13g2_decap_8
X_17854_ _22917_/D _17854_/A1 _17853_/C _17853_/Y VPWR VGND sg13g2_o21ai_1
XFILLER_61_1059 VPWR VGND sg13g2_decap_8
XFILLER_93_211 VPWR VGND sg13g2_decap_8
XFILLER_43_1460 VPWR VGND sg13g2_fill_1
X_16805_ _22672_/D _16150_/A _16830_/A _16804_/Y VPWR VGND sg13g2_o21ai_1
XFILLER_94_767 VPWR VGND sg13g2_fill_1
X_17785_ _17785_/Y _22574_/Q _17799_/C VPWR VGND sg13g2_xnor2_1
XFILLER_66_469 VPWR VGND sg13g2_decap_8
XFILLER_93_255 VPWR VGND sg13g2_decap_8
XFILLER_82_929 VPWR VGND sg13g2_fill_1
XFILLER_78_1501 VPWR VGND sg13g2_fill_1
XFILLER_19_352 VPWR VGND sg13g2_decap_4
X_19524_ _19525_/B _20305_/A _16351_/Y _20201_/B VPWR VGND sg13g2_o21ai_1
X_16736_ _16737_/B _22662_/Q _16748_/C VPWR VGND sg13g2_xor2_1
X_13948_ _13949_/B _13855_/A _13855_/B _13930_/A _13930_/B _13880_/A VPWR VGND sg13g2_a221oi_1
XFILLER_74_480 VPWR VGND sg13g2_decap_8
X_19455_ _19455_/Y _19673_/B _19367_/B _19454_/Y VPWR VGND sg13g2_o21ai_1
X_16667_ _16668_/B _22648_/Q _22647_/Q _16671_/D VPWR VGND sg13g2_nand3_1
XFILLER_1_1874 VPWR VGND sg13g2_decap_8
XFILLER_50_804 VPWR VGND sg13g2_decap_8
XFILLER_91_1712 VPWR VGND sg13g2_decap_4
XFILLER_34_366 VPWR VGND sg13g2_fill_1
XFILLER_95_1881 VPWR VGND sg13g2_decap_4
X_18406_ _18406_/Y _18406_/A _18406_/B VPWR VGND sg13g2_nand2_1
XFILLER_34_377 VPWR VGND sg13g2_decap_8
XFILLER_56_1832 VPWR VGND sg13g2_fill_2
XFILLER_108_1911 VPWR VGND sg13g2_decap_8
XFILLER_95_1892 VPWR VGND sg13g2_decap_8
X_15618_ _15984_/A _17056_/A _15625_/B VPWR VGND sg13g2_nand2_1
X_19386_ _19386_/X _19584_/S _19386_/B VPWR VGND sg13g2_and2_1
XFILLER_91_1734 VPWR VGND sg13g2_decap_8
XFILLER_72_1111 VPWR VGND sg13g2_fill_2
X_16598_ _16598_/Y _16610_/A _16598_/B VPWR VGND sg13g2_nor2_1
XFILLER_61_185 VPWR VGND sg13g2_decap_8
X_18337_ _22979_/D _14129_/C _16417_/B _18336_/Y VPWR VGND sg13g2_a21oi_1
XFILLER_91_1778 VPWR VGND sg13g2_fill_2
XFILLER_33_1106 VPWR VGND sg13g2_decap_4
X_15549_ _22460_/D _15695_/S _15544_/Y _15548_/Y VPWR VGND sg13g2_a21oi_1
XFILLER_104_1808 VPWR VGND sg13g2_fill_2
XFILLER_50_1420 VPWR VGND sg13g2_decap_8
X_18268_ _18268_/Y _18302_/B _18263_/Y _18267_/Y VPWR VGND sg13g2_o21ai_1
XFILLER_30_594 VPWR VGND sg13g2_fill_1
XFILLER_102_1521 VPWR VGND sg13g2_decap_4
X_17219_ _17219_/Y _22746_/Q _17219_/B VPWR VGND sg13g2_xnor2_1
XFILLER_50_1464 VPWR VGND sg13g2_fill_1
XFILLER_89_1652 VPWR VGND sg13g2_fill_2
XFILLER_102_1554 VPWR VGND sg13g2_decap_8
X_20230_ _20230_/Y _20229_/B _20233_/A2 _20229_/Y VPWR VGND sg13g2_a21oi_1
XFILLER_85_1549 VPWR VGND sg13g2_fill_1
XFILLER_115_154 VPWR VGND sg13g2_decap_8
XFILLER_104_828 VPWR VGND sg13g2_fill_2
X_20161_ _20168_/B _20295_/A1 _20003_/Y _20007_/Y _19769_/A VPWR VGND sg13g2_a22oi_1
XFILLER_89_539 VPWR VGND sg13g2_decap_8
XFILLER_83_1240 VPWR VGND sg13g2_fill_1
XFILLER_83_1251 VPWR VGND sg13g2_fill_1
X_20092_ _20112_/B _19400_/Y _20092_/A2 _19767_/A VPWR VGND sg13g2_a21oi_1
X_23920_ _23920_/Q _24210_/CLK _23920_/D fanout2636/X VPWR VGND sg13g2_dfrbpq_1
XFILLER_58_937 VPWR VGND sg13g2_decap_8
XFILLER_69_285 VPWR VGND sg13g2_fill_1
XFILLER_84_233 VPWR VGND sg13g2_fill_2
XFILLER_6_1763 VPWR VGND sg13g2_decap_8
XFILLER_22_1533 VPWR VGND sg13g2_decap_8
X_23851_ _23851_/Q clkload49/A _23851_/D fanout2675/X VPWR VGND sg13g2_dfrbpq_1
XFILLER_61_1593 VPWR VGND sg13g2_fill_1
XFILLER_73_929 VPWR VGND sg13g2_fill_2
XFILLER_84_277 VPWR VGND sg13g2_fill_1
X_22802_ _22802_/Q clkload20/A _22802_/D fanout2864/X VPWR VGND sg13g2_dfrbpq_1
X_23782_ _23782_/Q clkload40/A _23782_/D fanout2735/X VPWR VGND sg13g2_dfrbpq_1
XFILLER_96_1667 VPWR VGND sg13g2_fill_1
XFILLER_77_1044 VPWR VGND sg13g2_decap_4
XFILLER_25_333 VPWR VGND sg13g2_fill_1
X_22733_ _22733_/Q _22733_/CLK _22733_/D fanout2881/X VPWR VGND sg13g2_dfrbpq_1
XFILLER_77_1066 VPWR VGND sg13g2_decap_8
XFILLER_0_1351 VPWR VGND sg13g2_fill_2
XFILLER_26_878 VPWR VGND sg13g2_decap_8
XFILLER_81_984 VPWR VGND sg13g2_fill_2
XFILLER_80_450 VPWR VGND sg13g2_decap_8
XFILLER_38_1028 VPWR VGND sg13g2_decap_8
XFILLER_111_56 VPWR VGND sg13g2_decap_8
XFILLER_0_1373 VPWR VGND sg13g2_decap_4
X_22664_ _22664_/Q clkload23/A _22664_/D fanout2883/X VPWR VGND sg13g2_dfrbpq_1
XFILLER_25_388 VPWR VGND sg13g2_fill_1
XFILLER_40_325 VPWR VGND sg13g2_decap_8
XFILLER_52_185 VPWR VGND sg13g2_fill_2
XFILLER_70_1807 VPWR VGND sg13g2_decap_8
X_21615_ _21615_/Y _23824_/Q _21615_/B VPWR VGND sg13g2_nand2_1
X_22595_ _22595_/Q clkload22/A _22595_/D fanout2875/X VPWR VGND sg13g2_dfrbpq_1
XFILLER_90_1266 VPWR VGND sg13g2_decap_8
X_21546_ _21546_/Y _23790_/Q _21549_/B VPWR VGND sg13g2_nand2_1
XFILLER_103_1329 VPWR VGND sg13g2_fill_1
Xplace4060 _17965_/A _17987_/B VPWR VGND sg13g2_buf_1
Xplace4071 _17992_/S _18899_/A VPWR VGND sg13g2_buf_1
X_24265_ _24265_/X _24265_/A VPWR VGND sg13g2_buf_1
Xplace4082 _20154_/S1 _23196_/Q VPWR VGND sg13g2_buf_1
Xplace4093 _19514_/A _23195_/Q VPWR VGND sg13g2_buf_1
X_21477_ _21477_/Y _21477_/A _21483_/B VPWR VGND sg13g2_nand2_1
XFILLER_107_611 VPWR VGND sg13g2_decap_8
Xplace3370 _21926_/A1 _22260_/A1 VPWR VGND sg13g2_buf_1
X_23216_ _23216_/Q clkload33/A _23216_/D fanout2930/X VPWR VGND sg13g2_dfrbpq_1
Xplace3381 _17899_/A _16154_/X VPWR VGND sg13g2_buf_1
X_20428_ _23279_/D _20280_/Y _23279_/Q _20435_/B VPWR VGND sg13g2_mux2_1
Xplace3392 _17475_/B _17462_/B VPWR VGND sg13g2_buf_1
X_24196_ _24196_/Q _24196_/CLK _24196_/D fanout2704/X VPWR VGND sg13g2_dfrbpq_1
XFILLER_106_154 VPWR VGND sg13g2_decap_8
XFILLER_84_1026 VPWR VGND sg13g2_decap_8
X_23147_ _23147_/Q clkload5/A _23147_/D fanout2840/X VPWR VGND sg13g2_dfrbpq_1
X_20359_ _20359_/Y _20112_/A _19486_/Y _20358_/Y VPWR VGND sg13g2_o21ai_1
XFILLER_96_35 VPWR VGND sg13g2_decap_8
XFILLER_0_421 VPWR VGND sg13g2_fill_1
XFILLER_66_1471 VPWR VGND sg13g2_fill_2
X_23078_ _23078_/Q _23114_/CLK _23078_/D fanout2909/X VPWR VGND sg13g2_dfrbpq_1
XFILLER_103_850 VPWR VGND sg13g2_decap_4
XFILLER_76_701 VPWR VGND sg13g2_decap_8
XFILLER_62_1357 VPWR VGND sg13g2_fill_1
XFILLER_102_382 VPWR VGND sg13g2_decap_8
XFILLER_27_1499 VPWR VGND sg13g2_decap_4
XFILLER_102_393 VPWR VGND sg13g2_fill_2
X_14851_ _14851_/Y _14861_/A _14851_/B VPWR VGND sg13g2_nor2_1
XFILLER_64_918 VPWR VGND sg13g2_decap_8
XFILLER_90_203 VPWR VGND sg13g2_fill_2
XFILLER_90_214 VPWR VGND sg13g2_fill_2
X_17570_ _17570_/Y _16879_/A _17670_/A2 _17670_/B1 _17569_/Y VPWR VGND sg13g2_a22oi_1
XFILLER_16_300 VPWR VGND sg13g2_decap_8
X_14782_ _17932_/B _14782_/A _14782_/B _14782_/C _16856_/C VPWR VGND sg13g2_or4_1
X_11994_ _11994_/Y _11981_/B _11981_/A _11992_/Y _11993_/Y _11646_/X VPWR VGND sg13g2_a221oi_1
XFILLER_16_311 VPWR VGND sg13g2_fill_2
XFILLER_112_1193 VPWR VGND sg13g2_decap_8
XFILLER_95_1144 VPWR VGND sg13g2_decap_4
X_13733_ _13733_/Y _13733_/A _13733_/B VPWR VGND sg13g2_nor2_1
XFILLER_44_675 VPWR VGND sg13g2_decap_8
XFILLER_45_83 VPWR VGND sg13g2_decap_8
X_19240_ _19240_/X _19265_/A _19240_/B VPWR VGND sg13g2_or2_1
XFILLER_32_826 VPWR VGND sg13g2_decap_8
XFILLER_45_94 VPWR VGND sg13g2_fill_2
XFILLER_95_1199 VPWR VGND sg13g2_fill_1
X_16452_ _16452_/Y _22590_/Q _16472_/B VPWR VGND sg13g2_nand2_1
XFILLER_38_1540 VPWR VGND sg13g2_fill_2
X_13664_ _13664_/Y _14104_/A _14001_/B VPWR VGND sg13g2_nor2_1
XFILLER_32_859 VPWR VGND sg13g2_decap_8
X_15403_ _15404_/C _16852_/B _15403_/B VPWR VGND sg13g2_nor2_1
XFILLER_34_1404 VPWR VGND sg13g2_fill_1
X_19171_ _23143_/D _23143_/Q _15004_/Y _19171_/S VPWR VGND sg13g2_mux2_1
X_12615_ _20013_/A _12831_/B VPWR VGND sg13g2_inv_1
X_16383_ _22555_/D _23005_/Q _22555_/Q _16388_/B VPWR VGND sg13g2_mux2_1
X_13595_ _13596_/B _13678_/A1 _13590_/Y _13592_/Y _13595_/B2 _13594_/Y VPWR VGND sg13g2_a221oi_1
XFILLER_8_510 VPWR VGND sg13g2_decap_8
X_18122_ _22954_/D _18096_/C _18120_/Y _18121_/Y VPWR VGND sg13g2_o21ai_1
XFILLER_61_71 VPWR VGND sg13g2_fill_1
X_12546_ _12639_/S _13086_/A _13526_/B _12859_/C VPWR VGND sg13g2_or3_2
XFILLER_77_7 VPWR VGND sg13g2_fill_1
X_18053_ _18053_/X _19123_/A1 _23037_/Q _18053_/S VPWR VGND sg13g2_mux2_1
XFILLER_8_565 VPWR VGND sg13g2_fill_1
X_15265_ _15266_/C _16786_/A _16786_/B _16786_/C VPWR VGND sg13g2_nand3_1
XFILLER_8_576 VPWR VGND sg13g2_fill_2
X_12477_ _12480_/C _12788_/B _12477_/B VPWR VGND sg13g2_nor2_1
XANTENNA_4 _24276_/X VPWR VGND sg13g2_antennanp
X_17004_ _17005_/B _17004_/A _17004_/B _17004_/C VPWR VGND sg13g2_nor3_1
X_14216_ _14220_/A _15742_/B2 _22824_/Q _14215_/X VPWR VGND sg13g2_a21oi_2
XFILLER_103_1896 VPWR VGND sg13g2_decap_8
X_15196_ _15197_/D _22815_/Q _17373_/A _17835_/A _22911_/Q VPWR VGND sg13g2_a22oi_1
XFILLER_113_603 VPWR VGND sg13g2_decap_8
XFILLER_6_88 VPWR VGND sg13g2_fill_1
X_11359_ _11363_/A _11357_/X _11358_/X _11926_/S VPWR VGND sg13g2_mux2_1
XFILLER_98_314 VPWR VGND sg13g2_fill_2
X_14147_ _14766_/B _22992_/Q _22993_/Q _14147_/C _14435_/A VPWR VGND sg13g2_and4_1
XFILLER_28_1219 VPWR VGND sg13g2_fill_2
X_18955_ _18955_/Y _18955_/A _18955_/B VPWR VGND sg13g2_nand2_1
X_14078_ _14078_/Y _19835_/A _14423_/B VPWR VGND sg13g2_nor2_1
XFILLER_84_1593 VPWR VGND sg13g2_decap_8
XFILLER_112_168 VPWR VGND sg13g2_decap_8
Xclkbuf_4_3__f_clk_i clkload0/A clkbuf_3_1_0_clk_i/X VPWR VGND sg13g2_buf_8
X_17906_ _17907_/B _22933_/Q _17909_/B VPWR VGND sg13g2_nand2_1
X_13029_ _14653_/C _12873_/A _13026_/X _13028_/X VPWR VGND sg13g2_o21ai_1
XFILLER_39_414 VPWR VGND sg13g2_decap_8
X_18886_ _18886_/Y _18886_/A _18886_/B _18886_/C VPWR VGND sg13g2_nand3_1
XFILLER_6_1048 VPWR VGND sg13g2_decap_8
XFILLER_39_436 VPWR VGND sg13g2_decap_8
XFILLER_3_1925 VPWR VGND sg13g2_decap_8
XFILLER_82_715 VPWR VGND sg13g2_fill_1
XFILLER_97_1932 VPWR VGND sg13g2_decap_8
XFILLER_94_586 VPWR VGND sg13g2_fill_2
XFILLER_54_417 VPWR VGND sg13g2_decap_8
XFILLER_19_160 VPWR VGND sg13g2_decap_8
X_17768_ _22901_/D _17789_/B _17766_/Y _17767_/Y VPWR VGND sg13g2_a21oi_1
XFILLER_110_1845 VPWR VGND sg13g2_decap_8
XFILLER_19_171 VPWR VGND sg13g2_fill_1
XFILLER_39_1304 VPWR VGND sg13g2_fill_2
X_16719_ _16720_/B _22659_/Q _16726_/C VPWR VGND sg13g2_xor2_1
X_19507_ _19507_/Y _23205_/Q _19501_/Y _19505_/Y _23197_/Q _19497_/X VPWR VGND sg13g2_a221oi_1
XFILLER_34_130 VPWR VGND sg13g2_decap_8
X_17699_ _17699_/Y _23171_/Q _17590_/B _17699_/B1 _17698_/Y VPWR VGND sg13g2_a22oi_1
XFILLER_39_1359 VPWR VGND sg13g2_decap_8
XFILLER_91_1520 VPWR VGND sg13g2_decap_8
XFILLER_62_483 VPWR VGND sg13g2_decap_8
XFILLER_34_185 VPWR VGND sg13g2_decap_8
XFILLER_62_494 VPWR VGND sg13g2_fill_2
XFILLER_50_645 VPWR VGND sg13g2_decap_8
XFILLER_91_1553 VPWR VGND sg13g2_fill_1
XFILLER_37_1050 VPWR VGND sg13g2_decap_4
XFILLER_52_1504 VPWR VGND sg13g2_decap_8
XFILLER_108_1752 VPWR VGND sg13g2_decap_8
XFILLER_50_667 VPWR VGND sg13g2_decap_8
X_21400_ _21400_/Y _23719_/Q _21406_/B VPWR VGND sg13g2_nand2_1
X_22380_ _22380_/Y _22380_/A _22383_/B VPWR VGND sg13g2_nand2_1
XFILLER_30_391 VPWR VGND sg13g2_decap_8
X_21331_ _23686_/D _21331_/A1 _21330_/B _21330_/Y VPWR VGND sg13g2_o21ai_1
X_24050_ _24050_/Q clkload16/A _24050_/D fanout2622/X VPWR VGND sg13g2_dfrbpq_1
X_21262_ _21262_/Y _21262_/A _21264_/B VPWR VGND sg13g2_nand2_1
X_23001_ _23001_/Q clkload17/A _23001_/D fanout2838/X VPWR VGND sg13g2_dfrbpq_1
XFILLER_104_603 VPWR VGND sg13g2_decap_8
X_20213_ _20214_/C _24267_/A _20318_/B VPWR VGND sg13g2_nand2_1
X_21193_ _21193_/Y _23620_/Q _21197_/B VPWR VGND sg13g2_nand2_1
X_20144_ _20144_/Y _20144_/A _20144_/B VPWR VGND sg13g2_nand2_1
XFILLER_77_509 VPWR VGND sg13g2_fill_1
XFILLER_8_1825 VPWR VGND sg13g2_decap_8
XFILLER_28_1764 VPWR VGND sg13g2_decap_4
XFILLER_44_1021 VPWR VGND sg13g2_decap_8
XFILLER_106_56 VPWR VGND sg13g2_decap_8
X_20075_ _20075_/Y _20266_/B2 _20069_/Y _20074_/Y VPWR VGND sg13g2_a21oi_1
XFILLER_100_820 VPWR VGND sg13g2_fill_2
XFILLER_85_520 VPWR VGND sg13g2_fill_2
XFILLER_115_1756 VPWR VGND sg13g2_decap_8
XFILLER_112_691 VPWR VGND sg13g2_decap_8
XFILLER_24_1639 VPWR VGND sg13g2_fill_2
XFILLER_58_745 VPWR VGND sg13g2_decap_8
XFILLER_100_853 VPWR VGND sg13g2_fill_1
XFILLER_85_542 VPWR VGND sg13g2_decap_8
X_23903_ _23903_/Q _24131_/CLK _23903_/D fanout2749/X VPWR VGND sg13g2_dfrbpq_1
XFILLER_79_1106 VPWR VGND sg13g2_decap_4
XFILLER_57_255 VPWR VGND sg13g2_decap_8
XFILLER_6_1582 VPWR VGND sg13g2_fill_1
X_23834_ _23834_/Q clkload58/A _23834_/D fanout2760/X VPWR VGND sg13g2_dfrbpq_1
XFILLER_96_1420 VPWR VGND sg13g2_decap_4
X_23765_ _23765_/Q clkload52/A _23765_/D fanout2757/X VPWR VGND sg13g2_dfrbpq_1
XFILLER_41_601 VPWR VGND sg13g2_decap_8
XFILLER_53_461 VPWR VGND sg13g2_fill_1
XFILLER_53_472 VPWR VGND sg13g2_fill_2
X_22716_ _22716_/Q clkload25/A _22716_/D fanout2886/X VPWR VGND sg13g2_dfrbpq_1
XFILLER_40_100 VPWR VGND sg13g2_decap_8
XFILLER_80_280 VPWR VGND sg13g2_decap_8
XFILLER_41_645 VPWR VGND sg13g2_fill_1
X_23696_ _23696_/Q clkload56/A _23696_/D fanout2676/X VPWR VGND sg13g2_dfrbpq_1
XFILLER_74_1751 VPWR VGND sg13g2_fill_1
XFILLER_9_307 VPWR VGND sg13g2_decap_4
XFILLER_55_1150 VPWR VGND sg13g2_fill_1
X_22647_ _22647_/Q _22733_/CLK _22647_/D fanout2879/X VPWR VGND sg13g2_dfrbpq_1
XFILLER_90_1052 VPWR VGND sg13g2_fill_2
XFILLER_55_1172 VPWR VGND sg13g2_decap_8
X_12400_ _12400_/Y _12401_/B _24095_/Q _12399_/Y VPWR VGND sg13g2_o21ai_1
X_13380_ _13381_/B _13101_/Y _13510_/B _13379_/X VPWR VGND sg13g2_o21ai_1
X_22578_ _22578_/Q _23029_/CLK _22578_/D fanout2850/X VPWR VGND sg13g2_dfrbpq_1
XFILLER_40_199 VPWR VGND sg13g2_fill_1
XFILLER_90_1096 VPWR VGND sg13g2_decap_8
X_12331_ _19428_/A _12533_/A _12533_/B VPWR VGND sg13g2_and2_1
X_21529_ _23780_/D _21956_/A1 _21539_/B _21528_/Y VPWR VGND sg13g2_o21ai_1
XFILLER_68_1511 VPWR VGND sg13g2_fill_2
X_15050_ _18721_/A _15050_/A _15050_/B VPWR VGND sg13g2_nor2_1
X_12262_ _12533_/A _11441_/S _12257_/X _12258_/Y VPWR VGND sg13g2_a21o_1
X_24248_ _24248_/X _24248_/A VPWR VGND sg13g2_buf_1
XFILLER_31_96 VPWR VGND sg13g2_decap_8
XFILLER_68_1533 VPWR VGND sg13g2_fill_2
XFILLER_103_0 VPWR VGND sg13g2_decap_8
X_11213_ _11596_/C _22970_/Q _22968_/Q VPWR VGND sg13g2_nand2b_1
X_14001_ _14001_/Y _14014_/S _14001_/B VPWR VGND sg13g2_nand2b_1
X_12193_ _12193_/X _23869_/Q _23965_/Q _12193_/S VPWR VGND sg13g2_mux2_1
X_24179_ _24179_/Q clkload50/A _24179_/D fanout2663/X VPWR VGND sg13g2_dfrbpq_1
XFILLER_107_485 VPWR VGND sg13g2_decap_8
XFILLER_96_818 VPWR VGND sg13g2_decap_8
XFILLER_110_606 VPWR VGND sg13g2_decap_8
XFILLER_96_829 VPWR VGND sg13g2_fill_2
XFILLER_27_1230 VPWR VGND sg13g2_decap_4
XFILLER_95_317 VPWR VGND sg13g2_decap_8
X_18740_ _18744_/A _18713_/A _18739_/Y _23026_/Q VPWR VGND sg13g2_a21oi_1
XFILLER_7_1346 VPWR VGND sg13g2_decap_8
XFILLER_48_211 VPWR VGND sg13g2_fill_2
XFILLER_23_1127 VPWR VGND sg13g2_fill_1
X_14903_ _14905_/A _22492_/Q _14912_/B _15103_/B1 _22920_/Q VPWR VGND sg13g2_a22oi_1
XFILLER_102_190 VPWR VGND sg13g2_decap_8
XFILLER_48_255 VPWR VGND sg13g2_decap_8
X_15883_ _15883_/Y _15930_/A _20265_/A VPWR VGND sg13g2_nor2_1
X_17622_ _17622_/Y _17622_/A _22956_/Q VPWR VGND sg13g2_nand2_1
XFILLER_40_1452 VPWR VGND sg13g2_fill_1
X_14834_ _14834_/Y _22914_/Q _14854_/B VPWR VGND sg13g2_nor2_1
XFILLER_91_534 VPWR VGND sg13g2_decap_8
XFILLER_40_1474 VPWR VGND sg13g2_decap_4
XFILLER_56_93 VPWR VGND sg13g2_decap_8
XFILLER_91_578 VPWR VGND sg13g2_decap_8
X_14765_ _14774_/A _14765_/A _14837_/B VPWR VGND sg13g2_nor2b_1
XFILLER_91_589 VPWR VGND sg13g2_fill_1
XFILLER_45_984 VPWR VGND sg13g2_decap_8
XFILLER_60_910 VPWR VGND sg13g2_fill_1
X_16504_ _16504_/Y _15906_/A _15905_/Y _15906_/Y VPWR VGND sg13g2_a21oi_1
XFILLER_17_697 VPWR VGND sg13g2_fill_1
X_13716_ _13717_/C _14341_/B _13904_/B VPWR VGND sg13g2_nand2_1
XFILLER_75_1548 VPWR VGND sg13g2_fill_2
XFILLER_16_174 VPWR VGND sg13g2_fill_2
X_17484_ _17484_/Y _17484_/A _17503_/B VPWR VGND sg13g2_nand2_1
XFILLER_16_185 VPWR VGND sg13g2_fill_2
X_14696_ _14696_/Y _14696_/A _14715_/B VPWR VGND sg13g2_nor2_1
XFILLER_18_1911 VPWR VGND sg13g2_decap_8
XFILLER_71_280 VPWR VGND sg13g2_decap_4
XFILLER_31_133 VPWR VGND sg13g2_decap_8
X_19223_ _19223_/Y _19223_/A _19231_/S VPWR VGND sg13g2_nand2_1
X_16435_ _16437_/S _16435_/A _17034_/D VPWR VGND sg13g2_nor2_1
X_13647_ _13648_/D _14134_/D _13647_/B VPWR VGND sg13g2_nor2_1
XFILLER_92_1884 VPWR VGND sg13g2_decap_4
XFILLER_31_155 VPWR VGND sg13g2_fill_1
XFILLER_72_92 VPWR VGND sg13g2_decap_8
XFILLER_31_177 VPWR VGND sg13g2_decap_8
X_19154_ _23127_/D _23127_/Q _14824_/X _19171_/S VPWR VGND sg13g2_mux2_1
X_16366_ _16366_/Y _16365_/Y _14520_/B _15133_/A VPWR VGND sg13g2_o21ai_1
Xclkbuf_leaf_43_clk_i clkload49/A clkbuf_leaf_43_clk_i/A VPWR VGND sg13g2_buf_16
XFILLER_105_1947 VPWR VGND sg13g2_decap_8
X_13578_ _13579_/B _23246_/Q _23278_/Q _23374_/Q _23406_/Q _13578_/S0 _13578_/S1 VPWR
+ VGND sg13g2_mux4_1
XFILLER_31_199 VPWR VGND sg13g2_fill_2
XFILLER_34_1256 VPWR VGND sg13g2_fill_2
XFILLER_9_874 VPWR VGND sg13g2_decap_4
X_18105_ _18105_/Y _18105_/A _18119_/S VPWR VGND sg13g2_nand2_1
X_15317_ _15317_/Y _15325_/B _15348_/B VPWR VGND sg13g2_nor2b_1
X_19085_ _19085_/X _18884_/A _23111_/Q _19085_/S VPWR VGND sg13g2_mux2_1
XFILLER_51_1570 VPWR VGND sg13g2_decap_4
X_12529_ _12529_/Y _12542_/A _12529_/B VPWR VGND sg13g2_nand2b_2
X_16297_ _16322_/D _15022_/A _15022_/B _16295_/A VPWR VGND sg13g2_a21oi_1
XFILLER_51_1592 VPWR VGND sg13g2_decap_8
X_15248_ _15248_/X _16786_/C _16776_/B VPWR VGND sg13g2_and2_1
XFILLER_103_1693 VPWR VGND sg13g2_fill_1
Xhold4808 _22337_/A _24156_/Q VPWR VGND sg13g2_dlygate4sd3_1
Xhold4819 _20412_/A _23270_/Q VPWR VGND sg13g2_dlygate4sd3_1
XFILLER_67_1032 VPWR VGND sg13g2_fill_2
XFILLER_113_400 VPWR VGND sg13g2_decap_8
Xclkbuf_leaf_58_clk_i clkload35/A clkbuf_4_8__f_clk_i/X VPWR VGND sg13g2_buf_16
X_15179_ _17303_/A _15179_/A _15182_/A VPWR VGND sg13g2_and2_1
XFILLER_98_111 VPWR VGND sg13g2_fill_2
XFILLER_47_1628 VPWR VGND sg13g2_decap_4
X_19987_ _19988_/C _19987_/A _19987_/B VPWR VGND sg13g2_nand2_1
XFILLER_80_1210 VPWR VGND sg13g2_decap_8
XFILLER_45_1330 VPWR VGND sg13g2_decap_8
XFILLER_113_477 VPWR VGND sg13g2_decap_8
XFILLER_101_628 VPWR VGND sg13g2_decap_8
X_18938_ _18938_/Y _23051_/Q _19041_/A _18960_/B1 VPWR VGND sg13g2_o21ai_1
.ends
